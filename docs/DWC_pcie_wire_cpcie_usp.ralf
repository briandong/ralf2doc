system wire_pcie_controller_block {
    bytes 4;
    block PF0_TYPE0_HDR @'h0 {
        bytes 4;
        register DEVICE_ID_VENDOR_ID_REG @'h0 {
            bytes 4;
            field PCI_TYPE0_VENDOR_ID @'h0 {
                bits 16;
                access ro;
                hard_reset 'h0;
                doc {
                    Vendor ID.
The Vendor ID register identifies the manufacturer of the Function. Valid vendor identifiers are allocated by the PCI-SIG to ensure uniqueness. It is not permitted to populate this register with a value of FFFFh, which is an invalid value for Vendor ID.

Note: The access attributes of this field are as follows:
 - Wire: R (sticky) 
 - Dbi: if (DBI_RO_WR_EN == 1) then R/W(sticky) else R(sticky) 
Note: This register field is sticky.
                }
            }
            field PCI_TYPE0_DEVICE_ID @'h10 {
                bits 16;
                access ro;
                hard_reset 'h0;
                doc {
                    Device ID. The Device ID register identifies the particular Function. This identifier is allocated by the vendor.

Note: The access attributes of this field are as follows:
 - Wire: R (sticky) 
 - Dbi: if (DBI_RO_WR_EN == 1) then R/W(sticky) else R(sticky) 
Note: This register field is sticky.
                }
            }
            doc {
                Device ID and Vendor ID Register.Device ID and Vendor ID Register.
            }
        }
        register STATUS_COMMAND_REG @'h4 {
            bytes 4;
            field PCI_TYPE0_IO_EN @'h0 {
                access rw;
                volatile 1
                hard_reset 'h0;
                soft_reset 'h0;
                doc {
                    IO Space Enable.
Controls a Function's response to I/O Space accesses.
 - When this bit is set, the Function is enabled to decode the address and further process I/O Space accesses.
 - When this bit is clear, all received I/O accesses are caused to be handled as Unsupported Requests.
For a Function that does not support I/O Space accesses, the controller hardwires this bit to 0b.

Note: The access attributes of this field are as follows:
 - Wire: !has_io_bar ? RO : RW 
 - Dbi: !has_io_bar ? RO : RW 
                }
            }
            field PCI_TYPE0_MEM_SPACE_EN @'h1 {
                access rw;
                volatile 1
                hard_reset 'h0;
                soft_reset 'h0;
                doc {
                    Memory Space Enable.
Controls a Function's response to Memory Space accesses.
 - When this bit is set, the Function is enabled to decode the address and further process Memory Space accesses.
 - When this bit is clear, all received Memory Space accesses are caused to be handled as Unsupported Requests.
For a Function does not support Memory Space accesses, the controller hardwires this bit to 0b.

Note: The access attributes of this field are as follows:
 - Wire: !has_mem_bar ? RO : RW 
 - Dbi: !has_mem_bar ? RO : RW 
                }
            }
            field PCI_TYPE0_BUS_MASTER_EN @'h2 {
                access rw;
                hard_reset 'h0;
                soft_reset 'h0;
                doc {
                    Bus Master Enable.
Controls the ability of a Function to issue Memory and I/O Read/Write requests.
 - When this bit is set, the Function is allowed to issue Memory or I/O Requests.
 - When this bit is clear, the Function is not allowed to issue any Memory or I/O Requests.
Requests other than Memory or I/O Requests are not controlled by this bit.

Note: MSI/MSI-X interrupt Messages are in-band memory writes, setting the Bus Master Enable bit to 0b disables MSI/MSI-X interrupt Messages as well.

Note: The access attributes of this field are as follows:
 - Wire: R/W 
 - Dbi: R/W 
                }
            }
            field PCI_TYPE0_SPECIAL_CYCLE_OPERATION @'h3 {
                access ro;
                hard_reset 'h0;
                soft_reset 'h0;
                doc {
                    Special Cycle Enable.
This bit was originally described in the PCI Local Bus Specification. Its functionality does not apply to PCI Express. The controller hardwires this bit to 0b.
                }
            }
            field PCI_TYPE_MWI_ENABLE @'h4 {
                access ro;
                hard_reset 'h0;
                soft_reset 'h0;
                doc {
                    Memory Write and Invalidate.
This bit was originally described in the PCI Local Bus Specification and the
PCI-to-PCI Bridge architecture specification. Its functionality does not apply
to PCI Express, the controller hardwires this bit to 0b.
                }
            }
            field PCI_TYPE_VGA_PALETTE_SNOOP @'h5 {
                access ro;
                hard_reset 'h0;
                soft_reset 'h0;
                doc {
                    VGA Palette Snoop.
This bit was originally described in the PCI Local Bus Specification and the PCI-to-PCI Bridge architecture specification. Its functionality does not apply to PCI Express, the controller hardwires this bit to 0b.
                }
            }
            field PCI_TYPE0_PARITY_ERR_EN @'h6 {
                access rw;
                hard_reset 'h0;
                soft_reset 'h0;
                doc {
                    Parity Error Response.
This bit controls the logging of poisoned TLPs in the Master Data Parity Error
bit in the Status register. For more details see the "Error Registers" section of the PCI Express Base Specification.
                }
            }
            field PCI_TYPE_IDSEL_STEPPING @'h7 {
                access ro;
                hard_reset 'h0;
                soft_reset 'h0;
                doc {
                    IDSEL Stepping/Wait Cycle Control.
This bit was originally described in the PCI Local Bus Specification. Its functionality does not apply to PCI Express. The controller hardwires this bit to 0b.
                }
            }
            field PCI_TYPE0_SERREN @'h8 {
                access rw;
                hard_reset 'h0;
                soft_reset 'h0;
                doc {
                    SERR  Enable.
When set, this bit enables reporting upstream of Non-fatal and Fatal errors detected by the Function.

Note: The errors are reported if enabled either through this bit or
through the PCI Express specific bits in the Device Control register. For more
details see the "Error Registers" section of the PCI Express Base Specification.
                }
            }
            field RSVDP_9 @'h9 {
                access ro;
                hard_reset 'h0;
                soft_reset 'h0;
                doc {
                    Reserved for future use.
                }
            }
            field PCI_TYPE0_INT_EN @'ha {
                access rw;
                hard_reset 'h0;
                soft_reset 'h0;
                doc {
                    Interrupt Disable.
Controls the ability of a Function to generate INTx emulation interrupts.
 - When set, Functions are prevented from asserting INTx interrupts.
Note:
 - Any INTx emulation interrupts already asserted by the Function must be deasserted when this bit is Set. INTx interrupts use virtual wires that must, if asserted, be deasserted using the appropriate Deassert_INTx message(s) when this bit is set.
 - Only the INTx virtual wire interrupt(s) associated with the Function(s) for which this bit is set are affected.
 - For functions that generate INTx interrupts, this bit is required. For functions that do not generate INTx interrupts, this bit is optional.
                }
            }
            field PCI_TYPE_RESERV @'hb {
                bits 5;
                access ro;
                hard_reset 'h0;
                soft_reset 'h0;
                doc {
                    Reserved.

                }
            }
            field IMM_READINESS @'h10 {
                access ro;
                hard_reset 'h0;
                doc {
                    Immediate Readiness.
This optional bit, when set, indicates the Function is guaranteed to be ready to successfully complete valid configuration accesses at any time following any reset that the host is capable of issuing Configuration Requests to this Function.

When this bit is set, for accesses to this Function, software is exempt from all requirements to delay configuration accesses following any type of reset, including but
not limited to the timing requirements defined in "PCI Express Reset - Rules" section of the PCI Express Base Specification.

It is permitted that system software/firmware provide mechanisms that supersede the indication provided by this bit, however such software/firmware mechanisms are outside the scope of PCI Express Base Specification. 

Note: The access attributes of this field are as follows:
 - Wire: R (sticky) 
 - Dbi: if (DBI_RO_WR_EN == 1) then R/W else R 
Note: This register field is sticky.
                }
            }
            field RSVDP_17 @'h11 {
                bits 2;
                access ro;
                hard_reset 'h0;
                soft_reset 'h0;
                doc {
                    Reserved for future use.
                }
            }
            field INT_STATUS @'h13 {
                access ro;
                volatile 1
                hard_reset 'h0;
                soft_reset 'h0;
                doc {
                    Emulation interrupt pending.
When set, indicates that an INTx emulation interrupt is pending internally in the Function. Setting the Interrupt Disable bit has no effect on the state of this bit. For Functions that do not generate INTx interrupts, the controller hardwires this bit to 0b.
                }
            }
            field CAP_LIST @'h14 {
                access ro;
                hard_reset 'h0;
                soft_reset 'h0;
                doc {
                    Capabilities List.
Indicates the presence of an Extended Capability list item. Since all PCI Express device Functions are required to implement the PCI Express Capability structure, the controller hardwires this bit to 1b.
                }
            }
            field FAST_66MHZ_CAP @'h15 {
                access ro;
                hard_reset 'h0;
                soft_reset 'h0;
                doc {
                    66MHz Capable.
This bit was originally described in the PCI Local Bus Specification. Its functionality does not apply to PCI Express. The controller hardwires this bit to 0b.
                }
            }
            field RSVDP_22 @'h16 {
                access ro;
                hard_reset 'h0;
                soft_reset 'h0;
                doc {
                    Reserved for future use.
                }
            }
            field FAST_B2B_CAP @'h17 {
                access ro;
                hard_reset 'h0;
                soft_reset 'h0;
                doc {
                    Fast Back to Back Transaction Capable.
This bit was originally described in the PCI Local Bus Specification. Its functionality does not apply to PCI Express. The controller hardwires this bit to 0b.
                }
            }
            field MASTER_DPE @'h18 {
                access w1c;
                volatile 1
                hard_reset 'h0;
                soft_reset 'h0;
                doc {
                    Master Data Parity Error.
This bit is set by a Function if the Parity Error Response bit in the Command register is 1b and either of the following two conditions occurs:
 - Function receives a Poisoned Completion
 - Function transmits a Poisoned Request
If the Parity Error Response bit is 0b, this bit is never set.
                }
            }
            field DEV_SEL_TIMING @'h19 {
                bits 2;
                access ro;
                hard_reset 'h0;
                soft_reset 'h0;
                doc {
                    DEVSEL Timing.
This field was originally described in the PCI Local Bus Specification. Its functionality does not apply to PCI Express. The controller hardwires this field to 00b.
                }
            }
            field SIGNALED_TARGET_ABORT @'h1b {
                access w1c;
                volatile 1
                hard_reset 'h0;
                soft_reset 'h0;
                doc {
                    Signaled Target Abort.
This bit is set when a Function completes a Posted or Non-Posted Request as a Completer Abort error. The controller hardwires this bit to 0b for Functions that do not signal Completer Abort.
                }
            }
            field RCVD_TARGET_ABORT @'h1c {
                access w1c;
                volatile 1
                hard_reset 'h0;
                soft_reset 'h0;
                doc {
                    Received Target Abort.
This bit is set when a Requester receives a Completion with Completer Abort Completion Status. For Functions that do not make Non-Posted Requests on their own behalf, the controller hardwires this bit to 0b.
                }
            }
            field RCVD_MASTER_ABORT @'h1d {
                access w1c;
                volatile 1
                hard_reset 'h0;
                soft_reset 'h0;
                doc {
                    Received Master Abort.
This bit is set when a Requester receives a Completion with Unsupported Request Completion Status. For Functions that do not make Non-Posted Requests on their own behalf, the controller hardwires this bit to 0b.

                }
            }
            field SIGNALED_SYS_ERR @'h1e {
                access w1c;
                volatile 1
                hard_reset 'h0;
                soft_reset 'h0;
                doc {
                    Signaled System Error.
This bit is set when a Function sends an ERR_FATAL or ERR_NONFATAL message, and the SERR  Enable bit in the Command register is 1b. For Functions that do not send ERR_FATAL or ERR_NONFATAL messages, the controller hardwires this bit to 0b.
                }
            }
            field DETECTED_PARITY_ERR @'h1f {
                access w1c;
                volatile 1
                hard_reset 'h0;
                soft_reset 'h0;
                doc {
                    Detected Parity Error.
This bit is set by a Function whenever it receives a Poisoned TLP, regardless of the state the Parity Error Response bit in the Command register.
                }
            }
            doc {
                Status and Command Register.Status and Command Register.
            }
        }
        register CLASS_CODE_REVISION_ID @'h8 {
            bytes 4;
            field REVISION_ID @'h0 {
                bits 8;
                access ro;
                hard_reset 'h0;
                doc {
                    Revision ID.
The value in this register specifies a Function specific revision identifier. The value is chosen by the vendor. Zero is an acceptable value. The Revision ID should be viewed as a vendor defined extension to the Device ID.

Note: The access attributes of this field are as follows:
 - Wire: R (sticky) 
 - Dbi: if (DBI_RO_WR_EN == 1) then R/W(sticky) else R(sticky) 
Note: This register field is sticky.
                }
            }
            field PROGRAM_INTERFACE @'h8 {
                bits 8;
                access ro;
                hard_reset 'h0;
                doc {
                    Programming Interface.
This field identifies a specific register-level programming interface (if any) so that device independent software can interact with the Function.
Encodings for interface are provided in the PCI Code and ID Assignment Specification. All unspecified encodings are Reserved.

Note: The access attributes of this field are as follows:
 - Wire: R (sticky) 
 - Dbi: if (DBI_RO_WR_EN == 1) then R/W(sticky) else R(sticky) 
Note: This register field is sticky.
                }
            }
            field SUBCLASS_CODE @'h10 {
                bits 8;
                access ro;
                hard_reset 'h0;
                doc {
                    Sub-Class Code.
Specifies a base class sub-class, which identifies more specifically the operation of the Function.
Encodings for sub-class are provided in the PCI Code and ID Assignment Specification. All unspecified encodings are Reserved.

Note: The access attributes of this field are as follows:
 - Wire: R (sticky) 
 - Dbi: if (DBI_RO_WR_EN == 1) then R/W(sticky) else R(sticky) 
Note: This register field is sticky.
                }
            }
            field BASE_CLASS_CODE @'h18 {
                bits 8;
                access ro;
                hard_reset 'h0;
                doc {
                    Base Class Code.
A code that broadly classifies the type of operation the Function performs.
Encodings for base class, are provided in the PCI Code and ID Assignment Specification. All unspecified encodings are Reserved.

Note: The access attributes of this field are as follows:
 - Wire: R (sticky) 
 - Dbi: if (DBI_RO_WR_EN == 1) then R/W(sticky) else R(sticky) 
Note: This register field is sticky.
                }
            }
            doc {
                Class Code and Revision ID Register.Class Code and Revision ID Register.
            }
        }
        register BIST_HEADER_TYPE_LATENCY_CACHE_LINE_SIZE_REG @'hc {
            bytes 4;
            field CACHE_LINE_SIZE @'h0 {
                bits 8;
                access rw;
                hard_reset 'h0;
                soft_reset 'h0;
                doc {
                    Cache Line Size.
The Cache Line Size register is programmed by the system firmware or the operating system to system cache line size. However, legacy conventional PCI software may not always be able to program this register correctly especially in the case of Hot-Plug devices. This read-write register is implemented for legacy compatibility purposes but has no effect on any PCI Express device
behavior.
                }
            }
            field LATENCY_MASTER_TIMER @'h8 {
                bits 8;
                access ro;
                hard_reset 'h0;
                soft_reset 'h0;
                doc {
                    Latency Timer.
The Latency Timer was originally described in the PCI Local Bus Specification and the PCI-to-PCI Bridge Architecture Specification. Its functionality does not apply to PCI Express. The controller hardwires this register to 00h.
                }
            }
            field HEADER_TYPE @'h10 {
                bits 7;
                access ro;
                hard_reset 'h0;
                soft_reset 'h0;
                doc {
                    Header Layout.
This field identifies the layout of the second part of the predefined header.
The controller uses 000 0000b encoding.
                }
            }
            field MULTI_FUNC @'h17 {
                access ro;
                hard_reset 'h0;
                doc {
                    Multi-Function Device.
 - When set, indicates that the Device may contain multiple Functions, but not necessarily. Software is permitted to probe for Functions other than Function 0.
 - When clear, software must not probe for Functions other than Function 0 unless explicitly indicated by another mechanism, such as an ARI or SR-IOV Capability structure.
Except where stated otherwise, it is recommended that this bit be set if there are multiple Functions, and clear if there is only one Function.

Note: The access attributes of this field are as follows:
 - Wire: R (sticky) 
 - Dbi: if (DBI_RO_WR_EN == 1) then R/W(sticky) else R(sticky) 
Note: This register field is sticky.
                }
            }
            field BIST @'h18 {
                bits 8;
                access ro;
                hard_reset 'h0;
                soft_reset 'h0;
                doc {
                    BIST.
This register is used for control and status of BIST. For Functions that do not support BIST the controller hardwires the register to 00h. A Function whose BIST is invoked must not prevent normal operation of the PCI Express Link.
Bit descriptions:
 - [31]: BIST Capable.
When Set, this bit indicates that the Function supports BIST. When Clear, the Function does not support BIST.
 - [30]: Start BIST.
If BIST Capable is Set, Set this bit to invoke BIST. The Function resets the bit when BIST is complete. Software is permitted to fail the device if this bit is not Clear (BIST is not complete) 2 seconds after it had been Set. Writing this bit to 0b has no effect. This bit must be hardwired to 0b if BIST Capable is Clear.
 - [29:28]: Reserved.
 - [27:24]: Completion Code.
This field encodes the status of the most recent test. A value of 0000b means that the Function has passed its test. Non-zero values mean the Function failed. Function-specific failure codes can be encoded in the non-zero values. This field's value is only meaningful when BIST Capable is Set and Start BIST is Clear. This field must be hardwired to 0000b if BIST Capable is clear.
                }
            }
            doc {
                BIST, Header Type, Latency Timer, and Cache Line Size Register.BIST, Header Type, Latency Timer, and Cache Line Size Register.
            }
        }
        register BAR0_REG @'h10 {
            bytes 4;
            field BAR0_MEM_IO @'h0 {
                access ro;
                volatile 1
                hard_reset 'h0;
                soft_reset 'h0;
                doc {
                    BAR0 Memory Space Indicator.
This bit is used to determine whether the register maps into Memory or I/O Space. Base Address registers that map to Memory Space must return a 0b.
Base Address registers that map to I/O Space must return a 1b.

Note: The access attributes of this field are as follows:
 - Wire: R (sticky) 
 - Dbi: if (BAR_ENABLED == 1) then (if [DBI_RO_WR_EN == 1] then R(Sticky)/W(Sticky) else R(Sticky)) else RO(Sticky) 
Note: This register field is sticky.
                }
            }
            field BAR0_TYPE @'h1 {
                bits 2;
                access ro;
                volatile 1
                hard_reset 'h0;
                soft_reset 'h0;
                doc {
                    BAR0 Type.
 - Memory Space: Base Address registers that map into Memory Space can be 32 bits or 64 bits wide (to support mapping into a 64-bit address space).
The bit encoding is as follows:
 -- 00: Base register is 32 bits wide and can be mapped anywhere in the 32 address bit Memory Space.
 -- 01: Reserved.
 -- 10: Base register is 64 bits wide and can be mapped anywhere in the 64 address bit Memory Space.
 -- 11: Reserved.
 - IO Space: Bit 1 is reserved and must return 0b on reads. Bits[31:2] are used to map the function into IO space.
Note: The access attributes of this field are as follows:
 - Wire: R (sticky) 
 - Dbi: if (BAR_ENABLED == 1) then (if [DBI_RO_WR_EN == 1] then R(Sticky)/W(Sticky) else R(Sticky)) else RO(Sticky) 
Note: This register field is sticky.
                }
            }
            field BAR0_PREFETCH @'h3 {
                access ro;
                volatile 1
                hard_reset 'h0;
                soft_reset 'h0;
                doc {
                    BAR0 Prefetchable.
 - Memory Space: Set to one if data is pre-fetchable.
A Function is permitted to mark a range as prefetchable. If there are no side effects on reads, the function returns all bytes on reads regardless of the byte enables, and host bridges can merge processor writes into this range without causing errors. Bit must me clear otherwise.
 - IO Space: Not applicable
Note: The access attributes of this field are as follows:
 - Wire: R (sticky) 
 - Dbi: if (BAR_ENABLED == 1) then (if [DBI_RO_WR_EN == 1] then R(Sticky)/W(Sticky) else R(Sticky)) else RO(Sticky) 
Note: This register field is sticky.
                }
            }
            field BAR0_START @'h4 {
                bits 28;
                access rw;
                volatile 1
                hard_reset 'h0;
                soft_reset 'h0;
                doc {
                    BAR0 Base Address.
 - Memory Space: Base Address.
 - IO Space: bits[31:2] are used to map the function into IO space/Base.
Address. 

Note: The access attributes of this field are as follows:
 - Wire: R(Sticky)/W(Sticky) if enabled else R(Sticky) 
 - Dbi: R(Sticky)/W(Sticky) if enabled else R(Sticky) 
Note: This register field is sticky.
                }
            }
            doc {
                BAR0 Register. System software must build a consistent address map before booting the machine to an operating system. This means it has to determine how much memory is in the system, and how much address space the Functions in the system require. After determining this information, system software can map the Functions into reasonable locations and proceed with system boot. In order to do this mapping in a device-independent manner, the base registers for this mapping are placed in the predefined header portion of Configuration Space. It is strongly recommended that power-up firmware/software also support the optional Enhanced Configuration Access Mechanism (ECAM).BAR0 Register. System software must build a consistent address map before booting the machine to an operating system. This means it has to determine how much memory is in the system, and how much address space the Functions in the system require. After determining this information, system software can map the Functions into reasonable locations and proceed with system boot. In order to do this mapping in a device-independent manner, the base registers for this mapping are placed in the predefined header portion of Configuration Space. It is strongly recommended that power-up firmware/software also support the optional Enhanced Configuration Access Mechanism (ECAM).
            }
        }
        register BAR1_REG @'h14 {
            bytes 4;
            field BAR1_MEM_IO @'h0 {
                access ro;
                volatile 1
                hard_reset 'h0;
                soft_reset 'h0;
                doc {
                    BAR1 Memory Space Indicator.
This bit is used to determine whether the register maps into Memory or I/O Space. Base Address registers that map to Memory Space must return a 0b.
Base Address registers that map to I/O Space must return a 1b.

Note: The access attributes of this field are as follows:
 - Wire: R (sticky) 
 - Dbi: if (BAR_ENABLED == 1) then (if [DBI_RO_WR_EN == 1] then R(Sticky)/W(Sticky) else R(Sticky)) else RO(Sticky) 
Note: This register field is sticky.
                }
            }
            field BAR1_TYPE @'h1 {
                bits 2;
                access ro;
                volatile 1
                hard_reset 'h0;
                soft_reset 'h0;
                doc {
                    BAR1 Type.
 - Memory Space: Base Address registers that map into Memory Space can be 32 bits or 64 bits wide (to support mapping into a 64-bit address space).
The bit encoding is as follows:
 -- 00: Base register is 32 bits wide and can be mapped anywhere in the 32 address bit Memory Space.
 -- 01: Reserved.
 -- 10: Base register is 64 bits wide and can be mapped anywhere in the 64 address bit Memory Space.
 -- 11: Reserved.
 - IO Space: Bit 1 is reserved and must return 0b on reads. Bits[31:2] are used to map the function into IO space.
Note: The access attributes of this field are as follows:
 - Wire: R (sticky) 
 - Dbi: if (BAR_ENABLED == 1) then (if [DBI_RO_WR_EN == 1] then R(Sticky)/W(Sticky) else R(Sticky)) else RO(Sticky) 
Note: This register field is sticky.
                }
            }
            field BAR1_PREFETCH @'h3 {
                access ro;
                volatile 1
                hard_reset 'h0;
                soft_reset 'h0;
                doc {
                    BAR1 Prefetchable.
 - Memory Space: Set to one if data is pre-fetchable.
A Function is permitted to mark a range as prefetchable. If there are no side effects on reads, the function returns all bytes on reads regardless of the byte enables, and host bridges can merge processor writes into this range without causing errors. Bit must me clear otherwise.
 - IO Space: Not applicable
Note: The access attributes of this field are as follows:
 - Wire: R (sticky) 
 - Dbi: if (BAR_ENABLED == 1) then (if [DBI_RO_WR_EN == 1] then R(Sticky)/W(Sticky) else R(Sticky)) else RO(Sticky) 
Note: This register field is sticky.
                }
            }
            field BAR1_START @'h4 {
                bits 28;
                access rw;
                volatile 1
                hard_reset 'h0;
                soft_reset 'h0;
                doc {
                    BAR1 Base Address.
 - Memory Space: Base Address.
 - IO Space: bits[31:2] are used to map the function into IO space/Base.
Address. 

Note: The access attributes of this field are as follows:
 - Wire: R(Sticky)/W(Sticky) if enabled else R(Sticky) 
 - Dbi: R(Sticky)/W(Sticky) if enabled else R(Sticky) 
Note: This register field is sticky.
                }
            }
            doc {
                BAR1 Register. System software must build a consistent address map before booting the machine to an operating system. This means it has to determine how much memory is in the system, and how much address space the Functions in the system require. After determining this information, system software can map the Functions into reasonable locations and proceed with system boot. In order to do this mapping in a device-independent manner, the base registers for this mapping are placed in the predefined header portion of Configuration Space. It is strongly recommended that power-up firmware/software also support the optional Enhanced Configuration Access Mechanism (ECAM).BAR1 Register. System software must build a consistent address map before booting the machine to an operating system. This means it has to determine how much memory is in the system, and how much address space the Functions in the system require. After determining this information, system software can map the Functions into reasonable locations and proceed with system boot. In order to do this mapping in a device-independent manner, the base registers for this mapping are placed in the predefined header portion of Configuration Space. It is strongly recommended that power-up firmware/software also support the optional Enhanced Configuration Access Mechanism (ECAM).
            }
        }
        register BAR2_REG @'h18 {
            bytes 4;
            field BAR2_MEM_IO @'h0 {
                access ro;
                volatile 1
                hard_reset 'h0;
                soft_reset 'h0;
                doc {
                    BAR2 Memory Space Indicator.
This bit is used to determine whether the register maps into Memory or I/O Space. Base Address registers that map to Memory Space must return a 0b.
Base Address registers that map to I/O Space must return a 1b.

Note: The access attributes of this field are as follows:
 - Wire: R (sticky) 
 - Dbi: if (BAR_ENABLED == 1) then (if [DBI_RO_WR_EN == 1] then R(Sticky)/W(Sticky) else R(Sticky)) else RO(Sticky) 
Note: This register field is sticky.
                }
            }
            field BAR2_TYPE @'h1 {
                bits 2;
                access ro;
                volatile 1
                hard_reset 'h0;
                soft_reset 'h0;
                doc {
                    BAR2 Type.
 - Memory Space: Base Address registers that map into Memory Space can be 32 bits or 64 bits wide (to support mapping into a 64-bit address space).
The bit encoding is as follows:
 -- 00: Base register is 32 bits wide and can be mapped anywhere in the 32 address bit Memory Space.
 -- 01: Reserved.
 -- 10: Base register is 64 bits wide and can be mapped anywhere in the 64 address bit Memory Space.
 -- 11: Reserved.
 - IO Space: Bit 1 is reserved and must return 0b on reads. Bits[31:2] are used to map the function into IO space.
Note: The access attributes of this field are as follows:
 - Wire: R (sticky) 
 - Dbi: if (BAR_ENABLED == 1) then (if [DBI_RO_WR_EN == 1] then R(Sticky)/W(Sticky) else R(Sticky)) else RO(Sticky) 
Note: This register field is sticky.
                }
            }
            field BAR2_PREFETCH @'h3 {
                access ro;
                volatile 1
                hard_reset 'h0;
                soft_reset 'h0;
                doc {
                    BAR2 Prefetchable.
 - Memory Space: Set to one if data is pre-fetchable.
A Function is permitted to mark a range as prefetchable. If there are no side effects on reads, the function returns all bytes on reads regardless of the byte enables, and host bridges can merge processor writes into this range without causing errors. Bit must me clear otherwise.
 - IO Space: Not applicable
Note: The access attributes of this field are as follows:
 - Wire: R (sticky) 
 - Dbi: if (BAR_ENABLED == 1) then (if [DBI_RO_WR_EN == 1] then R(Sticky)/W(Sticky) else R(Sticky)) else RO(Sticky) 
Note: This register field is sticky.
                }
            }
            field BAR2_START @'h4 {
                bits 28;
                access rw;
                volatile 1
                hard_reset 'h0;
                soft_reset 'h0;
                doc {
                    BAR2 Base Address.
 - Memory Space: Base Address.
 - IO Space: bits[31:2] are used to map the function into IO space/Base.
Address. 

Note: The access attributes of this field are as follows:
 - Wire: R(Sticky)/W(Sticky) if enabled else R(Sticky) 
 - Dbi: R(Sticky)/W(Sticky) if enabled else R(Sticky) 
Note: This register field is sticky.
                }
            }
            doc {
                BAR2 Register. System software must build a consistent address map before booting the machine to an operating system. This means it has to determine how much memory is in the system, and how much address space the Functions in the system require. After determining this information, system software can map the Functions into reasonable locations and proceed with system boot. In order to do this mapping in a device-independent manner, the base registers for this mapping are placed in the predefined header portion of Configuration Space. It is strongly recommended that power-up firmware/software also support the optional Enhanced Configuration Access Mechanism (ECAM).BAR2 Register. System software must build a consistent address map before booting the machine to an operating system. This means it has to determine how much memory is in the system, and how much address space the Functions in the system require. After determining this information, system software can map the Functions into reasonable locations and proceed with system boot. In order to do this mapping in a device-independent manner, the base registers for this mapping are placed in the predefined header portion of Configuration Space. It is strongly recommended that power-up firmware/software also support the optional Enhanced Configuration Access Mechanism (ECAM).
            }
        }
        register BAR3_REG @'h1c {
            bytes 4;
            field BAR3_MEM_IO @'h0 {
                access rw;
                volatile 1
                hard_reset 'h0;
                soft_reset 'h0;
                doc {
                    BAR3 Memory Space Indicator.
This bit is used to determine whether the register maps into Memory or I/O Space. Base Address registers that map to Memory Space must return a 0b.
Base Address registers that map to I/O Space must return a 1b.

Note: The access attributes of this field are as follows:
 - Wire: R (sticky) 
 - Dbi: if (BAR_ENABLED == 1) then (if [DBI_RO_WR_EN == 1] then R(Sticky)/W(Sticky) else R(Sticky)) else RO(Sticky) 
Note: This register field is sticky.
                }
            }
            field BAR3_TYPE @'h1 {
                bits 2;
                access rw;
                volatile 1
                hard_reset 'h0;
                soft_reset 'h0;
                doc {
                    BAR3 Type.
 - Memory Space: Base Address registers that map into Memory Space can be 32 bits or 64 bits wide (to support mapping into a 64-bit address space).
The bit encoding is as follows:
 -- 00: Base register is 32 bits wide and can be mapped anywhere in the 32 address bit Memory Space.
 -- 01: Reserved.
 -- 10: Base register is 64 bits wide and can be mapped anywhere in the 64 address bit Memory Space.
 -- 11: Reserved.
 - IO Space: Bit 1 is reserved and must return 0b on reads. Bits[31:2] are used to map the function into IO space.
Note: The access attributes of this field are as follows:
 - Wire: R (sticky) 
 - Dbi: if (BAR_ENABLED == 1) then (if [DBI_RO_WR_EN == 1] then R(Sticky)/W(Sticky) else R(Sticky)) else RO(Sticky) 
Note: This register field is sticky.
                }
            }
            field BAR3_PREFETCH @'h3 {
                access rw;
                volatile 1
                hard_reset 'h0;
                soft_reset 'h0;
                doc {
                    BAR3 Prefetchable.
 - Memory Space: Set to one if data is pre-fetchable.
A Function is permitted to mark a range as prefetchable. If there are no side effects on reads, the function returns all bytes on reads regardless of the byte enables, and host bridges can merge processor writes into this range without causing errors. Bit must me clear otherwise.
 - IO Space: Not applicable
Note: The access attributes of this field are as follows:
 - Wire: R (sticky) 
 - Dbi: if (BAR_ENABLED == 1) then (if [DBI_RO_WR_EN == 1] then R(Sticky)/W(Sticky) else R(Sticky)) else RO(Sticky) 
Note: This register field is sticky.
                }
            }
            field BAR3_START @'h4 {
                bits 28;
                access rw;
                volatile 1
                hard_reset 'h0;
                soft_reset 'h0;
                doc {
                    BAR3 Base Address.
 - Memory Space: Base Address.
 - IO Space: bits[31:2] are used to map the function into IO space/Base.
Address. 

Note: The access attributes of this field are as follows:
 - Wire: R(Sticky)/W(Sticky) if enabled else R(Sticky) 
 - Dbi: R(Sticky)/W(Sticky) if enabled else R(Sticky) 
Note: This register field is sticky.
                }
            }
            doc {
                BAR3 Register. System software must build a consistent address map before booting the machine to an operating system. This means it has to determine how much memory is in the system, and how much address space the Functions in the system require. After determining this information, system software can map the Functions into reasonable locations and proceed with system boot. In order to do this mapping in a device-independent manner, the base registers for this mapping are placed in the predefined header portion of Configuration Space. It is strongly recommended that power-up firmware/software also support the optional Enhanced Configuration Access Mechanism (ECAM).BAR3 Register. System software must build a consistent address map before booting the machine to an operating system. This means it has to determine how much memory is in the system, and how much address space the Functions in the system require. After determining this information, system software can map the Functions into reasonable locations and proceed with system boot. In order to do this mapping in a device-independent manner, the base registers for this mapping are placed in the predefined header portion of Configuration Space. It is strongly recommended that power-up firmware/software also support the optional Enhanced Configuration Access Mechanism (ECAM).
            }
        }
        register BAR4_REG @'h20 {
            bytes 4;
            field BAR4_MEM_IO @'h0 {
                access ro;
                volatile 1
                hard_reset 'h0;
                soft_reset 'h0;
                doc {
                    BAR4 Memory Space Indicator.
This bit is used to determine whether the register maps into Memory or I/O Space. Base Address registers that map to Memory Space must return a 0b.
Base Address registers that map to I/O Space must return a 1b.

Note: The access attributes of this field are as follows:
 - Wire: R (sticky) 
 - Dbi: if (BAR_ENABLED == 1) then (if [DBI_RO_WR_EN == 1] then R(Sticky)/W(Sticky) else R(Sticky)) else RO(Sticky) 
Note: This register field is sticky.
                }
            }
            field BAR4_TYPE @'h1 {
                bits 2;
                access ro;
                volatile 1
                hard_reset 'h0;
                soft_reset 'h0;
                doc {
                    BAR4 Type.
 - Memory Space: Base Address registers that map into Memory Space can be 32 bits or 64 bits wide (to support mapping into a 64-bit address space).
The bit encoding is as follows:
 -- 00: Base register is 32 bits wide and can be mapped anywhere in the 32 address bit Memory Space.
 -- 01: Reserved.
 -- 10: Base register is 64 bits wide and can be mapped anywhere in the 64 address bit Memory Space.
 -- 11: Reserved.
 - IO Space: Bit 1 is reserved and must return 0b on reads. Bits[31:2] are used to map the function into IO space.
Note: The access attributes of this field are as follows:
 - Wire: R (sticky) 
 - Dbi: if (BAR_ENABLED == 1) then (if [DBI_RO_WR_EN == 1] then R(Sticky)/W(Sticky) else R(Sticky)) else RO(Sticky) 
Note: This register field is sticky.
                }
            }
            field BAR4_PREFETCH @'h3 {
                access ro;
                volatile 1
                hard_reset 'h0;
                soft_reset 'h0;
                doc {
                    BAR4 Prefetchable.
 - Memory Space: Set to one if data is pre-fetchable.
A Function is permitted to mark a range as prefetchable. If there are no side effects on reads, the function returns all bytes on reads regardless of the byte enables, and host bridges can merge processor writes into this range without causing errors. Bit must me clear otherwise.
 - IO Space: Not applicable
Note: The access attributes of this field are as follows:
 - Wire: R (sticky) 
 - Dbi: if (BAR_ENABLED == 1) then (if [DBI_RO_WR_EN == 1] then R(Sticky)/W(Sticky) else R(Sticky)) else RO(Sticky) 
Note: This register field is sticky.
                }
            }
            field BAR4_START @'h4 {
                bits 28;
                access rw;
                volatile 1
                hard_reset 'h0;
                soft_reset 'h0;
                doc {
                    BAR4 Base Address.
 - Memory Space: Base Address.
 - IO Space: bits[31:2] are used to map the function into IO space/Base.
Address. 

Note: The access attributes of this field are as follows:
 - Wire: R(Sticky)/W(Sticky) if enabled else R(Sticky) 
 - Dbi: R(Sticky)/W(Sticky) if enabled else R(Sticky) 
Note: This register field is sticky.
                }
            }
            doc {
                BAR4 Register. System software must build a consistent address map before booting the machine to an operating system. This means it has to determine how much memory is in the system, and how much address space the Functions in the system require. After determining this information, system software can map the Functions into reasonable locations and proceed with system boot. In order to do this mapping in a device-independent manner, the base registers for this mapping are placed in the predefined header portion of Configuration Space. It is strongly recommended that power-up firmware/software also support the optional Enhanced Configuration Access Mechanism (ECAM).BAR4 Register. System software must build a consistent address map before booting the machine to an operating system. This means it has to determine how much memory is in the system, and how much address space the Functions in the system require. After determining this information, system software can map the Functions into reasonable locations and proceed with system boot. In order to do this mapping in a device-independent manner, the base registers for this mapping are placed in the predefined header portion of Configuration Space. It is strongly recommended that power-up firmware/software also support the optional Enhanced Configuration Access Mechanism (ECAM).
            }
        }
        register BAR5_REG @'h24 {
            bytes 4;
            field BAR5_MEM_IO @'h0 {
                access ro;
                volatile 1
                hard_reset 'h0;
                soft_reset 'h0;
                doc {
                    BAR5 Memory Space Indicator.
This bit is used to determine whether the register maps into Memory or I/O Space. Base Address registers that map to Memory Space must return a 0b.
Base Address registers that map to I/O Space must return a 1b.

Note: The access attributes of this field are as follows:
 - Wire: R (sticky) 
 - Dbi: if (BAR_ENABLED == 1) then (if [DBI_RO_WR_EN == 1] then R(Sticky)/W(Sticky) else R(Sticky)) else RO(Sticky) 
Note: This register field is sticky.
                }
            }
            field BAR5_TYPE @'h1 {
                bits 2;
                access ro;
                volatile 1
                hard_reset 'h0;
                soft_reset 'h0;
                doc {
                    BAR5 Type.
 - Memory Space: Base Address registers that map into Memory Space can be 32 bits or 64 bits wide (to support mapping into a 64-bit address space).
The bit encoding is as follows:
 -- 00: Base register is 32 bits wide and can be mapped anywhere in the 32 address bit Memory Space.
 -- 01: Reserved.
 -- 10: Base register is 64 bits wide and can be mapped anywhere in the 64 address bit Memory Space.
 -- 11: Reserved.
 - IO Space: Bit 1 is reserved and must return 0b on reads. Bits[31:2] are used to map the function into IO space.
Note: The access attributes of this field are as follows:
 - Wire: R (sticky) 
 - Dbi: if (BAR_ENABLED == 1) then (if [DBI_RO_WR_EN == 1] then R(Sticky)/W(Sticky) else R(Sticky)) else RO(Sticky) 
Note: This register field is sticky.
                }
            }
            field BAR5_PREFETCH @'h3 {
                access ro;
                volatile 1
                hard_reset 'h0;
                soft_reset 'h0;
                doc {
                    BAR5 Prefetchable.
 - Memory Space: Set to one if data is pre-fetchable.
A Function is permitted to mark a range as prefetchable. If there are no side effects on reads, the function returns all bytes on reads regardless of the byte enables, and host bridges can merge processor writes into this range without causing errors. Bit must me clear otherwise.
 - IO Space: Not applicable
Note: The access attributes of this field are as follows:
 - Wire: R (sticky) 
 - Dbi: if (BAR_ENABLED == 1) then (if [DBI_RO_WR_EN == 1] then R(Sticky)/W(Sticky) else R(Sticky)) else RO(Sticky) 
Note: This register field is sticky.
                }
            }
            field BAR5_START @'h4 {
                bits 28;
                access rw;
                volatile 1
                hard_reset 'h0;
                soft_reset 'h0;
                doc {
                    BAR5 Base Address.
 - Memory Space: Base Address.
 - IO Space: bits[31:2] are used to map the function into IO space/Base.
Address. 

Note: The access attributes of this field are as follows:
 - Wire: R(Sticky)/W(Sticky) if enabled else R(Sticky) 
 - Dbi: R(Sticky)/W(Sticky) if enabled else R(Sticky) 
Note: This register field is sticky.
                }
            }
            doc {
                BAR5 Register. System software must build a consistent address map before booting the machine to an operating system. This means it has to determine how much memory is in the system, and how much address space the Functions in the system require. After determining this information, system software can map the Functions into reasonable locations and proceed with system boot. In order to do this mapping in a device-independent manner, the base registers for this mapping are placed in the predefined header portion of Configuration Space. It is strongly recommended that power-up firmware/software also support the optional Enhanced Configuration Access Mechanism (ECAM).BAR5 Register. System software must build a consistent address map before booting the machine to an operating system. This means it has to determine how much memory is in the system, and how much address space the Functions in the system require. After determining this information, system software can map the Functions into reasonable locations and proceed with system boot. In order to do this mapping in a device-independent manner, the base registers for this mapping are placed in the predefined header portion of Configuration Space. It is strongly recommended that power-up firmware/software also support the optional Enhanced Configuration Access Mechanism (ECAM).
            }
        }
        register CARDBUS_CIS_PTR_REG @'h28 {
            bytes 4;
            field CARDBUS_CIS_POINTER @'h0 {
                bits 32;
                access ro;
                hard_reset 'h0;
                doc {
                    CardBus CIS Pointer.
Its functionality does not apply to PCI Express. It must be hardwired to 0000 0000h.

Note: The access attributes of this field are as follows:
 - Wire: R (sticky) 
 - Dbi: if (DBI_RO_WR_EN == 1) then R/W(sticky) else R(sticky) 
Note: This register field is sticky.
                }
            }
            doc {
                CardBus CIS Pointer Register.CardBus CIS Pointer Register.
            }
        }
        register SUBSYSTEM_ID_SUBSYSTEM_VENDOR_ID_REG @'h2c {
            bytes 4;
            field SUBSYS_VENDOR_ID @'h0 {
                bits 16;
                access ro;
                hard_reset 'h0;
                doc {
                    Subsystem Vendor ID.
Subsystem Vendor IDs can be obtained from the PCI SIG and are used to identify the vendor of the add-in card or subsystem. Values for the Subsystem ID are vendor-specific.

Note: The access attributes of this field are as follows:
 - Wire: R (sticky) 
 - Dbi: if (DBI_RO_WR_EN == 1) then R/W(sticky) else R(sticky) 
Note: This register field is sticky.
                }
            }
            field SUBSYS_DEV_ID @'h10 {
                bits 16;
                access ro;
                hard_reset 'h0;
                doc {
                    Subsystem ID.


Note: The access attributes of this field are as follows:
 - Wire: R (sticky) 
 - Dbi: if (DBI_RO_WR_EN == 1) then R/W(sticky) else R(sticky) 
Note: This register field is sticky.
                }
            }
            doc {
                Subsystem ID and Subsystem Vendor ID Register.
These registers are used to uniquely identify the add-in card or subsystem where the PCI Express component resides. They provide a mechanism for vendors to distinguish their products from one another even though the assemblies may have the same PCI Express component on them (and, therefore, the same Vendor ID and Device ID).Subsystem ID and Subsystem Vendor ID Register.
These registers are used to uniquely identify the add-in card or subsystem where the PCI Express component resides. They provide a mechanism for vendors to distinguish their products from one another even though the assemblies may have the same PCI Express component on them (and, therefore, the same Vendor ID and Device ID).
            }
        }
        register EXP_ROM_BASE_ADDR_REG @'h30 {
            bytes 4;
            field ROM_BAR_ENABLE @'h0 {
                access rw;
                volatile 1
                hard_reset 'h0;
                doc {
                    Expansion ROM Enable.
This bit controls whether or not the Function accepts accesses to its expansion ROM.
 - When this bit is 0b, the Function's expansion ROM address space is disabled.
 - When the bit is 1b, address decoding is enabled using the parameters in the other part of the Expansion ROM Base Address register.
The Memory Space Enable bit in the Command register has precedence over the Expansion ROM Enable bit. A Function must claim accesses to its expansion ROM only if both the Memory Space Enable bit and the Expansion ROM Enable bit are set.

Note: The access attributes of this field are as follows:
 - Wire: if (EXP_ROM_BAR_MASK_REG.ROM_BAR_ENABLED == 1) then R/W else R 
 - Dbi: if (EXP_ROM_BAR_MASK_REG.ROM_BAR_ENABLED == 1) then R/W else R 
                }
            }
            field RSVDP_1 @'h1 {
                bits 10;
                access ro;
                hard_reset 'h0;
                soft_reset 'h0;
                doc {
                    Reserved for future use.
                }
            }
            field EXP_ROM_BASE_ADDRESS @'hb {
                bits 21;
                access rw;
                volatile 1
                hard_reset 'h0;
                soft_reset 'h0;
                doc {
                    Expansion ROM Base Address.
Upper 21 bits of the Expansion ROM base address.The number of bits (out of these 21) that a Function actually implements depends on how much address space the Function requires.

Note: The access attributes of this field are as follows:
 - Wire: if (EXP_ROM_BAR_MASK_REG.ROM_BAR_ENABLED == 1) then R/W else R 
 - Dbi: if (EXP_ROM_BAR_MASK_REG.ROM_BAR_ENABLED == 1) then R/W else R 
                }
            }
            doc {
                Expansion ROM BAR Register. This register handles the base address and size information for this expansion ROM.Expansion ROM BAR Register. This register handles the base address and size information for this expansion ROM.
            }
        }
        register PCI_CAP_PTR_REG @'h34 {
            bytes 4;
            field CAP_POINTER @'h0 {
                bits 8;
                access ro;
                hard_reset 'h0;
                doc {
                    Capabilities Pointer. This register points to a valid capability structure. Either this structure is the PCI Express Capability structure, or a subsequent list item points to the PCI Express Capability structure. The bottom two bits are reserved, the controller sets it to 00b. Software must mask these bits off before using this register as a pointer in Configuration Space to the first entry of a linked list of new capabilities.

Note: The access attributes of this field are as follows:
 - Wire: R (sticky) 
 - Dbi: if (DBI_RO_WR_EN == 1) then R/W(sticky) else R(sticky) 
Note: This register field is sticky.
                }
            }
            field RSVDP_8 @'h8 {
                bits 24;
                access ro;
                hard_reset 'h0;
                soft_reset 'h0;
                doc {
                    Reserved for future use.
                }
            }
            doc {
                Capabilities Pointer Register. This register is used to point to a linked list of capabilities implemented by a Function.Capabilities Pointer Register. This register is used to point to a linked list of capabilities implemented by a Function.
            }
        }
        register MAX_LATENCY_MIN_GRANT_INTERRUPT_PIN_INTERRUPT_LINE_REG @'h3c {
            bytes 4;
            field INT_LINE @'h0 {
                bits 8;
                access rw;
                hard_reset 'h0;
                soft_reset 'h0;
                doc {
                    Interrupt Line.
The Interrupt Line register communicates interrupt line routing information. The register must be implemented by any Function that uses an interrupt pin.
Values in this register are programmed by system software and are system architecture specific. The Function itself does not use this value; rather the value in this register is used by device drivers and operating systems.
                }
            }
            field INT_PIN @'h8 {
                bits 8;
                access ro;
                hard_reset 'h0;
                doc {
                    Interrupt Pin.
The Interrupt Pin register identifies the legacy interrupt Message(s) the Function uses.
The valid values are:
 - 01h, 02h, 03h, and 04h: Map to legacy interrupt Messages for INTA, INTB, INTC, and INTD respectively.
 - 00h: Indicates that the Function uses no legacy interrupt Message(s).
 - 05h through FFh: Reserved.
PCI Express defines one legacy interrupt Message for a single Function device and up to four legacy interrupt Messages for a multi-Function device. For a single Function device, only INTA may be used.

Any Function on a multi-Function device can use any of the INTx Messages. If a device implements a single legacy interrupt Message, it must be INTA; if it implements two legacy interrupt Messages, they must be INTA and INTB; and so forth.
For a multi-Function device, all Functions may use the same INTx Message or each may have its own (up to a maximum of four Functions) or any combination thereof. A single Function can never generate an interrupt request on more than one INTx Message.

Note: The access attributes of this field are as follows:
 - Wire: R (sticky) 
 - Dbi: if (DBI_RO_WR_EN == 1) then R/W else R 
Note: This register field is sticky.
                }
            }
            field RSVDP_16 @'h10 {
                bits 16;
                access ro;
                hard_reset 'h0;
                soft_reset 'h0;
                doc {
                    Reserved for future use.
                }
            }
            doc {
                Max_Lat, Min_Gnt, Interrupt Pin, and Interrupt Line Register. The Interrupt Line register communicates interrupt line routing information. The Interrupt Pin register identifies the legacy interrupt Message(s) the Function uses.Max_Lat, Min_Gnt, Interrupt Pin, and Interrupt Line Register. The Interrupt Line register communicates interrupt line routing information. The Interrupt Pin register identifies the legacy interrupt Message(s) the Function uses.
            }
        }
        doc {
            PF PCI-Compatible Configuration Space Header Type0
        }
    }
    block PF0_SPCIE_CAP @'h148 {
        bytes 4;
        register SPCIE_CAP_HEADER_REG @'h0 {
            bytes 4;
            field EXTENDED_CAP_ID @'h0 {
                bits 16;
                access ro;
                hard_reset 'h0;
                doc {
                    Secondary PCI Express Extended Capability ID.
For a description of this standard PCIe register field, see the PCI Express Specification.

Note: The access attributes of this field are as follows:
 - Wire: R (sticky) 
 - Dbi: if (DBI_RO_WR_EN == 1) then R/W(sticky) else R(sticky) 
Note: This register field is sticky.
                }
            }
            field CAP_VERSION @'h10 {
                bits 4;
                access ro;
                hard_reset 'h0;
                doc {
                    Capability Version.
For a description of this standard PCIe register field, see the PCI Express Specification.

Note: The access attributes of this field are as follows:
 - Wire: R (sticky) 
 - Dbi: if (DBI_RO_WR_EN == 1) then R/W(sticky) else R(sticky) 
Note: This register field is sticky.
                }
            }
            field NEXT_OFFSET @'h14 {
                bits 12;
                access ro;
                hard_reset 'h0;
                doc {
                    Next Capability Offset.
For a description of this standard PCIe register field, see the PCI Express Specification.

Note: The access attributes of this field are as follows:
 - Wire: R (sticky) 
 - Dbi: if (DBI_RO_WR_EN == 1) then R/W(sticky) else R(sticky) 
Note: This register field is sticky.
                }
            }
            doc {
                SPCIE Capability Header.
For a description of this standard PCIe register, see the PCI Express Specification.SPCIE Capability Header.
For a description of this standard PCIe register, see the PCI Express Specification.
            }
        }
        register LINK_CONTROL3_REG @'h4 {
            bytes 4;
            field PERFORM_EQ @'h0 {
                access ro;
                volatile 1
                hard_reset 'h0;
                doc {
                    Perform Equalization.
For a description of this standard PCIe register field, see the PCI Express Specification.

Note: The access attributes of this field are as follows:
 - Wire: RSVDP 
 - Dbi: RSVDP 
                }
            }
            field EQ_REQ_INT_EN @'h1 {
                access ro;
                hard_reset 'h0;
                doc {
                    Link Equalization Request Interrupt Enable.
For a description of this standard PCIe register field, see the PCI Express Specification.

Note: The access attributes of this field are as follows:
 - Wire: RSVDP 
 - Dbi: RSVDP 
                }
            }
            field RSVDP_2 @'h2 {
                bits 30;
                access ro;
                hard_reset 'h0;
                soft_reset 'h0;
                doc {
                    Reserved for future use.
                }
            }
            doc {
                Link Control 3 Register.
For a description of this standard PCIe register, see the PCI Express Specification.Link Control 3 Register.
For a description of this standard PCIe register, see the PCI Express Specification.
            }
        }
        register LANE_ERR_STATUS_REG @'h8 {
            bytes 4;
            field LANE_ERR_STATUS @'h0 {
                bits 16;
                access w1c;
                volatile 1
                hard_reset 'h0;
                soft_reset 'h0;
                doc {
                    Lane Error Status Bits per Lane.
For a description of this standard PCIe register field, see the PCI Express Specification.
                }
            }
            field RSVDP_LANE_ERR_STATUS @'h10 {
                bits 16;
                access ro;
                hard_reset 'h0;
                soft_reset 'h0;
                doc {
                    Reserved for future use.
                }
            }
            doc {
                Lane Error Status Register.
For a description of this standard PCIe register, see the PCI Express Specification.Lane Error Status Register.
For a description of this standard PCIe register, see the PCI Express Specification.
            }
        }
        register SPCIE_CAP_OFF_0CH_REG @'hc {
            bytes 4;
            field DSP_TX_PRESET0 @'h0 {
                bits 4;
                access ro;
                hard_reset 'h0;
                doc {
                    Downstream Port 8.0 GT/s Transmitter Preset 0.
For a description of this standard PCIe register field, see the PCI Express Specification.
                }
            }
            field DSP_RX_PRESET_HINT0 @'h4 {
                bits 3;
                access ro;
                hard_reset 'h0;
                doc {
                    Downstream Port 8.0 GT/s Receiver Preset Hint 0.
For a description of this standard PCIe register field, see the PCI Express Specification.
                }
            }
            field RSVDP_7 @'h7 {
                access ro;
                hard_reset 'h0;
                soft_reset 'h0;
                doc {
                    Reserved for future use.
                }
            }
            field USP_TX_PRESET0 @'h8 {
                bits 4;
                access ro;
                volatile 1
                hard_reset 'h0;
                doc {
                    Upstream Port 8.0 GT/s Transmitter Preset 0.

The write value is gated with the PCIE_CAP_CROSS_LINK_SUPPORT field of LINK_CAPABILITIES2_REG.
For a description of this standard PCIe register field, see the PCI Express Specification.

Note: This register field is sticky.
                }
            }
            field USP_RX_PRESET_HINT0 @'hc {
                bits 3;
                access ro;
                volatile 1
                hard_reset 'h0;
                doc {
                    Upstream Port 8.0 GT/s Receiver Preset Hint 0.

The write value is gated with the PCIE_CAP_CROSS_LINK_SUPPORT field of LINK_CAPABILITIES2_REG.
For a description of this standard PCIe register field, see the PCI Express Specification.

Note: This register field is sticky.
                }
            }
            field RSVDP_15 @'hf {
                access ro;
                hard_reset 'h0;
                soft_reset 'h0;
                doc {
                    Reserved for future use.
                }
            }
            field DSP_TX_PRESET1 @'h10 {
                bits 4;
                access ro;
                hard_reset 'h0;
                doc {
                    Downstream Port 8.0 GT/s Transmitter Preset 1.
For a description of this standard PCIe register field, see the PCI Express Specification.
                }
            }
            field DSP_RX_PRESET_HINT1 @'h14 {
                bits 3;
                access ro;
                hard_reset 'h0;
                doc {
                    Downstream Port 8.0 GT/s Receiver Preset Hint 1.
For a description of this standard PCIe register field, see the PCI Express Specification.
                }
            }
            field RSVDP_23 @'h17 {
                access ro;
                hard_reset 'h0;
                soft_reset 'h0;
                doc {
                    Reserved for future use.
                }
            }
            field USP_TX_PRESET1 @'h18 {
                bits 4;
                access ro;
                volatile 1
                hard_reset 'h0;
                doc {
                    Upstream Port 8.0 GT/s Transmitter Preset 1.

The write value is gated with the PCIE_CAP_CROSS_LINK_SUPPORT field of LINK_CAPABILITIES2_REG.
For a description of this standard PCIe register field, see the PCI Express Specification.

Note: This register field is sticky.
                }
            }
            field USP_RX_PRESET_HINT1 @'h1c {
                bits 3;
                access ro;
                volatile 1
                hard_reset 'h0;
                doc {
                    Upstream Port 8.0 GT/s Receiver Preset Hint 1.

The write value is gated with the PCIE_CAP_CROSS_LINK_SUPPORT field of LINK_CAPABILITIES2_REG.
For a description of this standard PCIe register field, see the PCI Express Specification.

Note: This register field is sticky.
                }
            }
            field RSVDP_31 @'h1f {
                access ro;
                hard_reset 'h0;
                soft_reset 'h0;
                doc {
                    Reserved for future use.
                }
            }
            doc {
                Lane Equalization Control Register for lanes 1 and 0.
For a description of this standard PCIe register, see the PCI Express Specification.Lane Equalization Control Register for lanes 1 and 0.
For a description of this standard PCIe register, see the PCI Express Specification.
            }
        }
        register SPCIE_CAP_OFF_10H_REG @'h10 {
            bytes 4;
            field DSP_TX_PRESET2 @'h0 {
                bits 4;
                access ro;
                hard_reset 'h0;
                doc {
                    Downstream Port 8.0 GT/s Transmitter Preset2.
For a description of this standard PCIe register, see the PCI Express Specification.
                }
            }
            field DSP_RX_PRESET_HINT2 @'h4 {
                bits 3;
                access ro;
                hard_reset 'h0;
                doc {
                    Downstream Port 8.0 GT/s Receiver Preset Hint2.
For a description of this standard PCIe register, see the PCI Express Specification.
                }
            }
            field RSVDP_7 @'h7 {
                access ro;
                hard_reset 'h0;
                soft_reset 'h0;
                doc {
                    Reserved for future use.
                }
            }
            field USP_TX_PRESET2 @'h8 {
                bits 4;
                access ro;
                volatile 1
                hard_reset 'h0;
                doc {
                    Upstream Port 8.0 GT/s Transmitter Preset2.

The write value is gated with the PCIE_CAP_CROSS_LINK_SUPPORT field of LINK_CAPABILITIES2_REG.
For a description of this standard PCIe register, see the PCI Express Specification.

Note: This register field is sticky.
                }
            }
            field USP_RX_PRESET_HINT2 @'hc {
                bits 3;
                access ro;
                volatile 1
                hard_reset 'h0;
                doc {
                    Upstream Port 8.0 GT/s Receiver Preset Hint2.

The write value is gated with the PCIE_CAP_CROSS_LINK_SUPPORT field of LINK_CAPABILITIES2_REG.
For a description of this standard PCIe register, see the PCI Express Specification.

Note: This register field is sticky.
                }
            }
            field RSVDP_15 @'hf {
                access ro;
                hard_reset 'h0;
                soft_reset 'h0;
                doc {
                    Reserved for future use.
                }
            }
            field DSP_TX_PRESET3 @'h10 {
                bits 4;
                access ro;
                hard_reset 'h0;
                doc {
                    Downstream Port 8.0 GT/s Transmitter Preset3.
For a description of this standard PCIe register, see the PCI Express Specification.
                }
            }
            field DSP_RX_PRESET_HINT3 @'h14 {
                bits 3;
                access ro;
                hard_reset 'h0;
                doc {
                    Downstream Port 8.0 GT/s Receiver Preset Hint3.
For a description of this standard PCIe register, see the PCI Express Specification.
                }
            }
            field RSVDP_23 @'h17 {
                access ro;
                hard_reset 'h0;
                soft_reset 'h0;
                doc {
                    Reserved for future use.
                }
            }
            field USP_TX_PRESET3 @'h18 {
                bits 4;
                access ro;
                volatile 1
                hard_reset 'h0;
                doc {
                    Upstream Port 8.0 GT/s Transmitter Preset3.

The write value is gated with the PCIE_CAP_CROSS_LINK_SUPPORT field of LINK_CAPABILITIES2_REG.
For a description of this standard PCIe register, see the PCI Express Specification.

Note: This register field is sticky.
                }
            }
            field USP_RX_PRESET_HINT3 @'h1c {
                bits 3;
                access ro;
                volatile 1
                hard_reset 'h0;
                doc {
                    Upstream Port 8.0 GT/s Receiver Preset Hint3.

The write value is gated with the PCIE_CAP_CROSS_LINK_SUPPORT field of LINK_CAPABILITIES2_REG.
For a description of this standard PCIe register, see the PCI Express Specification.

Note: This register field is sticky.
                }
            }
            field RSVDP_31 @'h1f {
                access ro;
                hard_reset 'h0;
                soft_reset 'h0;
                doc {
                    Reserved for future use.
                }
            }
            doc {
                Lane Equalization Control Register (LEC) or Lane Equalization Control Register 2 (LEC2)  2.
The function of this register is dependent on your actual configuration.
 - Gen3: LEC or RSVD depending on the value of CX_NL.
 - Gen4: LEC or LEC2 or RSVD depending on the value of CX_NL.
For a description of this standard PCIe register, see the PCI Express Specification.Lane Equalization Control Register (LEC) or Lane Equalization Control Register 2 (LEC2)  2.
The function of this register is dependent on your actual configuration.
 - Gen3: LEC or RSVD depending on the value of CX_NL.
 - Gen4: LEC or LEC2 or RSVD depending on the value of CX_NL.
For a description of this standard PCIe register, see the PCI Express Specification.
            }
        }
        register SPCIE_CAP_OFF_14H_REG @'h14 {
            bytes 4;
            field DSP_TX_PRESET4 @'h0 {
                bits 4;
                access ro;
                hard_reset 'h0;
                doc {
                    Downstream Port 8.0 GT/s Transmitter Preset4.
For a description of this standard PCIe register, see the PCI Express Specification.
                }
            }
            field DSP_RX_PRESET_HINT4 @'h4 {
                bits 3;
                access ro;
                hard_reset 'h0;
                doc {
                    Downstream Port 8.0 GT/s Receiver Preset Hint4.
For a description of this standard PCIe register, see the PCI Express Specification.
                }
            }
            field RSVDP_7 @'h7 {
                access ro;
                hard_reset 'h0;
                soft_reset 'h0;
                doc {
                    Reserved for future use.
                }
            }
            field USP_TX_PRESET4 @'h8 {
                bits 4;
                access ro;
                volatile 1
                hard_reset 'h0;
                doc {
                    Upstream Port 8.0 GT/s Transmitter Preset4.

The write value is gated with the PCIE_CAP_CROSS_LINK_SUPPORT field of LINK_CAPABILITIES2_REG.
For a description of this standard PCIe register, see the PCI Express Specification.

Note: This register field is sticky.
                }
            }
            field USP_RX_PRESET_HINT4 @'hc {
                bits 3;
                access ro;
                volatile 1
                hard_reset 'h0;
                doc {
                    Upstream Port 8.0 GT/s Receiver Preset Hint4.

The write value is gated with the PCIE_CAP_CROSS_LINK_SUPPORT field of LINK_CAPABILITIES2_REG.
For a description of this standard PCIe register, see the PCI Express Specification.

Note: This register field is sticky.
                }
            }
            field RSVDP_15 @'hf {
                access ro;
                hard_reset 'h0;
                soft_reset 'h0;
                doc {
                    Reserved for future use.
                }
            }
            field DSP_TX_PRESET5 @'h10 {
                bits 4;
                access ro;
                hard_reset 'h0;
                doc {
                    Downstream Port 8.0 GT/s Transmitter Preset5.
For a description of this standard PCIe register, see the PCI Express Specification.
                }
            }
            field DSP_RX_PRESET_HINT5 @'h14 {
                bits 3;
                access ro;
                hard_reset 'h0;
                doc {
                    Downstream Port 8.0 GT/s Receiver Preset Hint5.
For a description of this standard PCIe register, see the PCI Express Specification.
                }
            }
            field RSVDP_23 @'h17 {
                access ro;
                hard_reset 'h0;
                soft_reset 'h0;
                doc {
                    Reserved for future use.
                }
            }
            field USP_TX_PRESET5 @'h18 {
                bits 4;
                access ro;
                volatile 1
                hard_reset 'h0;
                doc {
                    Upstream Port 8.0 GT/s Transmitter Preset5.

The write value is gated with the PCIE_CAP_CROSS_LINK_SUPPORT field of LINK_CAPABILITIES2_REG.
For a description of this standard PCIe register, see the PCI Express Specification.

Note: This register field is sticky.
                }
            }
            field USP_RX_PRESET_HINT5 @'h1c {
                bits 3;
                access ro;
                volatile 1
                hard_reset 'h0;
                doc {
                    Upstream Port 8.0 GT/s Receiver Preset Hint5.

The write value is gated with the PCIE_CAP_CROSS_LINK_SUPPORT field of LINK_CAPABILITIES2_REG.
For a description of this standard PCIe register, see the PCI Express Specification.

Note: This register field is sticky.
                }
            }
            field RSVDP_31 @'h1f {
                access ro;
                hard_reset 'h0;
                soft_reset 'h0;
                doc {
                    Reserved for future use.
                }
            }
            doc {
                Lane Equalization Control Register (LEC) or Lane Equalization Control Register 2 (LEC2)  4.
The function of this register is dependent on your actual configuration.
 - Gen3: LEC or RSVD depending on the value of CX_NL.
 - Gen4: LEC or LEC2 or RSVD depending on the value of CX_NL.
For a description of this standard PCIe register, see the PCI Express Specification.Lane Equalization Control Register (LEC) or Lane Equalization Control Register 2 (LEC2)  4.
The function of this register is dependent on your actual configuration.
 - Gen3: LEC or RSVD depending on the value of CX_NL.
 - Gen4: LEC or LEC2 or RSVD depending on the value of CX_NL.
For a description of this standard PCIe register, see the PCI Express Specification.
            }
        }
        register SPCIE_CAP_OFF_18H_REG @'h18 {
            bytes 4;
            field DSP_TX_PRESET6 @'h0 {
                bits 4;
                access ro;
                hard_reset 'h0;
                doc {
                    Downstream Port 8.0 GT/s Transmitter Preset6.
For a description of this standard PCIe register, see the PCI Express Specification.
                }
            }
            field DSP_RX_PRESET_HINT6 @'h4 {
                bits 3;
                access ro;
                hard_reset 'h0;
                doc {
                    Downstream Port 8.0 GT/s Receiver Preset Hint6.
For a description of this standard PCIe register, see the PCI Express Specification.
                }
            }
            field RSVDP_7 @'h7 {
                access ro;
                hard_reset 'h0;
                soft_reset 'h0;
                doc {
                    Reserved for future use.
                }
            }
            field USP_TX_PRESET6 @'h8 {
                bits 4;
                access ro;
                volatile 1
                hard_reset 'h0;
                doc {
                    Upstream Port 8.0 GT/s Transmitter Preset6.

The write value is gated with the PCIE_CAP_CROSS_LINK_SUPPORT field of LINK_CAPABILITIES2_REG.
For a description of this standard PCIe register, see the PCI Express Specification.

Note: This register field is sticky.
                }
            }
            field USP_RX_PRESET_HINT6 @'hc {
                bits 3;
                access ro;
                volatile 1
                hard_reset 'h0;
                doc {
                    Upstream Port 8.0 GT/s Receiver Preset Hint6.

The write value is gated with the PCIE_CAP_CROSS_LINK_SUPPORT field of LINK_CAPABILITIES2_REG.
For a description of this standard PCIe register, see the PCI Express Specification.

Note: This register field is sticky.
                }
            }
            field RSVDP_15 @'hf {
                access ro;
                hard_reset 'h0;
                soft_reset 'h0;
                doc {
                    Reserved for future use.
                }
            }
            field DSP_TX_PRESET7 @'h10 {
                bits 4;
                access ro;
                hard_reset 'h0;
                doc {
                    Downstream Port 8.0 GT/s Transmitter Preset7.
For a description of this standard PCIe register, see the PCI Express Specification.
                }
            }
            field DSP_RX_PRESET_HINT7 @'h14 {
                bits 3;
                access ro;
                hard_reset 'h0;
                doc {
                    Downstream Port 8.0 GT/s Receiver Preset Hint7.
For a description of this standard PCIe register, see the PCI Express Specification.
                }
            }
            field RSVDP_23 @'h17 {
                access ro;
                hard_reset 'h0;
                soft_reset 'h0;
                doc {
                    Reserved for future use.
                }
            }
            field USP_TX_PRESET7 @'h18 {
                bits 4;
                access ro;
                volatile 1
                hard_reset 'h0;
                doc {
                    Upstream Port 8.0 GT/s Transmitter Preset7.

The write value is gated with the PCIE_CAP_CROSS_LINK_SUPPORT field of LINK_CAPABILITIES2_REG.
For a description of this standard PCIe register, see the PCI Express Specification.

Note: This register field is sticky.
                }
            }
            field USP_RX_PRESET_HINT7 @'h1c {
                bits 3;
                access ro;
                volatile 1
                hard_reset 'h0;
                doc {
                    Upstream Port 8.0 GT/s Receiver Preset Hint7.

The write value is gated with the PCIE_CAP_CROSS_LINK_SUPPORT field of LINK_CAPABILITIES2_REG.
For a description of this standard PCIe register, see the PCI Express Specification.

Note: This register field is sticky.
                }
            }
            field RSVDP_31 @'h1f {
                access ro;
                hard_reset 'h0;
                soft_reset 'h0;
                doc {
                    Reserved for future use.
                }
            }
            doc {
                Lane Equalization Control Register (LEC) or Lane Equalization Control Register 2 (LEC2)  6.
The function of this register is dependent on your actual configuration.
 - Gen3: LEC or RSVD depending on the value of CX_NL.
 - Gen4: LEC or LEC2 or RSVD depending on the value of CX_NL.
For a description of this standard PCIe register, see the PCI Express Specification.Lane Equalization Control Register (LEC) or Lane Equalization Control Register 2 (LEC2)  6.
The function of this register is dependent on your actual configuration.
 - Gen3: LEC or RSVD depending on the value of CX_NL.
 - Gen4: LEC or LEC2 or RSVD depending on the value of CX_NL.
For a description of this standard PCIe register, see the PCI Express Specification.
            }
        }
        register SPCIE_CAP_OFF_1CH_REG @'h1c {
            bytes 4;
            field DSP_TX_PRESET8 @'h0 {
                bits 4;
                access ro;
                hard_reset 'h0;
                doc {
                    Downstream Port 8.0 GT/s Transmitter Preset8.
For a description of this standard PCIe register, see the PCI Express Specification.
                }
            }
            field DSP_RX_PRESET_HINT8 @'h4 {
                bits 3;
                access ro;
                hard_reset 'h0;
                doc {
                    Downstream Port 8.0 GT/s Receiver Preset Hint8.
For a description of this standard PCIe register, see the PCI Express Specification.
                }
            }
            field RSVDP_7 @'h7 {
                access ro;
                hard_reset 'h0;
                soft_reset 'h0;
                doc {
                    Reserved for future use.
                }
            }
            field USP_TX_PRESET8 @'h8 {
                bits 4;
                access ro;
                volatile 1
                hard_reset 'h0;
                doc {
                    Upstream Port 8.0 GT/s Transmitter Preset8.

The write value is gated with the PCIE_CAP_CROSS_LINK_SUPPORT field of LINK_CAPABILITIES2_REG.
For a description of this standard PCIe register, see the PCI Express Specification.

Note: This register field is sticky.
                }
            }
            field USP_RX_PRESET_HINT8 @'hc {
                bits 3;
                access ro;
                volatile 1
                hard_reset 'h0;
                doc {
                    Upstream Port 8.0 GT/s Receiver Preset Hint8.

The write value is gated with the PCIE_CAP_CROSS_LINK_SUPPORT field of LINK_CAPABILITIES2_REG.
For a description of this standard PCIe register, see the PCI Express Specification.

Note: This register field is sticky.
                }
            }
            field RSVDP_15 @'hf {
                access ro;
                hard_reset 'h0;
                soft_reset 'h0;
                doc {
                    Reserved for future use.
                }
            }
            field DSP_TX_PRESET9 @'h10 {
                bits 4;
                access ro;
                hard_reset 'h0;
                doc {
                    Downstream Port 8.0 GT/s Transmitter Preset9.
For a description of this standard PCIe register, see the PCI Express Specification.
                }
            }
            field DSP_RX_PRESET_HINT9 @'h14 {
                bits 3;
                access ro;
                hard_reset 'h0;
                doc {
                    Downstream Port 8.0 GT/s Receiver Preset Hint9.
For a description of this standard PCIe register, see the PCI Express Specification.
                }
            }
            field RSVDP_23 @'h17 {
                access ro;
                hard_reset 'h0;
                soft_reset 'h0;
                doc {
                    Reserved for future use.
                }
            }
            field USP_TX_PRESET9 @'h18 {
                bits 4;
                access ro;
                volatile 1
                hard_reset 'h0;
                doc {
                    Upstream Port 8.0 GT/s Transmitter Preset9.

The write value is gated with the PCIE_CAP_CROSS_LINK_SUPPORT field of LINK_CAPABILITIES2_REG.
For a description of this standard PCIe register, see the PCI Express Specification.

Note: This register field is sticky.
                }
            }
            field USP_RX_PRESET_HINT9 @'h1c {
                bits 3;
                access ro;
                volatile 1
                hard_reset 'h0;
                doc {
                    Upstream Port 8.0 GT/s Receiver Preset Hint9.

The write value is gated with the PCIE_CAP_CROSS_LINK_SUPPORT field of LINK_CAPABILITIES2_REG.
For a description of this standard PCIe register, see the PCI Express Specification.

Note: This register field is sticky.
                }
            }
            field RSVDP_31 @'h1f {
                access ro;
                hard_reset 'h0;
                soft_reset 'h0;
                doc {
                    Reserved for future use.
                }
            }
            doc {
                Lane Equalization Control Register (LEC) or Lane Equalization Control Register 2 (LEC2)  8.
The function of this register is dependent on your actual configuration.
 - Gen3: LEC or RSVD depending on the value of CX_NL.
 - Gen4: LEC or LEC2 or RSVD depending on the value of CX_NL.
For a description of this standard PCIe register, see the PCI Express Specification.Lane Equalization Control Register (LEC) or Lane Equalization Control Register 2 (LEC2)  8.
The function of this register is dependent on your actual configuration.
 - Gen3: LEC or RSVD depending on the value of CX_NL.
 - Gen4: LEC or LEC2 or RSVD depending on the value of CX_NL.
For a description of this standard PCIe register, see the PCI Express Specification.
            }
        }
        register SPCIE_CAP_OFF_20H_REG @'h20 {
            bytes 4;
            field DSP_TX_PRESET10 @'h0 {
                bits 4;
                access ro;
                hard_reset 'h0;
                doc {
                    Downstream Port 8.0 GT/s Transmitter Preset10.
For a description of this standard PCIe register, see the PCI Express Specification.
                }
            }
            field DSP_RX_PRESET_HINT10 @'h4 {
                bits 3;
                access ro;
                hard_reset 'h0;
                doc {
                    Downstream Port 8.0 GT/s Receiver Preset Hint10.
For a description of this standard PCIe register, see the PCI Express Specification.
                }
            }
            field RSVDP_7 @'h7 {
                access ro;
                hard_reset 'h0;
                soft_reset 'h0;
                doc {
                    Reserved for future use.
                }
            }
            field USP_TX_PRESET10 @'h8 {
                bits 4;
                access ro;
                volatile 1
                hard_reset 'h0;
                doc {
                    Upstream Port 8.0 GT/s Transmitter Preset10.

The write value is gated with the PCIE_CAP_CROSS_LINK_SUPPORT field of LINK_CAPABILITIES2_REG.
For a description of this standard PCIe register, see the PCI Express Specification.

Note: This register field is sticky.
                }
            }
            field USP_RX_PRESET_HINT10 @'hc {
                bits 3;
                access ro;
                volatile 1
                hard_reset 'h0;
                doc {
                    Upstream Port 8.0 GT/s Receiver Preset Hint10.

The write value is gated with the PCIE_CAP_CROSS_LINK_SUPPORT field of LINK_CAPABILITIES2_REG.
For a description of this standard PCIe register, see the PCI Express Specification.

Note: This register field is sticky.
                }
            }
            field RSVDP_15 @'hf {
                access ro;
                hard_reset 'h0;
                soft_reset 'h0;
                doc {
                    Reserved for future use.
                }
            }
            field DSP_TX_PRESET11 @'h10 {
                bits 4;
                access ro;
                hard_reset 'h0;
                doc {
                    Downstream Port 8.0 GT/s Transmitter Preset11.
For a description of this standard PCIe register, see the PCI Express Specification.
                }
            }
            field DSP_RX_PRESET_HINT11 @'h14 {
                bits 3;
                access ro;
                hard_reset 'h0;
                doc {
                    Downstream Port 8.0 GT/s Receiver Preset Hint11.
For a description of this standard PCIe register, see the PCI Express Specification.
                }
            }
            field RSVDP_23 @'h17 {
                access ro;
                hard_reset 'h0;
                soft_reset 'h0;
                doc {
                    Reserved for future use.
                }
            }
            field USP_TX_PRESET11 @'h18 {
                bits 4;
                access ro;
                volatile 1
                hard_reset 'h0;
                doc {
                    Upstream Port 8.0 GT/s Transmitter Preset11.

The write value is gated with the PCIE_CAP_CROSS_LINK_SUPPORT field of LINK_CAPABILITIES2_REG.
For a description of this standard PCIe register, see the PCI Express Specification.

Note: This register field is sticky.
                }
            }
            field USP_RX_PRESET_HINT11 @'h1c {
                bits 3;
                access ro;
                volatile 1
                hard_reset 'h0;
                doc {
                    Upstream Port 8.0 GT/s Receiver Preset Hint11.

The write value is gated with the PCIE_CAP_CROSS_LINK_SUPPORT field of LINK_CAPABILITIES2_REG.
For a description of this standard PCIe register, see the PCI Express Specification.

Note: This register field is sticky.
                }
            }
            field RSVDP_31 @'h1f {
                access ro;
                hard_reset 'h0;
                soft_reset 'h0;
                doc {
                    Reserved for future use.
                }
            }
            doc {
                Lane Equalization Control Register (LEC) or Lane Equalization Control Register 2 (LEC2)  10.
The function of this register is dependent on your actual configuration.
 - Gen3: LEC or RSVD depending on the value of CX_NL.
 - Gen4: LEC or LEC2 or RSVD depending on the value of CX_NL.
For a description of this standard PCIe register, see the PCI Express Specification.Lane Equalization Control Register (LEC) or Lane Equalization Control Register 2 (LEC2)  10.
The function of this register is dependent on your actual configuration.
 - Gen3: LEC or RSVD depending on the value of CX_NL.
 - Gen4: LEC or LEC2 or RSVD depending on the value of CX_NL.
For a description of this standard PCIe register, see the PCI Express Specification.
            }
        }
        register SPCIE_CAP_OFF_24H_REG @'h24 {
            bytes 4;
            field DSP_TX_PRESET12 @'h0 {
                bits 4;
                access ro;
                hard_reset 'h0;
                doc {
                    Downstream Port 8.0 GT/s Transmitter Preset12.
For a description of this standard PCIe register, see the PCI Express Specification.
                }
            }
            field DSP_RX_PRESET_HINT12 @'h4 {
                bits 3;
                access ro;
                hard_reset 'h0;
                doc {
                    Downstream Port 8.0 GT/s Receiver Preset Hint12.
For a description of this standard PCIe register, see the PCI Express Specification.
                }
            }
            field RSVDP_7 @'h7 {
                access ro;
                hard_reset 'h0;
                soft_reset 'h0;
                doc {
                    Reserved for future use.
                }
            }
            field USP_TX_PRESET12 @'h8 {
                bits 4;
                access ro;
                volatile 1
                hard_reset 'h0;
                doc {
                    Upstream Port 8.0 GT/s Transmitter Preset12.

The write value is gated with the PCIE_CAP_CROSS_LINK_SUPPORT field of LINK_CAPABILITIES2_REG.
For a description of this standard PCIe register, see the PCI Express Specification.

Note: This register field is sticky.
                }
            }
            field USP_RX_PRESET_HINT12 @'hc {
                bits 3;
                access ro;
                volatile 1
                hard_reset 'h0;
                doc {
                    Upstream Port 8.0 GT/s Receiver Preset Hint12.

The write value is gated with the PCIE_CAP_CROSS_LINK_SUPPORT field of LINK_CAPABILITIES2_REG.
For a description of this standard PCIe register, see the PCI Express Specification.

Note: This register field is sticky.
                }
            }
            field RSVDP_15 @'hf {
                access ro;
                hard_reset 'h0;
                soft_reset 'h0;
                doc {
                    Reserved for future use.
                }
            }
            field DSP_TX_PRESET13 @'h10 {
                bits 4;
                access ro;
                hard_reset 'h0;
                doc {
                    Downstream Port 8.0 GT/s Transmitter Preset13.
For a description of this standard PCIe register, see the PCI Express Specification.
                }
            }
            field DSP_RX_PRESET_HINT13 @'h14 {
                bits 3;
                access ro;
                hard_reset 'h0;
                doc {
                    Downstream Port 8.0 GT/s Receiver Preset Hint13.
For a description of this standard PCIe register, see the PCI Express Specification.
                }
            }
            field RSVDP_23 @'h17 {
                access ro;
                hard_reset 'h0;
                soft_reset 'h0;
                doc {
                    Reserved for future use.
                }
            }
            field USP_TX_PRESET13 @'h18 {
                bits 4;
                access ro;
                volatile 1
                hard_reset 'h0;
                doc {
                    Upstream Port 8.0 GT/s Transmitter Preset13.

The write value is gated with the PCIE_CAP_CROSS_LINK_SUPPORT field of LINK_CAPABILITIES2_REG.
For a description of this standard PCIe register, see the PCI Express Specification.

Note: This register field is sticky.
                }
            }
            field USP_RX_PRESET_HINT13 @'h1c {
                bits 3;
                access ro;
                volatile 1
                hard_reset 'h0;
                doc {
                    Upstream Port 8.0 GT/s Receiver Preset Hint13.

The write value is gated with the PCIE_CAP_CROSS_LINK_SUPPORT field of LINK_CAPABILITIES2_REG.
For a description of this standard PCIe register, see the PCI Express Specification.

Note: This register field is sticky.
                }
            }
            field RSVDP_31 @'h1f {
                access ro;
                hard_reset 'h0;
                soft_reset 'h0;
                doc {
                    Reserved for future use.
                }
            }
            doc {
                Lane Equalization Control Register (LEC) or Lane Equalization Control Register 2 (LEC2)  12.
The function of this register is dependent on your actual configuration.
 - Gen3: LEC or RSVD depending on the value of CX_NL.
 - Gen4: LEC or LEC2 or RSVD depending on the value of CX_NL.
For a description of this standard PCIe register, see the PCI Express Specification.Lane Equalization Control Register (LEC) or Lane Equalization Control Register 2 (LEC2)  12.
The function of this register is dependent on your actual configuration.
 - Gen3: LEC or RSVD depending on the value of CX_NL.
 - Gen4: LEC or LEC2 or RSVD depending on the value of CX_NL.
For a description of this standard PCIe register, see the PCI Express Specification.
            }
        }
        register SPCIE_CAP_OFF_28H_REG @'h28 {
            bytes 4;
            field DSP_TX_PRESET14 @'h0 {
                bits 4;
                access ro;
                hard_reset 'h0;
                doc {
                    Downstream Port 8.0 GT/s Transmitter Preset14.
For a description of this standard PCIe register, see the PCI Express Specification.
                }
            }
            field DSP_RX_PRESET_HINT14 @'h4 {
                bits 3;
                access ro;
                hard_reset 'h0;
                doc {
                    Downstream Port 8.0 GT/s Receiver Preset Hint14.
For a description of this standard PCIe register, see the PCI Express Specification.
                }
            }
            field RSVDP_7 @'h7 {
                access ro;
                hard_reset 'h0;
                soft_reset 'h0;
                doc {
                    Reserved for future use.
                }
            }
            field USP_TX_PRESET14 @'h8 {
                bits 4;
                access ro;
                volatile 1
                hard_reset 'h0;
                doc {
                    Upstream Port 8.0 GT/s Transmitter Preset14.

The write value is gated with the PCIE_CAP_CROSS_LINK_SUPPORT field of LINK_CAPABILITIES2_REG.
For a description of this standard PCIe register, see the PCI Express Specification.

Note: This register field is sticky.
                }
            }
            field USP_RX_PRESET_HINT14 @'hc {
                bits 3;
                access ro;
                volatile 1
                hard_reset 'h0;
                doc {
                    Upstream Port 8.0 GT/s Receiver Preset Hint14.

The write value is gated with the PCIE_CAP_CROSS_LINK_SUPPORT field of LINK_CAPABILITIES2_REG.
For a description of this standard PCIe register, see the PCI Express Specification.

Note: This register field is sticky.
                }
            }
            field RSVDP_15 @'hf {
                access ro;
                hard_reset 'h0;
                soft_reset 'h0;
                doc {
                    Reserved for future use.
                }
            }
            field DSP_TX_PRESET15 @'h10 {
                bits 4;
                access ro;
                hard_reset 'h0;
                doc {
                    Downstream Port 8.0 GT/s Transmitter Preset15.
For a description of this standard PCIe register, see the PCI Express Specification.
                }
            }
            field DSP_RX_PRESET_HINT15 @'h14 {
                bits 3;
                access ro;
                hard_reset 'h0;
                doc {
                    Downstream Port 8.0 GT/s Receiver Preset Hint15.
For a description of this standard PCIe register, see the PCI Express Specification.
                }
            }
            field RSVDP_23 @'h17 {
                access ro;
                hard_reset 'h0;
                soft_reset 'h0;
                doc {
                    Reserved for future use.
                }
            }
            field USP_TX_PRESET15 @'h18 {
                bits 4;
                access ro;
                volatile 1
                hard_reset 'h0;
                doc {
                    Upstream Port 8.0 GT/s Transmitter Preset15.

The write value is gated with the PCIE_CAP_CROSS_LINK_SUPPORT field of LINK_CAPABILITIES2_REG.
For a description of this standard PCIe register, see the PCI Express Specification.

Note: This register field is sticky.
                }
            }
            field USP_RX_PRESET_HINT15 @'h1c {
                bits 3;
                access ro;
                volatile 1
                hard_reset 'h0;
                doc {
                    Upstream Port 8.0 GT/s Receiver Preset Hint15.

The write value is gated with the PCIE_CAP_CROSS_LINK_SUPPORT field of LINK_CAPABILITIES2_REG.
For a description of this standard PCIe register, see the PCI Express Specification.

Note: This register field is sticky.
                }
            }
            field RSVDP_31 @'h1f {
                access ro;
                hard_reset 'h0;
                soft_reset 'h0;
                doc {
                    Reserved for future use.
                }
            }
            doc {
                Lane Equalization Control Register (LEC) or Lane Equalization Control Register 2 (LEC2)  14.
The function of this register is dependent on your actual configuration.
 - Gen3: LEC or RSVD depending on the value of CX_NL.
 - Gen4: LEC or LEC2 or RSVD depending on the value of CX_NL.
For a description of this standard PCIe register, see the PCI Express Specification.Lane Equalization Control Register (LEC) or Lane Equalization Control Register 2 (LEC2)  14.
The function of this register is dependent on your actual configuration.
 - Gen3: LEC or RSVD depending on the value of CX_NL.
 - Gen4: LEC or LEC2 or RSVD depending on the value of CX_NL.
For a description of this standard PCIe register, see the PCI Express Specification.
            }
        }
        doc {
            Secondary PCI Express Capability Structure
        }
    }
    block PF0_PL16G_CAP @'h178 {
        bytes 4;
        register PL16G_EXT_CAP_HDR_REG @'h0 {
            bytes 4;
            field EXTENDED_CAP_ID @'h0 {
                bits 16;
                access ro;
                hard_reset 'h0;
                doc {
                    PCI Express Extended Capability ID.
For a description of this standard PCIe register field, see the PCI Express Base Specification 4.0.

Note: The access attributes of this field are as follows:
 - Wire: R (sticky) 
 - Dbi: if (DBI_RO_WR_EN == 1) then R/W(sticky) else R(sticky) 
Note: This register field is sticky.
                }
            }
            field CAP_VERSION @'h10 {
                bits 4;
                access ro;
                hard_reset 'h0;
                doc {
                    Capability Version.
For a description of this standard PCIe register field, see the PCI Express Base Specification 4.0.

Note: The access attributes of this field are as follows:
 - Wire: R (sticky) 
 - Dbi: if (DBI_RO_WR_EN == 1) then R/W(sticky) else R(sticky) 
Note: This register field is sticky.
                }
            }
            field NEXT_OFFSET @'h14 {
                bits 12;
                access ro;
                hard_reset 'h0;
                doc {
                    Next Capability Offset.
For a description of this standard PCIe register field, see the PCI Express Base Specification 4.0.

Note: The access attributes of this field are as follows:
 - Wire: R (sticky) 
 - Dbi: if (DBI_RO_WR_EN == 1) then R/W(sticky) else R(sticky) 
Note: This register field is sticky.
                }
            }
            doc {
                Physical Layer 16.0 GT/s Extended Capability Header.
For a description of this standard PCIe register, see the PCI Express Base Specification 4.0.Physical Layer 16.0 GT/s Extended Capability Header.
For a description of this standard PCIe register, see the PCI Express Base Specification 4.0.
            }
        }
        register PL16G_CAPABILITY_REG @'h4 {
            bytes 4;
            field RSVDP_0 @'h0 {
                bits 32;
                access ro;
                hard_reset 'h0;
                doc {
                    Reserved for future use.
                }
            }
            doc {
                16.0 GT/s Capabilities Register.
For a description of this standard PCIe register, see the PCI Express Base Specification 4.0.16.0 GT/s Capabilities Register.
For a description of this standard PCIe register, see the PCI Express Base Specification 4.0.
            }
        }
        register PL16G_CONTROL_REG @'h8 {
            bytes 4;
            field RSVDP_0 @'h0 {
                bits 32;
                access ro;
                hard_reset 'h0;
                doc {
                    Reserved for future use.
                }
            }
            doc {
                16.0 GT/s Control Register .
For a description of this standard PCIe register, see the PCI Express Base Specification 4.0.16.0 GT/s Control Register .
For a description of this standard PCIe register, see the PCI Express Base Specification 4.0.
            }
        }
        register PL16G_STATUS_REG @'hc {
            bytes 4;
            field EQ_16G_CPL @'h0 {
                access ro;
                volatile 1
                hard_reset 'h0;
                doc {
                    Equalization 16.0GT/s Complete.
For a description of this standard PCIe register field, see the PCI Express Base Specification 4.0.

Note: This register field is sticky.
                }
            }
            field EQ_16G_CPL_P1 @'h1 {
                access ro;
                volatile 1
                hard_reset 'h0;
                doc {
                    Equalization 16.0GT/s Phase 1 Successful.
For a description of this standard PCIe register field, see the PCI Express Base Specification 4.0.

Note: This register field is sticky.
                }
            }
            field EQ_16G_CPL_P2 @'h2 {
                access ro;
                volatile 1
                hard_reset 'h0;
                doc {
                    Equalization 16.0GT/s Phase 2 Successful.
For a description of this standard PCIe register field, see the PCI Express Base Specification 4.0.

Note: This register field is sticky.
                }
            }
            field EQ_16G_CPL_P3 @'h3 {
                access ro;
                volatile 1
                hard_reset 'h0;
                doc {
                    Equalization 16.0GT/s Phase 3 Successful.
For a description of this standard PCIe register field, see the PCI Express Base Specification 4.0.

Note: This register field is sticky.
                }
            }
            field LINK_EQ_16G_REQ @'h4 {
                access w1c;
                volatile 1
                hard_reset 'h0;
                doc {
                    Link Equalization Request 16.0GT/s.
For a description of this standard PCIe register field, see the PCI Express Base Specification 4.0.
                }
            }
            field RSVDP_5 @'h5 {
                bits 27;
                access ro;
                hard_reset 'h0;
                soft_reset 'h0;
                doc {
                    Reserved for future use.
                }
            }
            doc {
                16.0 GT/s Status Register.
For a description of this standard PCIe register, see the PCI Express Base Specification 4.0.16.0 GT/s Status Register.
For a description of this standard PCIe register, see the PCI Express Base Specification 4.0.
            }
        }
        register PL16G_LC_DPAR_STATUS_REG @'h10 {
            bytes 4;
            field LC_DPAR_STATUS @'h0 {
                bits 16;
                access w1c;
                volatile 1
                hard_reset 'h0;
                doc {
                    Local Data Parity Mismatch Status.
For a description of this standard PCIe register field, see the PCI Express Base Specification 4.0.
                }
            }
            field RSVDP_LC_DPAR_STATUS @'h10 {
                bits 16;
                access ro;
                hard_reset 'h0;
                doc {
                    Reserved for future use.
                }
            }
            doc {
                16.0 GT/s Local Data Parity Mismatch Status Register.
For a description of this standard PCIe register, see the PCI Express Base Specification 4.0.16.0 GT/s Local Data Parity Mismatch Status Register.
For a description of this standard PCIe register, see the PCI Express Base Specification 4.0.
            }
        }
        register PL16G_FIRST_RETIMER_DPAR_STATUS_REG @'h14 {
            bytes 4;
            field FIRST_RETIMER_DPAR_STATUS @'h0 {
                bits 16;
                access w1c;
                volatile 1
                hard_reset 'h0;
                doc {
                    First Retimer Data Parity Mismatch Status.
For a description of this standard PCIe register field, see the PCI Express Base Specification 4.0.
                }
            }
            field RSVDP_FIRST_RETIMER_DPAR_STATUS @'h10 {
                bits 16;
                access ro;
                hard_reset 'h0;
                doc {
                    Reserved for future use.
                }
            }
            doc {
                16.0 GT/s First Retimer Data Parity Mismatch Status Register.
For a description of this standard PCIe register, see the PCI Express Base Specification 4.0.16.0 GT/s First Retimer Data Parity Mismatch Status Register.
For a description of this standard PCIe register, see the PCI Express Base Specification 4.0.
            }
        }
        register PL16G_SECOND_RETIMER_DPAR_STATUS_REG @'h18 {
            bytes 4;
            field SECOND_RETIMER_DPAR_STATUS @'h0 {
                bits 16;
                access w1c;
                volatile 1
                hard_reset 'h0;
                doc {
                    Second Retimer Data Parity Mismatch Status .
For a description of this standard PCIe register field, see the PCI Express Base Specification 4.0.
                }
            }
            field RSVDP_SECOND_RETIMER_DPAR_STATUS @'h10 {
                bits 16;
                access ro;
                hard_reset 'h0;
                doc {
                    Reserved for future use.
                }
            }
            doc {
                16.0 GT/s Second Retimer Data Parity Mismatch Status Register.
For a description of this standard PCIe register, see the PCI Express Base Specification 4.0.16.0 GT/s Second Retimer Data Parity Mismatch Status Register.
For a description of this standard PCIe register, see the PCI Express Base Specification 4.0.
            }
        }
        register PL16G_CAP_OFF_20H_REG @'h20 {
            bytes 4;
            field DSP_16G_TX_PRESET0 @'h0 {
                bits 4;
                access ro;
                hard_reset 'h0;
                doc {
                    Downstream Port 16.0 GT/s Transmitter Preset0.
For a description of this standard PCIe register field, see the PCI Express Base Specification 4.0.
                }
            }
            field USP_16G_TX_PRESET0 @'h4 {
                bits 4;
                access ro;
                hard_reset 'h0;
                doc {
                    Upstream Port 16.0 GT/s Transmitter Preset0.
For a description of this standard PCIe register field, see the PCI Express Base Specification 4.0.
                }
            }
            field DSP_16G_TX_PRESET1 @'h8 {
                bits 4;
                access ro;
                hard_reset 'h0;
                doc {
                    Downstream Port 16.0 GT/s Transmitter Preset1.
For a description of this standard PCIe register field, see the PCI Express Base Specification 4.0.
                }
            }
            field USP_16G_TX_PRESET1 @'hc {
                bits 4;
                access ro;
                hard_reset 'h0;
                doc {
                    Upstream Port 16.0 GT/s Transmitter Preset1.
For a description of this standard PCIe register field, see the PCI Express Base Specification 4.0.
                }
            }
            field DSP_16G_TX_PRESET2 @'h10 {
                bits 4;
                access ro;
                hard_reset 'h0;
                doc {
                    Downstream Port 16.0 GT/s Transmitter Preset2.
For a description of this standard PCIe register field, see the PCI Express Base Specification 4.0.
                }
            }
            field USP_16G_TX_PRESET2 @'h14 {
                bits 4;
                access ro;
                hard_reset 'h0;
                doc {
                    Upstream Port 16.0 GT/s Transmitter Preset2.
For a description of this standard PCIe register field, see the PCI Express Base Specification 4.0.
                }
            }
            field DSP_16G_TX_PRESET3 @'h18 {
                bits 4;
                access ro;
                hard_reset 'h0;
                doc {
                    Downstream Port 16.0 GT/s Transmitter Preset3.
For a description of this standard PCIe register field, see the PCI Express Base Specification 4.0.
                }
            }
            field USP_16G_TX_PRESET3 @'h1c {
                bits 4;
                access ro;
                hard_reset 'h0;
                doc {
                    Upstream Port 16.0 GT/s Transmitter Preset3.
For a description of this standard PCIe register field, see the PCI Express Base Specification 4.0.
                }
            }
            doc {
                16.0 GT/s Lane Equalization Control Register  for Lane 0-3.
For a description of this standard PCIe register, see the PCI Express Base Specification 4.0.16.0 GT/s Lane Equalization Control Register  for Lane 0-3.
For a description of this standard PCIe register, see the PCI Express Base Specification 4.0.
            }
        }
        register PL16G_CAP_OFF_24H_REG @'h24 {
            bytes 4;
            field DSP_16G_TX_PRESET4 @'h0 {
                bits 4;
                access ro;
                hard_reset 'h0;
                doc {
                    Downstream Port 16.0 GT/s Transmitter Preset4.
For a description of this standard PCIe register field, see the PCI Express Base Specification 4.0.
                }
            }
            field USP_16G_TX_PRESET4 @'h4 {
                bits 4;
                access ro;
                hard_reset 'h0;
                doc {
                    Upstream Port 16.0 GT/s Transmitter Preset4.
For a description of this standard PCIe register field, see the PCI Express Base Specification 4.0.
                }
            }
            field DSP_16G_TX_PRESET5 @'h8 {
                bits 4;
                access ro;
                hard_reset 'h0;
                doc {
                    Downstream Port 16.0 GT/s Transmitter Preset5.
For a description of this standard PCIe register field, see the PCI Express Base Specification 4.0.
                }
            }
            field USP_16G_TX_PRESET5 @'hc {
                bits 4;
                access ro;
                hard_reset 'h0;
                doc {
                    Upstream Port 16.0 GT/s Transmitter Preset5.
For a description of this standard PCIe register field, see the PCI Express Base Specification 4.0.
                }
            }
            field DSP_16G_TX_PRESET6 @'h10 {
                bits 4;
                access ro;
                hard_reset 'h0;
                doc {
                    Downstream Port 16.0 GT/s Transmitter Preset6.
For a description of this standard PCIe register field, see the PCI Express Base Specification 4.0.
                }
            }
            field USP_16G_TX_PRESET6 @'h14 {
                bits 4;
                access ro;
                hard_reset 'h0;
                doc {
                    Upstream Port 16.0 GT/s Transmitter Preset6.
For a description of this standard PCIe register field, see the PCI Express Base Specification 4.0.
                }
            }
            field DSP_16G_TX_PRESET7 @'h18 {
                bits 4;
                access ro;
                hard_reset 'h0;
                doc {
                    Downstream Port 16.0 GT/s Transmitter Preset7.
For a description of this standard PCIe register field, see the PCI Express Base Specification 4.0.
                }
            }
            field USP_16G_TX_PRESET7 @'h1c {
                bits 4;
                access ro;
                hard_reset 'h0;
                doc {
                    Upstream Port 16.0 GT/s Transmitter Preset7.
For a description of this standard PCIe register field, see the PCI Express Base Specification 4.0.
                }
            }
            doc {
                16.0 GT/s Lane Equalization Control Register  for Lane 4-7.
For a description of this standard PCIe register, see the PCI Express Base Specification 4.0.16.0 GT/s Lane Equalization Control Register  for Lane 4-7.
For a description of this standard PCIe register, see the PCI Express Base Specification 4.0.
            }
        }
        register PL16G_CAP_OFF_28H_REG @'h28 {
            bytes 4;
            field DSP_16G_TX_PRESET8 @'h0 {
                bits 4;
                access ro;
                hard_reset 'h0;
                doc {
                    Downstream Port 16.0 GT/s Transmitter Preset8.
For a description of this standard PCIe register field, see the PCI Express Base Specification 4.0.
                }
            }
            field USP_16G_TX_PRESET8 @'h4 {
                bits 4;
                access ro;
                hard_reset 'h0;
                doc {
                    Upstream Port 16.0 GT/s Transmitter Preset8.
For a description of this standard PCIe register field, see the PCI Express Base Specification 4.0.
                }
            }
            field DSP_16G_TX_PRESET9 @'h8 {
                bits 4;
                access ro;
                hard_reset 'h0;
                doc {
                    Downstream Port 16.0 GT/s Transmitter Preset9.
For a description of this standard PCIe register field, see the PCI Express Base Specification 4.0.
                }
            }
            field USP_16G_TX_PRESET9 @'hc {
                bits 4;
                access ro;
                hard_reset 'h0;
                doc {
                    Upstream Port 16.0 GT/s Transmitter Preset9.
For a description of this standard PCIe register field, see the PCI Express Base Specification 4.0.
                }
            }
            field DSP_16G_TX_PRESET10 @'h10 {
                bits 4;
                access ro;
                hard_reset 'h0;
                doc {
                    Downstream Port 16.0 GT/s Transmitter Preset10.
For a description of this standard PCIe register field, see the PCI Express Base Specification 4.0.
                }
            }
            field USP_16G_TX_PRESET10 @'h14 {
                bits 4;
                access ro;
                hard_reset 'h0;
                doc {
                    Upstream Port 16.0 GT/s Transmitter Preset10.
For a description of this standard PCIe register field, see the PCI Express Base Specification 4.0.
                }
            }
            field DSP_16G_TX_PRESET11 @'h18 {
                bits 4;
                access ro;
                hard_reset 'h0;
                doc {
                    Downstream Port 16.0 GT/s Transmitter Preset11.
For a description of this standard PCIe register field, see the PCI Express Base Specification 4.0.
                }
            }
            field USP_16G_TX_PRESET11 @'h1c {
                bits 4;
                access ro;
                hard_reset 'h0;
                doc {
                    Upstream Port 16.0 GT/s Transmitter Preset11.
For a description of this standard PCIe register field, see the PCI Express Base Specification 4.0.
                }
            }
            doc {
                16.0 GT/s Lane Equalization Control Register  for Lane 8-11.
For a description of this standard PCIe register, see the PCI Express Base Specification 4.0.16.0 GT/s Lane Equalization Control Register  for Lane 8-11.
For a description of this standard PCIe register, see the PCI Express Base Specification 4.0.
            }
        }
        register PL16G_CAP_OFF_2CH_REG @'h2c {
            bytes 4;
            field DSP_16G_TX_PRESET12 @'h0 {
                bits 4;
                access ro;
                hard_reset 'h0;
                doc {
                    Downstream Port 16.0 GT/s Transmitter Preset12.
For a description of this standard PCIe register field, see the PCI Express Base Specification 4.0.
                }
            }
            field USP_16G_TX_PRESET12 @'h4 {
                bits 4;
                access ro;
                hard_reset 'h0;
                doc {
                    Upstream Port 16.0 GT/s Transmitter Preset12.
For a description of this standard PCIe register field, see the PCI Express Base Specification 4.0.
                }
            }
            field DSP_16G_TX_PRESET13 @'h8 {
                bits 4;
                access ro;
                hard_reset 'h0;
                doc {
                    Downstream Port 16.0 GT/s Transmitter Preset13.
For a description of this standard PCIe register field, see the PCI Express Base Specification 4.0.
                }
            }
            field USP_16G_TX_PRESET13 @'hc {
                bits 4;
                access ro;
                hard_reset 'h0;
                doc {
                    Upstream Port 16.0 GT/s Transmitter Preset13.
For a description of this standard PCIe register field, see the PCI Express Base Specification 4.0.
                }
            }
            field DSP_16G_TX_PRESET14 @'h10 {
                bits 4;
                access ro;
                hard_reset 'h0;
                doc {
                    Downstream Port 16.0 GT/s Transmitter Preset14.
For a description of this standard PCIe register field, see the PCI Express Base Specification 4.0.
                }
            }
            field USP_16G_TX_PRESET14 @'h14 {
                bits 4;
                access ro;
                hard_reset 'h0;
                doc {
                    Upstream Port 16.0 GT/s Transmitter Preset14.
For a description of this standard PCIe register field, see the PCI Express Base Specification 4.0.
                }
            }
            field DSP_16G_TX_PRESET15 @'h18 {
                bits 4;
                access ro;
                hard_reset 'h0;
                doc {
                    Downstream Port 16.0 GT/s Transmitter Preset15.
For a description of this standard PCIe register field, see the PCI Express Base Specification 4.0.
                }
            }
            field USP_16G_TX_PRESET15 @'h1c {
                bits 4;
                access ro;
                hard_reset 'h0;
                doc {
                    Upstream Port 16.0 GT/s Transmitter Preset15.
For a description of this standard PCIe register field, see the PCI Express Base Specification 4.0.
                }
            }
            doc {
                16.0 GT/s Lane Equalization Control Register  for Lane 12-15.
For a description of this standard PCIe register, see the PCI Express Base Specification 4.0.16.0 GT/s Lane Equalization Control Register  for Lane 12-15.
For a description of this standard PCIe register, see the PCI Express Base Specification 4.0.
            }
        }
        doc {
            Physical Layer 16.0 GT/s Extended Capability Structure
        }
    }
    block PF0_MARGIN_CAP @'h1a8 {
        bytes 4;
        register MARGIN_EXT_CAP_HDR_REG @'h0 {
            bytes 4;
            field EXTENDED_CAP_ID @'h0 {
                bits 16;
                access ro;
                hard_reset 'h0;
                doc {
                    PCI Express Extended Capability ID.
For a description of this standard PCIe register field, see the PCI Express Base Specification 4.0.

Note: The access attributes of this field are as follows:
 - Wire: R (sticky) 
 - Dbi: if (DBI_RO_WR_EN == 1) then R/W(sticky) else R(sticky) 
Note: This register field is sticky.
                }
            }
            field CAP_VERSION @'h10 {
                bits 4;
                access ro;
                hard_reset 'h0;
                doc {
                    Capability Version.
For a description of this standard PCIe register field, see the PCI Express Base Specification 4.0.

Note: The access attributes of this field are as follows:
 - Wire: R (sticky) 
 - Dbi: if (DBI_RO_WR_EN == 1) then R/W(sticky) else R(sticky) 
Note: This register field is sticky.
                }
            }
            field NEXT_OFFSET @'h14 {
                bits 12;
                access ro;
                hard_reset 'h0;
                doc {
                    Next Capability Offset.
For a description of this standard PCIe register field, see the PCI Express Base Specification 4.0.

Note: The access attributes of this field are as follows:
 - Wire: R (sticky) 
 - Dbi: if (DBI_RO_WR_EN == 1) then R/W(sticky) else R(sticky) 
Note: This register field is sticky.
                }
            }
            doc {
                Margining Extended Capability Header.
For a description of this standard PCIe register, see the PCI Express Base Specification 4.0.Margining Extended Capability Header.
For a description of this standard PCIe register, see the PCI Express Base Specification 4.0.
            }
        }
        register MARGIN_PORT_CAPABILITIES_STATUS_REG @'h4 {
            bytes 4;
            field MARGINING_USES_DRIVER_SOFTWARE @'h0 {
                access ro;
                hard_reset 'h0;
                doc {
                    Margining uses Driver Software.
For a description of this standard PCIe register, see the PCI Express Base Specification 4.0.

Note: The access attributes of this field are as follows:
 - Wire: R (sticky) 
 - Dbi: if (DBI_RO_WR_EN == 1) then R/W(sticky) else R(sticky) 
Note: This register field is sticky.
                }
            }
            field RSVDP_1 @'h1 {
                bits 15;
                access ro;
                hard_reset 'h0;
                soft_reset 'h0;
                doc {
                    Reserved for future use.
                }
            }
            field MARGINING_READY @'h10 {
                access ro;
                volatile 1
                hard_reset 'h0;
                doc {
                    Margining Ready.
For a description of this standard PCIe register, see the PCI Express Base Specification 4.0.
                }
            }
            field MARGINING_SOFTWARE_READY @'h11 {
                access ro;
                volatile 1
                hard_reset 'h0;
                doc {
                    Margining Software Ready.
For a description of this standard PCIe register, see the PCI Express Base Specification 4.0.
                }
            }
            field RSVDP_18 @'h12 {
                bits 14;
                access ro;
                hard_reset 'h0;
                soft_reset 'h0;
                doc {
                    Reserved for future use.
                }
            }
            doc {
                Margining Port Capabilities and Status Register.
For a description of this standard PCIe register, see the PCI Express Base Specification 4.0.Margining Port Capabilities and Status Register.
For a description of this standard PCIe register, see the PCI Express Base Specification 4.0.
            }
        }
        register MARGIN_LANE_CNTRL_STATUS0_REG @'h8 {
            bytes 4;
            field RECEIVER_NUMBER @'h0 {
                bits 3;
                access rw;
                hard_reset 'h0;
                doc {
                    Receiver Number for Lane 0.
For a description of this standard PCIe register field, see the PCI Express Base Specification 4.0.
                }
            }
            field MARGIN_TYPE @'h3 {
                bits 3;
                access rw;
                volatile 1
                hard_reset 'h0;
                doc {
                    Margin Type for Lane 0.
For a description of this standard PCIe register field, see the PCI Express Base Specification 4.0.
                }
            }
            field USAGE_MODEL @'h6 {
                access rw;
                volatile 1
                hard_reset 'h0;
                doc {
                    Usage Model for Lane 0.
For a description of this standard PCIe register field, see the PCI Express Base Specification 4.0.
                }
            }
            field RSVDP_7 @'h7 {
                access ro;
                hard_reset 'h0;
                soft_reset 'h0;
                doc {
                    Reserved for future use.
                }
            }
            field MARGIN_PAYLOAD @'h8 {
                bits 8;
                access rw;
                volatile 1
                hard_reset 'h0;
                doc {
                    Margin Payload for Lane 0.
For a description of this standard PCIe register field, see the PCI Express Base Specification 4.0.
                }
            }
            field RECEIVER_NUMBER_STATUS @'h10 {
                bits 3;
                access ro;
                volatile 1
                hard_reset 'h0;
                doc {
                    Receiver Number(Status) for Lane 0.
For a description of this standard PCIe register field, see the PCI Express Base Specification 4.0.
                }
            }
            field MARGIN_TYPE_STATUS @'h13 {
                bits 3;
                access ro;
                volatile 1
                hard_reset 'h0;
                doc {
                    Margin Type(Status) for Lane 0.
For a description of this standard PCIe register field, see the PCI Express Base Specification 4.0.
                }
            }
            field USAGE_MODEL_STATUS @'h16 {
                access ro;
                volatile 1
                hard_reset 'h0;
                doc {
                    Usage Model(Status) for Lane 0.
For a description of this standard PCIe register field, see the PCI Express Base Specification 4.0.
                }
            }
            field RSVDP_23 @'h17 {
                access ro;
                hard_reset 'h0;
                soft_reset 'h0;
                doc {
                    Reserved for future use.
                }
            }
            field MARGIN_PAYLOAD_STATUS @'h18 {
                bits 8;
                access ro;
                volatile 1
                hard_reset 'h0;
                doc {
                    Margin Payload(Status) for Lane 0.
For a description of this standard PCIe register field, see the PCI Express Base Specification 4.0.
                }
            }
            doc {
                Margining Lane Control and Status Register for Lane 0.
For a description of this standard PCIe register, see the PCI Express Base Specification 4.0.Margining Lane Control and Status Register for Lane 0.
For a description of this standard PCIe register, see the PCI Express Base Specification 4.0.
            }
        }
        register MARGIN_LANE_CNTRL_STATUS1_REG @'hc {
            bytes 4;
            field RECEIVER_NUMBER @'h0 {
                bits 3;
                access rw;
                hard_reset 'h0;
                doc {
                    Receiver Number for Lane 1.
For a description of this standard PCIe register field, see the PCI Express Base Specification 4.0.
                }
            }
            field MARGIN_TYPE @'h3 {
                bits 3;
                access rw;
                volatile 1
                hard_reset 'h0;
                doc {
                    Margin Type for Lane 1.
For a description of this standard PCIe register field, see the PCI Express Base Specification 4.0.
                }
            }
            field USAGE_MODEL @'h6 {
                access rw;
                volatile 1
                hard_reset 'h0;
                doc {
                    Usage Model for Lane 1.
For a description of this standard PCIe register field, see the PCI Express Base Specification 4.0.
                }
            }
            field RSVDP_7 @'h7 {
                access ro;
                hard_reset 'h0;
                soft_reset 'h0;
                doc {
                    Reserved for future use.
                }
            }
            field MARGIN_PAYLOAD @'h8 {
                bits 8;
                access rw;
                volatile 1
                hard_reset 'h0;
                doc {
                    Margin Payload for Lane 1.
For a description of this standard PCIe register field, see the PCI Express Base Specification 4.0.
                }
            }
            field RECEIVER_NUMBER_STATUS @'h10 {
                bits 3;
                access ro;
                volatile 1
                hard_reset 'h0;
                doc {
                    Receiver Number(Status) for Lane 1.
For a description of this standard PCIe register field, see the PCI Express Base Specification 4.0.
                }
            }
            field MARGIN_TYPE_STATUS @'h13 {
                bits 3;
                access ro;
                volatile 1
                hard_reset 'h0;
                doc {
                    Margin Type(Status) for Lane 1.
For a description of this standard PCIe register field, see the PCI Express Base Specification 4.0.
                }
            }
            field USAGE_MODEL_STATUS @'h16 {
                access ro;
                volatile 1
                hard_reset 'h0;
                doc {
                    Usage Model(Status) for Lane 1.
For a description of this standard PCIe register field, see the PCI Express Base Specification 4.0.
                }
            }
            field RSVDP_23 @'h17 {
                access ro;
                hard_reset 'h0;
                soft_reset 'h0;
                doc {
                    Reserved for future use.
                }
            }
            field MARGIN_PAYLOAD_STATUS @'h18 {
                bits 8;
                access ro;
                volatile 1
                hard_reset 'h0;
                doc {
                    Margin Payload(Status) for Lane 1.
For a description of this standard PCIe register field, see the PCI Express Base Specification 4.0.
                }
            }
            doc {
                Margining Lane Control and Status Register for Lane 1.
For a description of this standard PCIe register, see the PCI Express Base Specification 4.0.Margining Lane Control and Status Register for Lane 1.
For a description of this standard PCIe register, see the PCI Express Base Specification 4.0.
            }
        }
        register MARGIN_LANE_CNTRL_STATUS2_REG @'h10 {
            bytes 4;
            field RECEIVER_NUMBER @'h0 {
                bits 3;
                access rw;
                hard_reset 'h0;
                doc {
                    Receiver Number for Lane 2.
For a description of this standard PCIe register field, see the PCI Express Base Specification 4.0.
                }
            }
            field MARGIN_TYPE @'h3 {
                bits 3;
                access rw;
                volatile 1
                hard_reset 'h0;
                doc {
                    Margin Type for Lane 2.
For a description of this standard PCIe register field, see the PCI Express Base Specification 4.0.
                }
            }
            field USAGE_MODEL @'h6 {
                access rw;
                volatile 1
                hard_reset 'h0;
                doc {
                    Usage Model for Lane 2.
For a description of this standard PCIe register field, see the PCI Express Base Specification 4.0.
                }
            }
            field RSVDP_7 @'h7 {
                access ro;
                hard_reset 'h0;
                soft_reset 'h0;
                doc {
                    Reserved for future use.
                }
            }
            field MARGIN_PAYLOAD @'h8 {
                bits 8;
                access rw;
                volatile 1
                hard_reset 'h0;
                doc {
                    Margin Payload for Lane 2.
For a description of this standard PCIe register field, see the PCI Express Base Specification 4.0.
                }
            }
            field RECEIVER_NUMBER_STATUS @'h10 {
                bits 3;
                access ro;
                volatile 1
                hard_reset 'h0;
                doc {
                    Receiver Number(Status) for Lane 2.
For a description of this standard PCIe register field, see the PCI Express Base Specification 4.0.
                }
            }
            field MARGIN_TYPE_STATUS @'h13 {
                bits 3;
                access ro;
                volatile 1
                hard_reset 'h0;
                doc {
                    Margin Type(Status) for Lane 2.
For a description of this standard PCIe register field, see the PCI Express Base Specification 4.0.
                }
            }
            field USAGE_MODEL_STATUS @'h16 {
                access ro;
                volatile 1
                hard_reset 'h0;
                doc {
                    Usage Model(Status) for Lane 2.
For a description of this standard PCIe register field, see the PCI Express Base Specification 4.0.
                }
            }
            field RSVDP_23 @'h17 {
                access ro;
                hard_reset 'h0;
                soft_reset 'h0;
                doc {
                    Reserved for future use.
                }
            }
            field MARGIN_PAYLOAD_STATUS @'h18 {
                bits 8;
                access ro;
                volatile 1
                hard_reset 'h0;
                doc {
                    Margin Payload(Status) for Lane 2.
For a description of this standard PCIe register field, see the PCI Express Base Specification 4.0.
                }
            }
            doc {
                Margining Lane Control and Status Register for Lane 2.
For a description of this standard PCIe register, see the PCI Express Base Specification 4.0.Margining Lane Control and Status Register for Lane 2.
For a description of this standard PCIe register, see the PCI Express Base Specification 4.0.
            }
        }
        register MARGIN_LANE_CNTRL_STATUS3_REG @'h14 {
            bytes 4;
            field RECEIVER_NUMBER @'h0 {
                bits 3;
                access rw;
                hard_reset 'h0;
                doc {
                    Receiver Number for Lane 3.
For a description of this standard PCIe register field, see the PCI Express Base Specification 4.0.
                }
            }
            field MARGIN_TYPE @'h3 {
                bits 3;
                access rw;
                volatile 1
                hard_reset 'h0;
                doc {
                    Margin Type for Lane 3.
For a description of this standard PCIe register field, see the PCI Express Base Specification 4.0.
                }
            }
            field USAGE_MODEL @'h6 {
                access rw;
                volatile 1
                hard_reset 'h0;
                doc {
                    Usage Model for Lane 3.
For a description of this standard PCIe register field, see the PCI Express Base Specification 4.0.
                }
            }
            field RSVDP_7 @'h7 {
                access ro;
                hard_reset 'h0;
                soft_reset 'h0;
                doc {
                    Reserved for future use.
                }
            }
            field MARGIN_PAYLOAD @'h8 {
                bits 8;
                access rw;
                volatile 1
                hard_reset 'h0;
                doc {
                    Margin Payload for Lane 3.
For a description of this standard PCIe register field, see the PCI Express Base Specification 4.0.
                }
            }
            field RECEIVER_NUMBER_STATUS @'h10 {
                bits 3;
                access ro;
                volatile 1
                hard_reset 'h0;
                doc {
                    Receiver Number(Status) for Lane 3.
For a description of this standard PCIe register field, see the PCI Express Base Specification 4.0.
                }
            }
            field MARGIN_TYPE_STATUS @'h13 {
                bits 3;
                access ro;
                volatile 1
                hard_reset 'h0;
                doc {
                    Margin Type(Status) for Lane 3.
For a description of this standard PCIe register field, see the PCI Express Base Specification 4.0.
                }
            }
            field USAGE_MODEL_STATUS @'h16 {
                access ro;
                volatile 1
                hard_reset 'h0;
                doc {
                    Usage Model(Status) for Lane 3.
For a description of this standard PCIe register field, see the PCI Express Base Specification 4.0.
                }
            }
            field RSVDP_23 @'h17 {
                access ro;
                hard_reset 'h0;
                soft_reset 'h0;
                doc {
                    Reserved for future use.
                }
            }
            field MARGIN_PAYLOAD_STATUS @'h18 {
                bits 8;
                access ro;
                volatile 1
                hard_reset 'h0;
                doc {
                    Margin Payload(Status) for Lane 3.
For a description of this standard PCIe register field, see the PCI Express Base Specification 4.0.
                }
            }
            doc {
                Margining Lane Control and Status Register for Lane 3.
For a description of this standard PCIe register, see the PCI Express Base Specification 4.0.Margining Lane Control and Status Register for Lane 3.
For a description of this standard PCIe register, see the PCI Express Base Specification 4.0.
            }
        }
        register MARGIN_LANE_CNTRL_STATUS4_REG @'h18 {
            bytes 4;
            field RECEIVER_NUMBER @'h0 {
                bits 3;
                access rw;
                hard_reset 'h0;
                doc {
                    Receiver Number for Lane 4.
For a description of this standard PCIe register field, see the PCI Express Base Specification 4.0.
                }
            }
            field MARGIN_TYPE @'h3 {
                bits 3;
                access rw;
                volatile 1
                hard_reset 'h0;
                doc {
                    Margin Type for Lane 4.
For a description of this standard PCIe register field, see the PCI Express Base Specification 4.0.
                }
            }
            field USAGE_MODEL @'h6 {
                access rw;
                volatile 1
                hard_reset 'h0;
                doc {
                    Usage Model for Lane 4.
For a description of this standard PCIe register field, see the PCI Express Base Specification 4.0.
                }
            }
            field RSVDP_7 @'h7 {
                access ro;
                hard_reset 'h0;
                soft_reset 'h0;
                doc {
                    Reserved for future use.
                }
            }
            field MARGIN_PAYLOAD @'h8 {
                bits 8;
                access rw;
                volatile 1
                hard_reset 'h0;
                doc {
                    Margin Payload for Lane 4.
For a description of this standard PCIe register field, see the PCI Express Base Specification 4.0.
                }
            }
            field RECEIVER_NUMBER_STATUS @'h10 {
                bits 3;
                access ro;
                volatile 1
                hard_reset 'h0;
                doc {
                    Receiver Number(Status) for Lane 4.
For a description of this standard PCIe register field, see the PCI Express Base Specification 4.0.
                }
            }
            field MARGIN_TYPE_STATUS @'h13 {
                bits 3;
                access ro;
                volatile 1
                hard_reset 'h0;
                doc {
                    Margin Type(Status) for Lane 4.
For a description of this standard PCIe register field, see the PCI Express Base Specification 4.0.
                }
            }
            field USAGE_MODEL_STATUS @'h16 {
                access ro;
                volatile 1
                hard_reset 'h0;
                doc {
                    Usage Model(Status) for Lane 4.
For a description of this standard PCIe register field, see the PCI Express Base Specification 4.0.
                }
            }
            field RSVDP_23 @'h17 {
                access ro;
                hard_reset 'h0;
                soft_reset 'h0;
                doc {
                    Reserved for future use.
                }
            }
            field MARGIN_PAYLOAD_STATUS @'h18 {
                bits 8;
                access ro;
                volatile 1
                hard_reset 'h0;
                doc {
                    Margin Payload(Status) for Lane 4.
For a description of this standard PCIe register field, see the PCI Express Base Specification 4.0.
                }
            }
            doc {
                Margining Lane Control and Status Register for Lane 4.
For a description of this standard PCIe register, see the PCI Express Base Specification 4.0.Margining Lane Control and Status Register for Lane 4.
For a description of this standard PCIe register, see the PCI Express Base Specification 4.0.
            }
        }
        register MARGIN_LANE_CNTRL_STATUS5_REG @'h1c {
            bytes 4;
            field RECEIVER_NUMBER @'h0 {
                bits 3;
                access rw;
                hard_reset 'h0;
                doc {
                    Receiver Number for Lane 5.
For a description of this standard PCIe register field, see the PCI Express Base Specification 4.0.
                }
            }
            field MARGIN_TYPE @'h3 {
                bits 3;
                access rw;
                volatile 1
                hard_reset 'h0;
                doc {
                    Margin Type for Lane 5.
For a description of this standard PCIe register field, see the PCI Express Base Specification 4.0.
                }
            }
            field USAGE_MODEL @'h6 {
                access rw;
                volatile 1
                hard_reset 'h0;
                doc {
                    Usage Model for Lane 5.
For a description of this standard PCIe register field, see the PCI Express Base Specification 4.0.
                }
            }
            field RSVDP_7 @'h7 {
                access ro;
                hard_reset 'h0;
                soft_reset 'h0;
                doc {
                    Reserved for future use.
                }
            }
            field MARGIN_PAYLOAD @'h8 {
                bits 8;
                access rw;
                volatile 1
                hard_reset 'h0;
                doc {
                    Margin Payload for Lane 5.
For a description of this standard PCIe register field, see the PCI Express Base Specification 4.0.
                }
            }
            field RECEIVER_NUMBER_STATUS @'h10 {
                bits 3;
                access ro;
                volatile 1
                hard_reset 'h0;
                doc {
                    Receiver Number(Status) for Lane 5.
For a description of this standard PCIe register field, see the PCI Express Base Specification 4.0.
                }
            }
            field MARGIN_TYPE_STATUS @'h13 {
                bits 3;
                access ro;
                volatile 1
                hard_reset 'h0;
                doc {
                    Margin Type(Status) for Lane 5.
For a description of this standard PCIe register field, see the PCI Express Base Specification 4.0.
                }
            }
            field USAGE_MODEL_STATUS @'h16 {
                access ro;
                volatile 1
                hard_reset 'h0;
                doc {
                    Usage Model(Status) for Lane 5.
For a description of this standard PCIe register field, see the PCI Express Base Specification 4.0.
                }
            }
            field RSVDP_23 @'h17 {
                access ro;
                hard_reset 'h0;
                soft_reset 'h0;
                doc {
                    Reserved for future use.
                }
            }
            field MARGIN_PAYLOAD_STATUS @'h18 {
                bits 8;
                access ro;
                volatile 1
                hard_reset 'h0;
                doc {
                    Margin Payload(Status) for Lane 5.
For a description of this standard PCIe register field, see the PCI Express Base Specification 4.0.
                }
            }
            doc {
                Margining Lane Control and Status Register for Lane 5.
For a description of this standard PCIe register, see the PCI Express Base Specification 4.0.Margining Lane Control and Status Register for Lane 5.
For a description of this standard PCIe register, see the PCI Express Base Specification 4.0.
            }
        }
        register MARGIN_LANE_CNTRL_STATUS6_REG @'h20 {
            bytes 4;
            field RECEIVER_NUMBER @'h0 {
                bits 3;
                access rw;
                hard_reset 'h0;
                doc {
                    Receiver Number for Lane 6.
For a description of this standard PCIe register field, see the PCI Express Base Specification 4.0.
                }
            }
            field MARGIN_TYPE @'h3 {
                bits 3;
                access rw;
                volatile 1
                hard_reset 'h0;
                doc {
                    Margin Type for Lane 6.
For a description of this standard PCIe register field, see the PCI Express Base Specification 4.0.
                }
            }
            field USAGE_MODEL @'h6 {
                access rw;
                volatile 1
                hard_reset 'h0;
                doc {
                    Usage Model for Lane 6.
For a description of this standard PCIe register field, see the PCI Express Base Specification 4.0.
                }
            }
            field RSVDP_7 @'h7 {
                access ro;
                hard_reset 'h0;
                soft_reset 'h0;
                doc {
                    Reserved for future use.
                }
            }
            field MARGIN_PAYLOAD @'h8 {
                bits 8;
                access rw;
                volatile 1
                hard_reset 'h0;
                doc {
                    Margin Payload for Lane 6.
For a description of this standard PCIe register field, see the PCI Express Base Specification 4.0.
                }
            }
            field RECEIVER_NUMBER_STATUS @'h10 {
                bits 3;
                access ro;
                volatile 1
                hard_reset 'h0;
                doc {
                    Receiver Number(Status) for Lane 6.
For a description of this standard PCIe register field, see the PCI Express Base Specification 4.0.
                }
            }
            field MARGIN_TYPE_STATUS @'h13 {
                bits 3;
                access ro;
                volatile 1
                hard_reset 'h0;
                doc {
                    Margin Type(Status) for Lane 6.
For a description of this standard PCIe register field, see the PCI Express Base Specification 4.0.
                }
            }
            field USAGE_MODEL_STATUS @'h16 {
                access ro;
                volatile 1
                hard_reset 'h0;
                doc {
                    Usage Model(Status) for Lane 6.
For a description of this standard PCIe register field, see the PCI Express Base Specification 4.0.
                }
            }
            field RSVDP_23 @'h17 {
                access ro;
                hard_reset 'h0;
                soft_reset 'h0;
                doc {
                    Reserved for future use.
                }
            }
            field MARGIN_PAYLOAD_STATUS @'h18 {
                bits 8;
                access ro;
                volatile 1
                hard_reset 'h0;
                doc {
                    Margin Payload(Status) for Lane 6.
For a description of this standard PCIe register field, see the PCI Express Base Specification 4.0.
                }
            }
            doc {
                Margining Lane Control and Status Register for Lane 6.
For a description of this standard PCIe register, see the PCI Express Base Specification 4.0.Margining Lane Control and Status Register for Lane 6.
For a description of this standard PCIe register, see the PCI Express Base Specification 4.0.
            }
        }
        register MARGIN_LANE_CNTRL_STATUS7_REG @'h24 {
            bytes 4;
            field RECEIVER_NUMBER @'h0 {
                bits 3;
                access rw;
                hard_reset 'h0;
                doc {
                    Receiver Number for Lane 7.
For a description of this standard PCIe register field, see the PCI Express Base Specification 4.0.
                }
            }
            field MARGIN_TYPE @'h3 {
                bits 3;
                access rw;
                volatile 1
                hard_reset 'h0;
                doc {
                    Margin Type for Lane 7.
For a description of this standard PCIe register field, see the PCI Express Base Specification 4.0.
                }
            }
            field USAGE_MODEL @'h6 {
                access rw;
                volatile 1
                hard_reset 'h0;
                doc {
                    Usage Model for Lane 7.
For a description of this standard PCIe register field, see the PCI Express Base Specification 4.0.
                }
            }
            field RSVDP_7 @'h7 {
                access ro;
                hard_reset 'h0;
                soft_reset 'h0;
                doc {
                    Reserved for future use.
                }
            }
            field MARGIN_PAYLOAD @'h8 {
                bits 8;
                access rw;
                volatile 1
                hard_reset 'h0;
                doc {
                    Margin Payload for Lane 7.
For a description of this standard PCIe register field, see the PCI Express Base Specification 4.0.
                }
            }
            field RECEIVER_NUMBER_STATUS @'h10 {
                bits 3;
                access ro;
                volatile 1
                hard_reset 'h0;
                doc {
                    Receiver Number(Status) for Lane 7.
For a description of this standard PCIe register field, see the PCI Express Base Specification 4.0.
                }
            }
            field MARGIN_TYPE_STATUS @'h13 {
                bits 3;
                access ro;
                volatile 1
                hard_reset 'h0;
                doc {
                    Margin Type(Status) for Lane 7.
For a description of this standard PCIe register field, see the PCI Express Base Specification 4.0.
                }
            }
            field USAGE_MODEL_STATUS @'h16 {
                access ro;
                volatile 1
                hard_reset 'h0;
                doc {
                    Usage Model(Status) for Lane 7.
For a description of this standard PCIe register field, see the PCI Express Base Specification 4.0.
                }
            }
            field RSVDP_23 @'h17 {
                access ro;
                hard_reset 'h0;
                soft_reset 'h0;
                doc {
                    Reserved for future use.
                }
            }
            field MARGIN_PAYLOAD_STATUS @'h18 {
                bits 8;
                access ro;
                volatile 1
                hard_reset 'h0;
                doc {
                    Margin Payload(Status) for Lane 7.
For a description of this standard PCIe register field, see the PCI Express Base Specification 4.0.
                }
            }
            doc {
                Margining Lane Control and Status Register for Lane 7.
For a description of this standard PCIe register, see the PCI Express Base Specification 4.0.Margining Lane Control and Status Register for Lane 7.
For a description of this standard PCIe register, see the PCI Express Base Specification 4.0.
            }
        }
        register MARGIN_LANE_CNTRL_STATUS8_REG @'h28 {
            bytes 4;
            field RECEIVER_NUMBER @'h0 {
                bits 3;
                access rw;
                hard_reset 'h0;
                doc {
                    Receiver Number for Lane 8.
For a description of this standard PCIe register field, see the PCI Express Base Specification 4.0.
                }
            }
            field MARGIN_TYPE @'h3 {
                bits 3;
                access rw;
                volatile 1
                hard_reset 'h0;
                doc {
                    Margin Type for Lane 8.
For a description of this standard PCIe register field, see the PCI Express Base Specification 4.0.
                }
            }
            field USAGE_MODEL @'h6 {
                access rw;
                volatile 1
                hard_reset 'h0;
                doc {
                    Usage Model for Lane 8.
For a description of this standard PCIe register field, see the PCI Express Base Specification 4.0.
                }
            }
            field RSVDP_7 @'h7 {
                access ro;
                hard_reset 'h0;
                soft_reset 'h0;
                doc {
                    Reserved for future use.
                }
            }
            field MARGIN_PAYLOAD @'h8 {
                bits 8;
                access rw;
                volatile 1
                hard_reset 'h0;
                doc {
                    Margin Payload for Lane 8.
For a description of this standard PCIe register field, see the PCI Express Base Specification 4.0.
                }
            }
            field RECEIVER_NUMBER_STATUS @'h10 {
                bits 3;
                access ro;
                volatile 1
                hard_reset 'h0;
                doc {
                    Receiver Number(Status) for Lane 8.
For a description of this standard PCIe register field, see the PCI Express Base Specification 4.0.
                }
            }
            field MARGIN_TYPE_STATUS @'h13 {
                bits 3;
                access ro;
                volatile 1
                hard_reset 'h0;
                doc {
                    Margin Type(Status) for Lane 8.
For a description of this standard PCIe register field, see the PCI Express Base Specification 4.0.
                }
            }
            field USAGE_MODEL_STATUS @'h16 {
                access ro;
                volatile 1
                hard_reset 'h0;
                doc {
                    Usage Model(Status) for Lane 8.
For a description of this standard PCIe register field, see the PCI Express Base Specification 4.0.
                }
            }
            field RSVDP_23 @'h17 {
                access ro;
                hard_reset 'h0;
                soft_reset 'h0;
                doc {
                    Reserved for future use.
                }
            }
            field MARGIN_PAYLOAD_STATUS @'h18 {
                bits 8;
                access ro;
                volatile 1
                hard_reset 'h0;
                doc {
                    Margin Payload(Status) for Lane 8.
For a description of this standard PCIe register field, see the PCI Express Base Specification 4.0.
                }
            }
            doc {
                Margining Lane Control and Status Register for Lane 8.
For a description of this standard PCIe register, see the PCI Express Base Specification 4.0.Margining Lane Control and Status Register for Lane 8.
For a description of this standard PCIe register, see the PCI Express Base Specification 4.0.
            }
        }
        register MARGIN_LANE_CNTRL_STATUS9_REG @'h2c {
            bytes 4;
            field RECEIVER_NUMBER @'h0 {
                bits 3;
                access rw;
                hard_reset 'h0;
                doc {
                    Receiver Number for Lane 9.
For a description of this standard PCIe register field, see the PCI Express Base Specification 4.0.
                }
            }
            field MARGIN_TYPE @'h3 {
                bits 3;
                access rw;
                volatile 1
                hard_reset 'h0;
                doc {
                    Margin Type for Lane 9.
For a description of this standard PCIe register field, see the PCI Express Base Specification 4.0.
                }
            }
            field USAGE_MODEL @'h6 {
                access rw;
                volatile 1
                hard_reset 'h0;
                doc {
                    Usage Model for Lane 9.
For a description of this standard PCIe register field, see the PCI Express Base Specification 4.0.
                }
            }
            field RSVDP_7 @'h7 {
                access ro;
                hard_reset 'h0;
                soft_reset 'h0;
                doc {
                    Reserved for future use.
                }
            }
            field MARGIN_PAYLOAD @'h8 {
                bits 8;
                access rw;
                volatile 1
                hard_reset 'h0;
                doc {
                    Margin Payload for Lane 9.
For a description of this standard PCIe register field, see the PCI Express Base Specification 4.0.
                }
            }
            field RECEIVER_NUMBER_STATUS @'h10 {
                bits 3;
                access ro;
                volatile 1
                hard_reset 'h0;
                doc {
                    Receiver Number(Status) for Lane 9.
For a description of this standard PCIe register field, see the PCI Express Base Specification 4.0.
                }
            }
            field MARGIN_TYPE_STATUS @'h13 {
                bits 3;
                access ro;
                volatile 1
                hard_reset 'h0;
                doc {
                    Margin Type(Status) for Lane 9.
For a description of this standard PCIe register field, see the PCI Express Base Specification 4.0.
                }
            }
            field USAGE_MODEL_STATUS @'h16 {
                access ro;
                volatile 1
                hard_reset 'h0;
                doc {
                    Usage Model(Status) for Lane 9.
For a description of this standard PCIe register field, see the PCI Express Base Specification 4.0.
                }
            }
            field RSVDP_23 @'h17 {
                access ro;
                hard_reset 'h0;
                soft_reset 'h0;
                doc {
                    Reserved for future use.
                }
            }
            field MARGIN_PAYLOAD_STATUS @'h18 {
                bits 8;
                access ro;
                volatile 1
                hard_reset 'h0;
                doc {
                    Margin Payload(Status) for Lane 9.
For a description of this standard PCIe register field, see the PCI Express Base Specification 4.0.
                }
            }
            doc {
                Margining Lane Control and Status Register for Lane 9.
For a description of this standard PCIe register, see the PCI Express Base Specification 4.0.Margining Lane Control and Status Register for Lane 9.
For a description of this standard PCIe register, see the PCI Express Base Specification 4.0.
            }
        }
        register MARGIN_LANE_CNTRL_STATUS10_REG @'h30 {
            bytes 4;
            field RECEIVER_NUMBER @'h0 {
                bits 3;
                access rw;
                hard_reset 'h0;
                doc {
                    Receiver Number for Lane 10.
For a description of this standard PCIe register field, see the PCI Express Base Specification 4.0.
                }
            }
            field MARGIN_TYPE @'h3 {
                bits 3;
                access rw;
                volatile 1
                hard_reset 'h0;
                doc {
                    Margin Type for Lane 10.
For a description of this standard PCIe register field, see the PCI Express Base Specification 4.0.
                }
            }
            field USAGE_MODEL @'h6 {
                access rw;
                volatile 1
                hard_reset 'h0;
                doc {
                    Usage Model for Lane 10.
For a description of this standard PCIe register field, see the PCI Express Base Specification 4.0.
                }
            }
            field RSVDP_7 @'h7 {
                access ro;
                hard_reset 'h0;
                soft_reset 'h0;
                doc {
                    Reserved for future use.
                }
            }
            field MARGIN_PAYLOAD @'h8 {
                bits 8;
                access rw;
                volatile 1
                hard_reset 'h0;
                doc {
                    Margin Payload for Lane 10.
For a description of this standard PCIe register field, see the PCI Express Base Specification 4.0.
                }
            }
            field RECEIVER_NUMBER_STATUS @'h10 {
                bits 3;
                access ro;
                volatile 1
                hard_reset 'h0;
                doc {
                    Receiver Number(Status) for Lane 10.
For a description of this standard PCIe register field, see the PCI Express Base Specification 4.0.
                }
            }
            field MARGIN_TYPE_STATUS @'h13 {
                bits 3;
                access ro;
                volatile 1
                hard_reset 'h0;
                doc {
                    Margin Type(Status) for Lane 10.
For a description of this standard PCIe register field, see the PCI Express Base Specification 4.0.
                }
            }
            field USAGE_MODEL_STATUS @'h16 {
                access ro;
                volatile 1
                hard_reset 'h0;
                doc {
                    Usage Model(Status) for Lane 10.
For a description of this standard PCIe register field, see the PCI Express Base Specification 4.0.
                }
            }
            field RSVDP_23 @'h17 {
                access ro;
                hard_reset 'h0;
                soft_reset 'h0;
                doc {
                    Reserved for future use.
                }
            }
            field MARGIN_PAYLOAD_STATUS @'h18 {
                bits 8;
                access ro;
                volatile 1
                hard_reset 'h0;
                doc {
                    Margin Payload(Status) for Lane 10.
For a description of this standard PCIe register field, see the PCI Express Base Specification 4.0.
                }
            }
            doc {
                Margining Lane Control and Status Register for Lane 10.
For a description of this standard PCIe register, see the PCI Express Base Specification 4.0.Margining Lane Control and Status Register for Lane 10.
For a description of this standard PCIe register, see the PCI Express Base Specification 4.0.
            }
        }
        register MARGIN_LANE_CNTRL_STATUS11_REG @'h34 {
            bytes 4;
            field RECEIVER_NUMBER @'h0 {
                bits 3;
                access rw;
                hard_reset 'h0;
                doc {
                    Receiver Number for Lane 11.
For a description of this standard PCIe register field, see the PCI Express Base Specification 4.0.
                }
            }
            field MARGIN_TYPE @'h3 {
                bits 3;
                access rw;
                volatile 1
                hard_reset 'h0;
                doc {
                    Margin Type for Lane 11.
For a description of this standard PCIe register field, see the PCI Express Base Specification 4.0.
                }
            }
            field USAGE_MODEL @'h6 {
                access rw;
                volatile 1
                hard_reset 'h0;
                doc {
                    Usage Model for Lane 11.
For a description of this standard PCIe register field, see the PCI Express Base Specification 4.0.
                }
            }
            field RSVDP_7 @'h7 {
                access ro;
                hard_reset 'h0;
                soft_reset 'h0;
                doc {
                    Reserved for future use.
                }
            }
            field MARGIN_PAYLOAD @'h8 {
                bits 8;
                access rw;
                volatile 1
                hard_reset 'h0;
                doc {
                    Margin Payload for Lane 11.
For a description of this standard PCIe register field, see the PCI Express Base Specification 4.0.
                }
            }
            field RECEIVER_NUMBER_STATUS @'h10 {
                bits 3;
                access ro;
                volatile 1
                hard_reset 'h0;
                doc {
                    Receiver Number(Status) for Lane 11.
For a description of this standard PCIe register field, see the PCI Express Base Specification 4.0.
                }
            }
            field MARGIN_TYPE_STATUS @'h13 {
                bits 3;
                access ro;
                volatile 1
                hard_reset 'h0;
                doc {
                    Margin Type(Status) for Lane 11.
For a description of this standard PCIe register field, see the PCI Express Base Specification 4.0.
                }
            }
            field USAGE_MODEL_STATUS @'h16 {
                access ro;
                volatile 1
                hard_reset 'h0;
                doc {
                    Usage Model(Status) for Lane 11.
For a description of this standard PCIe register field, see the PCI Express Base Specification 4.0.
                }
            }
            field RSVDP_23 @'h17 {
                access ro;
                hard_reset 'h0;
                soft_reset 'h0;
                doc {
                    Reserved for future use.
                }
            }
            field MARGIN_PAYLOAD_STATUS @'h18 {
                bits 8;
                access ro;
                volatile 1
                hard_reset 'h0;
                doc {
                    Margin Payload(Status) for Lane 11.
For a description of this standard PCIe register field, see the PCI Express Base Specification 4.0.
                }
            }
            doc {
                Margining Lane Control and Status Register for Lane 11.
For a description of this standard PCIe register, see the PCI Express Base Specification 4.0.Margining Lane Control and Status Register for Lane 11.
For a description of this standard PCIe register, see the PCI Express Base Specification 4.0.
            }
        }
        register MARGIN_LANE_CNTRL_STATUS12_REG @'h38 {
            bytes 4;
            field RECEIVER_NUMBER @'h0 {
                bits 3;
                access rw;
                hard_reset 'h0;
                doc {
                    Receiver Number for Lane 12.
For a description of this standard PCIe register field, see the PCI Express Base Specification 4.0.
                }
            }
            field MARGIN_TYPE @'h3 {
                bits 3;
                access rw;
                volatile 1
                hard_reset 'h0;
                doc {
                    Margin Type for Lane 12.
For a description of this standard PCIe register field, see the PCI Express Base Specification 4.0.
                }
            }
            field USAGE_MODEL @'h6 {
                access rw;
                volatile 1
                hard_reset 'h0;
                doc {
                    Usage Model for Lane 12.
For a description of this standard PCIe register field, see the PCI Express Base Specification 4.0.
                }
            }
            field RSVDP_7 @'h7 {
                access ro;
                hard_reset 'h0;
                soft_reset 'h0;
                doc {
                    Reserved for future use.
                }
            }
            field MARGIN_PAYLOAD @'h8 {
                bits 8;
                access rw;
                volatile 1
                hard_reset 'h0;
                doc {
                    Margin Payload for Lane 12.
For a description of this standard PCIe register field, see the PCI Express Base Specification 4.0.
                }
            }
            field RECEIVER_NUMBER_STATUS @'h10 {
                bits 3;
                access ro;
                volatile 1
                hard_reset 'h0;
                doc {
                    Receiver Number(Status) for Lane 12.
For a description of this standard PCIe register field, see the PCI Express Base Specification 4.0.
                }
            }
            field MARGIN_TYPE_STATUS @'h13 {
                bits 3;
                access ro;
                volatile 1
                hard_reset 'h0;
                doc {
                    Margin Type(Status) for Lane 12.
For a description of this standard PCIe register field, see the PCI Express Base Specification 4.0.
                }
            }
            field USAGE_MODEL_STATUS @'h16 {
                access ro;
                volatile 1
                hard_reset 'h0;
                doc {
                    Usage Model(Status) for Lane 12.
For a description of this standard PCIe register field, see the PCI Express Base Specification 4.0.
                }
            }
            field RSVDP_23 @'h17 {
                access ro;
                hard_reset 'h0;
                soft_reset 'h0;
                doc {
                    Reserved for future use.
                }
            }
            field MARGIN_PAYLOAD_STATUS @'h18 {
                bits 8;
                access ro;
                volatile 1
                hard_reset 'h0;
                doc {
                    Margin Payload(Status) for Lane 12.
For a description of this standard PCIe register field, see the PCI Express Base Specification 4.0.
                }
            }
            doc {
                Margining Lane Control and Status Register for Lane 12.
For a description of this standard PCIe register, see the PCI Express Base Specification 4.0.Margining Lane Control and Status Register for Lane 12.
For a description of this standard PCIe register, see the PCI Express Base Specification 4.0.
            }
        }
        register MARGIN_LANE_CNTRL_STATUS13_REG @'h3c {
            bytes 4;
            field RECEIVER_NUMBER @'h0 {
                bits 3;
                access rw;
                hard_reset 'h0;
                doc {
                    Receiver Number for Lane 13.
For a description of this standard PCIe register field, see the PCI Express Base Specification 4.0.
                }
            }
            field MARGIN_TYPE @'h3 {
                bits 3;
                access rw;
                volatile 1
                hard_reset 'h0;
                doc {
                    Margin Type for Lane 13.
For a description of this standard PCIe register field, see the PCI Express Base Specification 4.0.
                }
            }
            field USAGE_MODEL @'h6 {
                access rw;
                volatile 1
                hard_reset 'h0;
                doc {
                    Usage Model for Lane 13.
For a description of this standard PCIe register field, see the PCI Express Base Specification 4.0.
                }
            }
            field RSVDP_7 @'h7 {
                access ro;
                hard_reset 'h0;
                soft_reset 'h0;
                doc {
                    Reserved for future use.
                }
            }
            field MARGIN_PAYLOAD @'h8 {
                bits 8;
                access rw;
                volatile 1
                hard_reset 'h0;
                doc {
                    Margin Payload for Lane 13.
For a description of this standard PCIe register field, see the PCI Express Base Specification 4.0.
                }
            }
            field RECEIVER_NUMBER_STATUS @'h10 {
                bits 3;
                access ro;
                volatile 1
                hard_reset 'h0;
                doc {
                    Receiver Number(Status) for Lane 13.
For a description of this standard PCIe register field, see the PCI Express Base Specification 4.0.
                }
            }
            field MARGIN_TYPE_STATUS @'h13 {
                bits 3;
                access ro;
                volatile 1
                hard_reset 'h0;
                doc {
                    Margin Type(Status) for Lane 13.
For a description of this standard PCIe register field, see the PCI Express Base Specification 4.0.
                }
            }
            field USAGE_MODEL_STATUS @'h16 {
                access ro;
                volatile 1
                hard_reset 'h0;
                doc {
                    Usage Model(Status) for Lane 13.
For a description of this standard PCIe register field, see the PCI Express Base Specification 4.0.
                }
            }
            field RSVDP_23 @'h17 {
                access ro;
                hard_reset 'h0;
                soft_reset 'h0;
                doc {
                    Reserved for future use.
                }
            }
            field MARGIN_PAYLOAD_STATUS @'h18 {
                bits 8;
                access ro;
                volatile 1
                hard_reset 'h0;
                doc {
                    Margin Payload(Status) for Lane 13.
For a description of this standard PCIe register field, see the PCI Express Base Specification 4.0.
                }
            }
            doc {
                Margining Lane Control and Status Register for Lane 13.
For a description of this standard PCIe register, see the PCI Express Base Specification 4.0.Margining Lane Control and Status Register for Lane 13.
For a description of this standard PCIe register, see the PCI Express Base Specification 4.0.
            }
        }
        register MARGIN_LANE_CNTRL_STATUS14_REG @'h40 {
            bytes 4;
            field RECEIVER_NUMBER @'h0 {
                bits 3;
                access rw;
                hard_reset 'h0;
                doc {
                    Receiver Number for Lane 14.
For a description of this standard PCIe register field, see the PCI Express Base Specification 4.0.
                }
            }
            field MARGIN_TYPE @'h3 {
                bits 3;
                access rw;
                volatile 1
                hard_reset 'h0;
                doc {
                    Margin Type for Lane 14.
For a description of this standard PCIe register field, see the PCI Express Base Specification 4.0.
                }
            }
            field USAGE_MODEL @'h6 {
                access rw;
                volatile 1
                hard_reset 'h0;
                doc {
                    Usage Model for Lane 14.
For a description of this standard PCIe register field, see the PCI Express Base Specification 4.0.
                }
            }
            field RSVDP_7 @'h7 {
                access ro;
                hard_reset 'h0;
                soft_reset 'h0;
                doc {
                    Reserved for future use.
                }
            }
            field MARGIN_PAYLOAD @'h8 {
                bits 8;
                access rw;
                volatile 1
                hard_reset 'h0;
                doc {
                    Margin Payload for Lane 14.
For a description of this standard PCIe register field, see the PCI Express Base Specification 4.0.
                }
            }
            field RECEIVER_NUMBER_STATUS @'h10 {
                bits 3;
                access ro;
                volatile 1
                hard_reset 'h0;
                doc {
                    Receiver Number(Status) for Lane 14.
For a description of this standard PCIe register field, see the PCI Express Base Specification 4.0.
                }
            }
            field MARGIN_TYPE_STATUS @'h13 {
                bits 3;
                access ro;
                volatile 1
                hard_reset 'h0;
                doc {
                    Margin Type(Status) for Lane 14.
For a description of this standard PCIe register field, see the PCI Express Base Specification 4.0.
                }
            }
            field USAGE_MODEL_STATUS @'h16 {
                access ro;
                volatile 1
                hard_reset 'h0;
                doc {
                    Usage Model(Status) for Lane 14.
For a description of this standard PCIe register field, see the PCI Express Base Specification 4.0.
                }
            }
            field RSVDP_23 @'h17 {
                access ro;
                hard_reset 'h0;
                soft_reset 'h0;
                doc {
                    Reserved for future use.
                }
            }
            field MARGIN_PAYLOAD_STATUS @'h18 {
                bits 8;
                access ro;
                volatile 1
                hard_reset 'h0;
                doc {
                    Margin Payload(Status) for Lane 14.
For a description of this standard PCIe register field, see the PCI Express Base Specification 4.0.
                }
            }
            doc {
                Margining Lane Control and Status Register for Lane 14.
For a description of this standard PCIe register, see the PCI Express Base Specification 4.0.Margining Lane Control and Status Register for Lane 14.
For a description of this standard PCIe register, see the PCI Express Base Specification 4.0.
            }
        }
        register MARGIN_LANE_CNTRL_STATUS15_REG @'h44 {
            bytes 4;
            field RECEIVER_NUMBER @'h0 {
                bits 3;
                access rw;
                hard_reset 'h0;
                doc {
                    Receiver Number for Lane 15.
For a description of this standard PCIe register field, see the PCI Express Base Specification 4.0.
                }
            }
            field MARGIN_TYPE @'h3 {
                bits 3;
                access rw;
                volatile 1
                hard_reset 'h0;
                doc {
                    Margin Type for Lane 15.
For a description of this standard PCIe register field, see the PCI Express Base Specification 4.0.
                }
            }
            field USAGE_MODEL @'h6 {
                access rw;
                volatile 1
                hard_reset 'h0;
                doc {
                    Usage Model for Lane 15.
For a description of this standard PCIe register field, see the PCI Express Base Specification 4.0.
                }
            }
            field RSVDP_7 @'h7 {
                access ro;
                hard_reset 'h0;
                soft_reset 'h0;
                doc {
                    Reserved for future use.
                }
            }
            field MARGIN_PAYLOAD @'h8 {
                bits 8;
                access rw;
                volatile 1
                hard_reset 'h0;
                doc {
                    Margin Payload for Lane 15.
For a description of this standard PCIe register field, see the PCI Express Base Specification 4.0.
                }
            }
            field RECEIVER_NUMBER_STATUS @'h10 {
                bits 3;
                access ro;
                volatile 1
                hard_reset 'h0;
                doc {
                    Receiver Number(Status) for Lane 15.
For a description of this standard PCIe register field, see the PCI Express Base Specification 4.0.
                }
            }
            field MARGIN_TYPE_STATUS @'h13 {
                bits 3;
                access ro;
                volatile 1
                hard_reset 'h0;
                doc {
                    Margin Type(Status) for Lane 15.
For a description of this standard PCIe register field, see the PCI Express Base Specification 4.0.
                }
            }
            field USAGE_MODEL_STATUS @'h16 {
                access ro;
                volatile 1
                hard_reset 'h0;
                doc {
                    Usage Model(Status) for Lane 15.
For a description of this standard PCIe register field, see the PCI Express Base Specification 4.0.
                }
            }
            field RSVDP_23 @'h17 {
                access ro;
                hard_reset 'h0;
                soft_reset 'h0;
                doc {
                    Reserved for future use.
                }
            }
            field MARGIN_PAYLOAD_STATUS @'h18 {
                bits 8;
                access ro;
                volatile 1
                hard_reset 'h0;
                doc {
                    Margin Payload(Status) for Lane 15.
For a description of this standard PCIe register field, see the PCI Express Base Specification 4.0.
                }
            }
            doc {
                Margining Lane Control and Status Register for Lane 15.
For a description of this standard PCIe register, see the PCI Express Base Specification 4.0.Margining Lane Control and Status Register for Lane 15.
For a description of this standard PCIe register, see the PCI Express Base Specification 4.0.
            }
        }
        doc {
            Margining Extended Capability Structure
        }
    }
    block PF0_RAS_DES_CAP @'h1fc {
        bytes 4;
        register RAS_DES_CAP_HEADER_REG @'h0 {
            bytes 4;
            field EXTENDED_CAP_ID @'h0 {
                bits 16;
                access ro;
                hard_reset 'h0;
                doc {
                    PCI Express Extended Capability ID.
For a description of this standard PCIe register field, see the PCI Express Specification.

Note: The access attributes of this field are as follows:
 - Wire: R (sticky) 
 - Dbi: if (DBI_RO_WR_EN == 1) then R/W(sticky) else R(sticky) 
Note: This register field is sticky.
                }
            }
            field CAP_VERSION @'h10 {
                bits 4;
                access ro;
                hard_reset 'h0;
                doc {
                    Capability Version.
For a description of this standard PCIe register field, see the PCI Express Specification.

Note: The access attributes of this field are as follows:
 - Wire: R (sticky) 
 - Dbi: if (DBI_RO_WR_EN == 1) then R/W(sticky) else R(sticky) 
Note: This register field is sticky.
                }
            }
            field NEXT_OFFSET @'h14 {
                bits 12;
                access ro;
                hard_reset 'h0;
                doc {
                    Next Capability Offset.
For a description of this standard PCIe register field, see the PCI Express Specification.

Note: The access attributes of this field are as follows:
 - Wire: R (sticky) 
 - Dbi: if (DBI_RO_WR_EN == 1) then R/W(sticky) else R(sticky) 
Note: This register field is sticky.
                }
            }
            doc {
                Vendor-Specific Extended Capability Header.
For a description of this standard PCIe register, see the PCI Express Specification.Vendor-Specific Extended Capability Header.
For a description of this standard PCIe register, see the PCI Express Specification.
            }
        }
        register VENDOR_SPECIFIC_HEADER_REG @'h4 {
            bytes 4;
            field VSEC_ID @'h0 {
                bits 16;
                access ro;
                hard_reset 'h0;
                doc {
                    VSEC ID.
For a description of this standard PCIe register field, see the PCI Express Specification.
                }
            }
            field VSEC_REV @'h10 {
                bits 4;
                access ro;
                hard_reset 'h0;
                doc {
                    VSEC Rev.
For a description of this standard PCIe register field, see the PCI Express Specification.
                }
            }
            field VSEC_LENGTH @'h14 {
                bits 12;
                access ro;
                hard_reset 'h0;
                doc {
                    VSEC Length.
For a description of this standard PCIe register field, see the PCI Express Specification.
                }
            }
            doc {
                Vendor-Specific Header.
For a description of this standard PCIe register, see the PCI Express Specification.Vendor-Specific Header.
For a description of this standard PCIe register, see the PCI Express Specification.
            }
        }
        register EVENT_COUNTER_CONTROL_REG @'h8 {
            bytes 4;
            field EVENT_COUNTER_CLEAR @'h0 {
                bits 2;
                access wo;
                volatile 1
                hard_reset 'h0;
                doc {
                    Event Counter Clear.
Clears the Event Counter selected by the EVENT_COUNTER_EVENT_SELECT and EVENT_COUNTER_LANE_SELECT fields in this register.
You can clear the value of a specific Event Counter by writing the 'per clear' code and you can clear all event counters at once by writing the 'all clear' code.
The read value is always '0'.
 - 00: no change
 - 01: per clear
 - 10: no change
 - 11: all clear
 - Other: reserved
                }
            }
            field EVENT_COUNTER_ENABLE @'h2 {
                bits 3;
                access wo;
                volatile 1
                hard_reset 'h0;
                doc {
                    Event Counter Enable.
Enables/disables the Event Counter selected by the EVENT_COUNTER_EVENT_SELECT and EVENT_COUNTER_LANE_SELECT fields in this register.
By default, all event counters are disabled.
You can enable/disable a specific Event Counter by writing the 'per event off' or 'per event on' codes.
You can enable/disable all event counters by writing the 'all on' or 'all off' codes.
The read value is always '0'.
 - 000: no change
 - 001: per event off
 - 010: no change
 - 011: per event on
 - 100: no change
 - 101: all off
 - 110: no change
 - 111: all on
                }
            }
            field RSVDP_5 @'h5 {
                bits 2;
                access ro;
                hard_reset 'h0;
                soft_reset 'h0;
                doc {
                    Reserved for future use.
                }
            }
            field EVENT_COUNTER_STATUS @'h7 {
                access ro;
                volatile 1
                hard_reset 'h0;
                doc {
                    Event Counter Status.
This register returns the current value of the Event Counter selected by the following fields:
 - EVENT_COUNTER_EVENT_SELECT
 - EVENT_COUNTER_LANE_SELECT
Note: This register field is sticky.
                }
            }
            field EVENT_COUNTER_LANE_SELECT @'h8 {
                bits 4;
                access rw;
                hard_reset 'h0;
                doc {
                    Event Counter Lane Select.
This field in conjunction with EVENT_COUNTER_EVENT_SELECT indexes the Event Counter data returned by the EVENT_COUNTER_DATA_REG register.
 - 0x0: Lane0
 - 0x1: Lane1
 - 0x2: Lane2
 - ..
 - 0xF: Lane15
Note: This register field is sticky.
                }
            }
            field RSVDP_12 @'hc {
                bits 4;
                access ro;
                hard_reset 'h0;
                soft_reset 'h0;
                doc {
                    Reserved for future use.
                }
            }
            field EVENT_COUNTER_EVENT_SELECT @'h10 {
                bits 12;
                access rw;
                hard_reset 'h0;
                doc {
                    Event Counter Data Select.
This field in conjunction with the EVENT_COUNTER_LANE_SELECT field indexes the Event Counter data returned by the EVENT_COUNTER_DATA_REG register.
 - 27-24: Group number(4-bit: 0..0x7)
 - 23-16: Event number(8-bit: 0..0x13) within the Group
For example:
 - 0x000: Ebuf Overflow
 - 0x001: Ebuf Underrun
 - ..
 - 0x700: Tx Memory Write
 - 0x713: Rx Message TLP
For detailed definitions of Group number and Event number, see the RAS DES chapter in the Databook.

Note: This register field is sticky.
                }
            }
            field RSVDP_28 @'h1c {
                bits 4;
                access ro;
                hard_reset 'h0;
                soft_reset 'h0;
                doc {
                    Reserved for future use.
                }
            }
            doc {
                Event Counter Control.
This is a viewport control register.
 - Setting the EVENT_COUNTER_EVENT_SELECT and EVENT_COUNTER_LANE_SELECT fields in this register determine the Event Counter data returned by the EVENT_COUNTER_DATA_REG viewport register.
 - Setting the EVENT_COUNTER_ENABLE field in this register enables the Event Counter selected by the EVENT_COUNTER_EVENT_SELECT and EVENT_COUNTER_LANE_SELECT fields in this register.
 - Setting the EVENT_COUNTER_CLEAR field in this register clears the Event Counter selected by the EVENT_COUNTER_EVENT_SELECT and EVENT_COUNTER_LANE_SELECT fields in this register.
 - Reading the EVENT_COUNTER_STATUS field in this register returns the Enable status of the Event Counter selected by the EVENT_COUNTER_EVENT_SELECT and EVENT_COUNTER_LANE_SELECT fields in this register.Event Counter Control.
This is a viewport control register.
 - Setting the EVENT_COUNTER_EVENT_SELECT and EVENT_COUNTER_LANE_SELECT fields in this register determine the Event Counter data returned by the EVENT_COUNTER_DATA_REG viewport register.
 - Setting the EVENT_COUNTER_ENABLE field in this register enables the Event Counter selected by the EVENT_COUNTER_EVENT_SELECT and EVENT_COUNTER_LANE_SELECT fields in this register.
 - Setting the EVENT_COUNTER_CLEAR field in this register clears the Event Counter selected by the EVENT_COUNTER_EVENT_SELECT and EVENT_COUNTER_LANE_SELECT fields in this register.
 - Reading the EVENT_COUNTER_STATUS field in this register returns the Enable status of the Event Counter selected by the EVENT_COUNTER_EVENT_SELECT and EVENT_COUNTER_LANE_SELECT fields in this register.
            }
        }
        register EVENT_COUNTER_DATA_REG @'hc {
            bytes 4;
            field EVENT_COUNTER_DATA @'h0 {
                bits 32;
                access ro;
                volatile 1
                hard_reset 'h0;
                doc {
                    Event Counter Data.
This register returns the data selected by the following fields:
 - EVENT_COUNTER_EVENT_SELECT in EVENT_COUNTER_CONTROL_REG
 - EVENT_COUNTER_LANE_SELECT in EVENT_COUNTER_CONTROL_REG
Note: This register field is sticky.
                }
            }
            doc {
                Event Counter Data.
This viewport register returns the data selected by the following fields:
 - EVENT_COUNTER_EVENT_SELECT in EVENT_COUNTER_CONTROL_REG
 - EVENT_COUNTER_LANE_SELECT in EVENT_COUNTER_CONTROL_REG
For more details, see the RAS DES section in the Core Operations chapter of the Databook.Event Counter Data.
This viewport register returns the data selected by the following fields:
 - EVENT_COUNTER_EVENT_SELECT in EVENT_COUNTER_CONTROL_REG
 - EVENT_COUNTER_LANE_SELECT in EVENT_COUNTER_CONTROL_REG
For more details, see the RAS DES section in the Core Operations chapter of the Databook.
            }
        }
        register TIME_BASED_ANALYSIS_CONTROL_REG @'h10 {
            bytes 4;
            field TIMER_START @'h0 {
                access rw;
                volatile 1
                hard_reset 'h0;
                doc {
                    Timer Start.
 - 1: Start/Restart
 - 0: Stop
This bit will be cleared automatically when the measurement is finished.
Note: The app_ras_des_tba_ctrl input also sets the contents of this field and controls the measurement start/stop.

Note: This register field is sticky.
                }
            }
            field RSVDP_1 @'h1 {
                bits 7;
                access ro;
                hard_reset 'h0;
                soft_reset 'h0;
                doc {
                    Reserved for future use.
                }
            }
            field TIME_BASED_DURATION_SELECT @'h8 {
                bits 8;
                access rw;
                hard_reset 'h0;
                doc {
                    Time-based Duration Select.
Selects the duration of time-based analysis.
When "manual control" is selected and TIMER_START is set to '1', this analysis never stops until TIMER_STOP is set to '0'.
 - 0x0: Manual control
 - 0x1: 1ms
 - 0x2: 10ms
 - 0x3: 100ms
 - 0x4: 1s
 - 0x5: 2s
 - 0x6: 4s
 - Else: Reserved
Note: This register field is sticky.
                }
            }
            field RSVDP_16 @'h10 {
                bits 8;
                access ro;
                hard_reset 'h0;
                soft_reset 'h0;
                doc {
                    Reserved for future use.
                }
            }
            field TIME_BASED_REPORT_SELECT @'h18 {
                bits 8;
                access rw;
                hard_reset 'h0;
                doc {
                    Time-based Report Select.
Selects what type of data is measured for the selected duration (TIME_BASED_DURATION_SELECT), and returned in TIME_BASED_ANALYSIS_DATA.
Each type of data is measured using one of three types of units:
 - Core_clk Cycles. Total time in ps is [Value of TIME_BASED_ANALYSIS_DATA returned when TIME_BASED_REPORT_SELECT=0x00] * TIME_BASED_ANALYSIS_DATA
 - Aux_clk Cycles. Total time in ps is [Period of platform specific clock] * TIME_BASED_ANALYSIS_DATA
 - Data Bytes. Actual amount of bytes is 16 * TIME_BASED_ANALYSIS_DATA
Core_clk Cycles
 - 0x00: Duration of 1 cycle
 - 0x01: TxL0s
 - 0x02: RxL0s
 - 0x03: L0
 - 0x04: L1 (Rsvd when aux_clk is supplied from the platform specific clock during L1, L1.1 or L1.2)
 - 0x07: Configuration/Recovery
Aux_clk Cycles
 - 0x05: L1.1
 - 0x06: L1.2
Data Bytes
 - 0x20: Tx TLP data payload Bytes
 - 0x21: Rx TLP data payload Bytes
 - Else: Rsvd
Note: This register field is sticky.
                }
            }
            doc {
                Time-based Analysis Control. Used for controlling the measurement of RX/TX data throughput and time spent in each low-power LTSSM state.
For more details, see the RAS DES section in the Core Operations chapter of the Databook.Time-based Analysis Control. Used for controlling the measurement of RX/TX data throughput and time spent in each low-power LTSSM state.
For more details, see the RAS DES section in the Core Operations chapter of the Databook.
            }
        }
        register TIME_BASED_ANALYSIS_DATA_REG @'h14 {
            bytes 4;
            field TIME_BASED_ANALYSIS_DATA @'h0 {
                bits 32;
                access ro;
                volatile 1
                hard_reset 'h0;
                doc {
                    Time Based Analysis Data.
This register returns the data selected by the TIME_BASED_REPORT_SELECT field in TIME_BASED_ANALYSIS_CONTROL_REG.
The results are cleared when next measurement starts.

Note: This register field is sticky.
                }
            }
            doc {
                Time-based Analysis Data. Contains the measurement results of RX/TX data throughput and time spent in each low-power LTSSM state.
This viewport register returns the data selected by the TIME_BASED_REPORT_SELECT field in TIME_BASED_ANALYSIS_CONTROL_REG
For more details, see the RAS DES section in the Core Operations chapter of the Databook.Time-based Analysis Data. Contains the measurement results of RX/TX data throughput and time spent in each low-power LTSSM state.
This viewport register returns the data selected by the TIME_BASED_REPORT_SELECT field in TIME_BASED_ANALYSIS_CONTROL_REG
For more details, see the RAS DES section in the Core Operations chapter of the Databook.
            }
        }
        register EINJ_ENABLE_REG @'h30 {
            bytes 4;
            field ERROR_INJECTION0_ENABLE @'h0 {
                access rw;
                volatile 1
                hard_reset 'h0;
                doc {
                    Error Injection0 Enable (CRC Error).

Enables insertion of errors into various CRC.

For more details, see the EINJ0_CRC_REG register.

Note: This register field is sticky.
                }
            }
            field ERROR_INJECTION1_ENABLE @'h1 {
                access rw;
                volatile 1
                hard_reset 'h0;
                doc {
                    Error Injection1 Enable (Sequence Number Error).

Enables insertion of errors into sequence numbers.

For more details, see the EINJ1_SEQNUM_REG register.

Note: This register field is sticky.
                }
            }
            field ERROR_INJECTION2_ENABLE @'h2 {
                access rw;
                volatile 1
                hard_reset 'h0;
                doc {
                    Error Injection2 Enable (DLLP Error).

Enables insertion of DLLP errors.

For more details, see the EINJ2_DLLP_REG register.

Note: This register field is sticky.
                }
            }
            field ERROR_INJECTION3_ENABLE @'h3 {
                access rw;
                volatile 1
                hard_reset 'h0;
                doc {
                    Error Injection3 Enable (Symbol DataK Mask Error or Sync Header Error).

Enables DataK masking of special symbols or the breaking of the sync header.

For more details, see the EINJ3_SYMBOL_REG register.

Note: This register field is sticky.
                }
            }
            field ERROR_INJECTION4_ENABLE @'h4 {
                access rw;
                volatile 1
                hard_reset 'h0;
                doc {
                    Error Injection4 Enable (FC Credit Update Error).

Enables insertion of errors into UpdateFCs.

For more details, see the EINJ4_FC_REG register.

Note: This register field is sticky.
                }
            }
            field ERROR_INJECTION5_ENABLE @'h5 {
                access rw;
                volatile 1
                hard_reset 'h0;
                doc {
                    Error Injection5 Enable (TLP Duplicate/Nullify Error).

Enables insertion of duplicate/nullified TLPs.

For more details, see the EINJ5_SP_TLP_REG register.

Note: This register field is sticky.
                }
            }
            field ERROR_INJECTION6_ENABLE @'h6 {
                access rw;
                volatile 1
                hard_reset 'h0;
                doc {
                    Error Injection6 Enable (Specific TLP Error).
Enables insertion of errors into the packets that you select.

You can set this bit to '1' when you have disabled RAS datapath protection (DP) by setting CX_RASDP = CX_RASDP_RAM_PROT =0.

You can set this bit to '1' when you have disabled the address translation by setting ADDR_TRANSLATION_SUPPORT_EN=0.
For more details, see the EINJ6_COMPARE_*_REG/EINJ6_CHANGE_*_REG/EINJ6_TLP_REG registers.

Note: This register field is sticky.
                }
            }
            field RSVDP_7 @'h7 {
                bits 25;
                access ro;
                hard_reset 'h0;
                soft_reset 'h0;
                doc {
                    Reserved for future use.
                }
            }
            doc {
                Error Injection Enable.
Each type of error insertion is enabled by the corresponding bit in this register. The specific injection controls for each type of error are defined in the following registers:
 - 0: CRC Error: EINJ0_CRC_REG
 - 1: Sequence Number Error: EINJ1_SEQNUM_REG
 - 2: DLLP Error: EINJ2_DLLP_REG 
 - 3: Symbol DataK Mask Error or Sync Header Error: EINJ3_SYMBOL_REG
 - 4: FC Credit Update Error: EINJ4_FC_REG
 - 5: TLP Duplicate/Nullify Error: EINJ5_SP_TLP_REG
 - 6: Specific TLP Error: EINJ6_COMPARE_*_REG/EINJ6_CHANGE_*_REG/EINJ6_TLP_REG
After the errors have been inserted by controller, it will clear each bit here.
For more details, see the RAS DES section in the Core Operations chapter of the Databook.Error Injection Enable.
Each type of error insertion is enabled by the corresponding bit in this register. The specific injection controls for each type of error are defined in the following registers:
 - 0: CRC Error: EINJ0_CRC_REG
 - 1: Sequence Number Error: EINJ1_SEQNUM_REG
 - 2: DLLP Error: EINJ2_DLLP_REG 
 - 3: Symbol DataK Mask Error or Sync Header Error: EINJ3_SYMBOL_REG
 - 4: FC Credit Update Error: EINJ4_FC_REG
 - 5: TLP Duplicate/Nullify Error: EINJ5_SP_TLP_REG
 - 6: Specific TLP Error: EINJ6_COMPARE_*_REG/EINJ6_CHANGE_*_REG/EINJ6_TLP_REG
After the errors have been inserted by controller, it will clear each bit here.
For more details, see the RAS DES section in the Core Operations chapter of the Databook.
            }
        }
        register EINJ0_CRC_REG @'h34 {
            bytes 4;
            field EINJ0_COUNT @'h0 {
                bits 8;
                access rw;
                volatile 1
                hard_reset 'h0;
                doc {
                    Error injection count.
Indicates the number of errors.
This register is decremented when the errors have been inserted.
 - If the counter value is 0x01 and error is inserted, ERROR_INJECTION0_ENABLE in EINJ_ENABLE_REG returns 0b.
 - If the counter value is 0x00 and ERROR_INJECTION0_ENABLE=1, the errors are inserted until ERROR_INJECTION0_ENABLE is set to '0'. 
Note: This register field is sticky.
                }
            }
            field EINJ0_CRC_TYPE @'h8 {
                bits 4;
                access rw;
                hard_reset 'h0;
                doc {
                    Error injection type.
Selects the type of CRC error to be inserted.

Tx Path
 - 0000b: New TLP's LCRC error injection
 - 0001b: 16bCRC error injection of ACK/NAK DLLP
 - 0010b: 16bCRC error injection of Update-FC DLLP
 - 0011b: New TLP's ECRC error injection
 - 0100b: TLP's FCRC error injection (128b/130b)
 - 0101b: Parity error of TSOS (128b/130b)
 - 0110b: Parity error of SKPOS (128b/130b)
Rx Path
 - 1000b: LCRC error injection
 - 1011b: ECRC error injection
 - Others: Reserved
Note: This register field is sticky.
                }
            }
            field RSVDP_12 @'hc {
                bits 20;
                access ro;
                hard_reset 'h0;
                soft_reset 'h0;
                doc {
                    Reserved for future use.
                }
            }
            doc {
                Error Injection Control 0 (CRC Error).
Controls the insertion of errors into the CRC, and parity of ordered sets for the selected type of the packets as follows:
 - LCRC. Bad TLP will be detected at the receiver side; receiver responds with NAK DLLP; Data Link Retry starts.
 - 16-bit CRC of ACK/NAK DLLPs. Bad DLLP occurs at the receiver side; Replay NUM Rollover occurs.
 - 16-bit CRC of UpdateFC DLLPs. Error insertion continues for the specific time; LTSSM transitions to the Recovery state because of the UpdateFC timeout (if the timeout is implemented at the receiver of the UpdateFCs).
 - ECRC. If ECRC check is enabled, ECRC error is detected at the receiver side.
 - FCRC. Framing error will be detected, TLP is discarded, and the LTSSM transitions to Recovery state.
 - Parity of TSOS. Error insertion continues for the specific time; LTSSM Recovery/Configuration timeout will occur.
 - Parity of SKPOS. Lane error will be detected at the receiver side.Error Injection Control 0 (CRC Error).
Controls the insertion of errors into the CRC, and parity of ordered sets for the selected type of the packets as follows:
 - LCRC. Bad TLP will be detected at the receiver side; receiver responds with NAK DLLP; Data Link Retry starts.
 - 16-bit CRC of ACK/NAK DLLPs. Bad DLLP occurs at the receiver side; Replay NUM Rollover occurs.
 - 16-bit CRC of UpdateFC DLLPs. Error insertion continues for the specific time; LTSSM transitions to the Recovery state because of the UpdateFC timeout (if the timeout is implemented at the receiver of the UpdateFCs).
 - ECRC. If ECRC check is enabled, ECRC error is detected at the receiver side.
 - FCRC. Framing error will be detected, TLP is discarded, and the LTSSM transitions to Recovery state.
 - Parity of TSOS. Error insertion continues for the specific time; LTSSM Recovery/Configuration timeout will occur.
 - Parity of SKPOS. Lane error will be detected at the receiver side.
            }
        }
        register EINJ1_SEQNUM_REG @'h38 {
            bytes 4;
            field EINJ1_COUNT @'h0 {
                bits 8;
                access rw;
                volatile 1
                hard_reset 'h0;
                doc {
                    Error injection count.
Indicates the number of errors.
This register is decremented as the errors are being inserted.
 - If the counter value is 0x01 and error is inserted, ERROR_INJECTION1_ENABLE in EINJ_ENABLE_REG returns '0'.
 - If the counter value is 0x00 and ERROR_INJECTION1_ENABLE=1, the errors are inserted until ERROR_INJECTION1_ENABLE is set to '0'. 
Note: This register field is sticky.
                }
            }
            field EINJ1_SEQNUM_TYPE @'h8 {
                access rw;
                hard_reset 'h0;
                doc {
                    Sequence number type.
Selects the type of sequence number.
 - 0b: Insertion of New TLP's SEQ  error
 - 1b: Insertion of ACK/NAK DLLP's SEQ  Error
Note: This register field is sticky.
                }
            }
            field RSVDP_9 @'h9 {
                bits 7;
                access ro;
                hard_reset 'h0;
                soft_reset 'h0;
                doc {
                    Reserved for future use.
                }
            }
            field EINJ1_BAD_SEQNUM @'h10 {
                bits 13;
                access rw;
                hard_reset 'h0;
                doc {
                    Bad sequence number.
Indicates the value to add/subtract from the naturally-assigned sequence numbers. This value is represented by two's complement.
 - 0x0FFF: +4095
 - ..
 - 0x0002: +2
 - 0x0001: +1
 - 0x0000: 0
 - 0x1FFF: -1
 - 0x1FFE: -2
 - ..
 - 0x1001: -4095
For example:
 - Set Type, SEQ  and Count
 -- EINJ1_SEQNUM_TYPE =0 (Insert errors into new TLPs)
 -- EINJ1_BAD_SEQNUM =0x1FFD (represents -3)
 -- EINJ1_COUNT =1
 - Enable Error Injection
 -- ERROR_INJECTION1_ENABLE =1
 - Send a TLP From the Core's Application Interface
 -- Assume SEQ 5 is given to the TLP.
 - The SEQ  is Changed to  2 by the Error Injection Function in Layer2.
 -- 5 + (-3) = 2
 - The TLP with SEQ 2 is Transmitted to PCIe Link.
Note: This register field is sticky.
                }
            }
            field RSVDP_29 @'h1d {
                bits 3;
                access ro;
                hard_reset 'h0;
                soft_reset 'h0;
                doc {
                    Reserved for future use.
                }
            }
            doc {
                Error Injection Control 1 (Sequence Number Error).

Controls the sequence number of the specific TLPs and ACK/NAK DLLPs.
Data Link Protocol Error will be detected at the Rx side of ACK/NAL DLLPs when one of these conditions is true:
 - ((NEXT_TRANSMIT_SEQ -1) - AckNak_Seq_Num) mod 4096 > 2048
 - (AckNak_Seq_Num - ACKD_SEQ) mod 4096 >= 2048
TLP is treated as Duplicate TLP at the Rx side when all these conditions are true:
 - Sequence Number != NEXT_RCV_SEQ
 - (NEXT_RCV_SEQ - Sequence Number) mod 4096 <= 2048
TLP is treated as Bad TLP at the Rx side when all these conditions are true:
 - Sequence Number != NEXT_RCV_SEQ and
 - (NEXT_RCV_SEQ - Sequence Number) mod 4096 > 2048Error Injection Control 1 (Sequence Number Error).

Controls the sequence number of the specific TLPs and ACK/NAK DLLPs.
Data Link Protocol Error will be detected at the Rx side of ACK/NAL DLLPs when one of these conditions is true:
 - ((NEXT_TRANSMIT_SEQ -1) - AckNak_Seq_Num) mod 4096 > 2048
 - (AckNak_Seq_Num - ACKD_SEQ) mod 4096 >= 2048
TLP is treated as Duplicate TLP at the Rx side when all these conditions are true:
 - Sequence Number != NEXT_RCV_SEQ
 - (NEXT_RCV_SEQ - Sequence Number) mod 4096 <= 2048
TLP is treated as Bad TLP at the Rx side when all these conditions are true:
 - Sequence Number != NEXT_RCV_SEQ and
 - (NEXT_RCV_SEQ - Sequence Number) mod 4096 > 2048
            }
        }
        register EINJ2_DLLP_REG @'h3c {
            bytes 4;
            field EINJ2_COUNT @'h0 {
                bits 8;
                access rw;
                volatile 1
                hard_reset 'h0;
                doc {
                    Error injection count.
Indicates the number of errors.
This register is decremented as the errors are being inserted.
 - If the counter value is 0x01 and the error is inserted, ERROR_INJECTION2_ENABLE in EINJ_ENABLE_REG returns '0'.
 - If the counter value is 0x00 and ERROR_INJECTION2_ENABLE =1, the errors are inserted until ERROR_INJECTION2_ENABLE is set to '0'.
This register is affected only when EINJ2_DLLP_TYPE =2'10b.

Note: This register field is sticky.
                }
            }
            field EINJ2_DLLP_TYPE @'h8 {
                bits 2;
                access rw;
                hard_reset 'h0;
                doc {
                    DLLP Type.
Selects the type of DLLP errors to be inserted.
 - 00b: ACK/NAK DLLP's transmission block
 - 01b: Update FC DLLP's transmission block
 - 10b: Always Transmission for NAK DLLP
 - 11b: Reserved
Note: This register field is sticky.
                }
            }
            field RSVDP_10 @'ha {
                bits 22;
                access ro;
                hard_reset 'h0;
                soft_reset 'h0;
                doc {
                    Reserved for future use.
                }
            }
            doc {
                Error Injection Control 2 (DLLP Error).
Controls the transmission of DLLPs and inserts the following errors:
 - If "ACK/NAK DLLP's transmission block" is selected, replay timeout error will occur at the transmitter of the TLPs and then Data Link Retry will occur.
 - If "Update FC DLLP's transmission block" is selected, LTSSM will transition to the Recovery state because of the UpdateFC timeout (if the timeout is implemented at the receiver of the UpdateFCs).
 - If "Always Transmission for NAK DLLP" is selected, Data Link Retry will occur at the transmitter of the TLPs. Furthermore, Replay NUM Rollover will occur when the transmitter has been requested four times to send the TLP with the same sequence number.Error Injection Control 2 (DLLP Error).
Controls the transmission of DLLPs and inserts the following errors:
 - If "ACK/NAK DLLP's transmission block" is selected, replay timeout error will occur at the transmitter of the TLPs and then Data Link Retry will occur.
 - If "Update FC DLLP's transmission block" is selected, LTSSM will transition to the Recovery state because of the UpdateFC timeout (if the timeout is implemented at the receiver of the UpdateFCs).
 - If "Always Transmission for NAK DLLP" is selected, Data Link Retry will occur at the transmitter of the TLPs. Furthermore, Replay NUM Rollover will occur when the transmitter has been requested four times to send the TLP with the same sequence number.
            }
        }
        register EINJ3_SYMBOL_REG @'h40 {
            bytes 4;
            field EINJ3_COUNT @'h0 {
                bits 8;
                access rw;
                volatile 1
                hard_reset 'h0;
                doc {
                    Error injection count.
Indicates the number of errors.
This register is decremented as the errors are being inserted.
 - If the counter value is 0x01 and error is inserted, ERROR_INJECTION3_ENABLE in EINJ_ENABLE_REG returns '0'.
 - If the counter value is 0x00 and ERROR_INJECTION3_ENABLE =1, the errors are inserted until ERROR_INJECTION3_ENABLE is set to '0'. 
Note: This register field is sticky.
                }
            }
            field EINJ3_SYMBOL_TYPE @'h8 {
                bits 3;
                access rw;
                hard_reset 'h0;
                doc {
                    Error Type.
8b/10b encoding - Mask K symbol. It is not supported to insert errors into the first ordered-set after exiting from TxElecIdle when CX_FREQ_STEP_EN has been enabled.
 - 000b: Reserved
 - 001b: COM/PAD(TS1 Order set)
 - 010b: COM/PAD(TS2 Order set)
 - 011b: COM/FTS(FTS Order set)
 - 100b: COM/IDL(E-Idle Order set)
 - 101b: END/EDB Symbol
 - 110b: STP/SDP Symbol
 - 111b: COM/SKP(SKP Order set)
128b/130b encoding - Change sync header.
 - 000b: Invert sync header
 - Others: Reserved
Note: This register field is sticky.
                }
            }
            field RSVDP_11 @'hb {
                bits 21;
                access ro;
                hard_reset 'h0;
                soft_reset 'h0;
                doc {
                    Reserved for future use.
                }
            }
            doc {
                Error Injection Control 3 (Symbol Error).
When 8b/10b encoding is used, this register controls error insertion into the special (K code) symbols.
 - If TS1/TS2/FTS/E-Idle/SKP is selected, it affects whole of the ordered set. It might cause timeout of the LTSSM.
 - If END/EDB/STP/SDP is selected, TLP/DLLP will be discarded at the receiver side.
When 128b/130b encoding is used, this register controls error insertion into the sync-header.Error Injection Control 3 (Symbol Error).
When 8b/10b encoding is used, this register controls error insertion into the special (K code) symbols.
 - If TS1/TS2/FTS/E-Idle/SKP is selected, it affects whole of the ordered set. It might cause timeout of the LTSSM.
 - If END/EDB/STP/SDP is selected, TLP/DLLP will be discarded at the receiver side.
When 128b/130b encoding is used, this register controls error insertion into the sync-header.
            }
        }
        register EINJ4_FC_REG @'h44 {
            bytes 4;
            field EINJ4_COUNT @'h0 {
                bits 8;
                access rw;
                volatile 1
                hard_reset 'h0;
                doc {
                    Error injection count.
Indicates the number of errors.
This register is decremented as the errors are being inserted.
 - If the counter value is 0x01 and error is inserted, ERROR_INJECTION4_ENABLE in EINJ_ENABLE_REG returns '0'.
 - If the counter value is 0x00 and ERROR_INJECTION4_ENABLE =1, the errors are inserted until ERROR_INJECTION4_ENABLE is set to '0'. 
Note: This register field is sticky.
                }
            }
            field EINJ4_UPDFC_TYPE @'h8 {
                bits 3;
                access rw;
                hard_reset 'h0;
                doc {
                    Update-FC type.
Selects the credit type.
 - 000b: Posted TLP Header Credit value control
 - 001b: Non-Posted TLP Header Credit value control
 - 010b: Completion TLP Header Credit value control
 - 011b: Reserved
 - 100b: Posted TLP Data Credit value control
 - 101b: Non-Posted TLP Data Credit value control
 - 110b: Completion TLP Data Credit value control
 - 111b: Reserved
Note: This register field is sticky.
                }
            }
            field RSVDP_11 @'hb {
                access ro;
                hard_reset 'h0;
                soft_reset 'h0;
                doc {
                    Reserved for future use.
                }
            }
            field EINJ4_VC_NUMBER @'hc {
                bits 3;
                access rw;
                hard_reset 'h0;
                doc {
                    VC Number.
Indicates target VC Number.

Note: This register field is sticky.
                }
            }
            field RSVDP_15 @'hf {
                access ro;
                hard_reset 'h0;
                soft_reset 'h0;
                doc {
                    Reserved for future use.
                }
            }
            field EINJ4_BAD_UPDFC_VALUE @'h10 {
                bits 13;
                access rw;
                hard_reset 'h0;
                doc {
                    Bad update-FC credit value.
Indicates the value to add/subtract from the UpdateFC credit. This value is represented by two's complement.
 - 0x0FFF: +4095
 - ..
 - 0x0002: +2
 - 0x0001: +1
 - 0x0000: 0
 - 0x1FFF: -1
 - 0x1FFE: -2
 - ..
 - 0x1001: -4095
Note: This register field is sticky.
                }
            }
            field RSVDP_29 @'h1d {
                bits 3;
                access ro;
                hard_reset 'h0;
                soft_reset 'h0;
                doc {
                    Reserved for future use.
                }
            }
            doc {
                Error Injection Control 4 (FC Credit Error).
Controls error insertion into the credit value in the UpdateFCs. It is possible to insert errors for any of the following types:
 - Posted TLP Header credit
 - Non-Posted TLP Header credit
 - Completion TLP Header credit
 - Posted TLP Data credit
 - Non-Posted TLP Data credit
 - Completion TLP Data credit
These errors are not correctable while error insertion is enabled. Receiver buffer overflow error might occur.Error Injection Control 4 (FC Credit Error).
Controls error insertion into the credit value in the UpdateFCs. It is possible to insert errors for any of the following types:
 - Posted TLP Header credit
 - Non-Posted TLP Header credit
 - Completion TLP Header credit
 - Posted TLP Data credit
 - Non-Posted TLP Data credit
 - Completion TLP Data credit
These errors are not correctable while error insertion is enabled. Receiver buffer overflow error might occur.
            }
        }
        register EINJ5_SP_TLP_REG @'h48 {
            bytes 4;
            field EINJ5_COUNT @'h0 {
                bits 8;
                access rw;
                volatile 1
                hard_reset 'h0;
                doc {
                    Error injection count.
Indicates the number of errors.
This register is decremented as the errors are being inserted.
 - If the counter value is 0x01 and error is inserted, ERROR_INJECTION5_ENABLE in EINJ_ENABLE_REG returns '0'.
 - If the counter value is 0x00 and ERROR_INJECTION5_ENABLE =1, the errors are inserted until ERROR_INJECTION5_ENABLE is set to '0'. 
Note: This register field is sticky.
                }
            }
            field EINJ5_SPECIFIED_TLP @'h8 {
                access rw;
                hard_reset 'h0;
                doc {
                    Specified TLP.
Selects the specified TLP to be inserted.
 - 0: Generates duplicate TLPs by handling ACK DLLP as NAK DLLP.
 - 1: Generates Nullified TLP (Original TLP will be stored in retry buffer).
Note: This register field is sticky.
                }
            }
            field RSVDP_9 @'h9 {
                bits 23;
                access ro;
                hard_reset 'h0;
                soft_reset 'h0;
                doc {
                    Reserved for future use.
                }
            }
            doc {
                Error Injection Control 5 (Specific TLP Error).
Controls the generation of specified TLPs. Correctable errors will occur which will be fixed by the PCIe protocol.
 - For Duplicate TLP, the controller initiates Data Link Retry by handling ACK DLLP as NAK DLLP. These TLPs will be duplicate TLPs at the receiver side.
 - For Nullified TLP, the TLPs that the controller transmits are changed into nullified TLPs and the original TLPs are stored in the retry buffer. The receiver of these TLPs will detect the lack of seq  and send NAK DLLP at the next TLP. Then the original TLPs are sent from retry buffer and the data controls are recovered. For 128 bit controller or more than 128 bit, the controller inserts errors the number of times of EINJ5_COUNT but doesn't ensure that the errors are continuously inserted into TLPs.Error Injection Control 5 (Specific TLP Error).
Controls the generation of specified TLPs. Correctable errors will occur which will be fixed by the PCIe protocol.
 - For Duplicate TLP, the controller initiates Data Link Retry by handling ACK DLLP as NAK DLLP. These TLPs will be duplicate TLPs at the receiver side.
 - For Nullified TLP, the TLPs that the controller transmits are changed into nullified TLPs and the original TLPs are stored in the retry buffer. The receiver of these TLPs will detect the lack of seq  and send NAK DLLP at the next TLP. Then the original TLPs are sent from retry buffer and the data controls are recovered. For 128 bit controller or more than 128 bit, the controller inserts errors the number of times of EINJ5_COUNT but doesn't ensure that the errors are continuously inserted into TLPs.
            }
        }
        register EINJ6_COMPARE_POINT_H0_REG @'h4c {
            bytes 4;
            field EINJ6_COMPARE_POINT_H0 @'h0 {
                bits 32;
                access rw;
                hard_reset 'h0;
                doc {
                    Packet Compare Point: 1st DWORD.

Specifies which Tx TLP header DWORD 0 bits to compare with the corresponding bits in the Packet Compare Value registers (EINJ6_COMPARE_VALUE*).

When all specified bits (in the Tx TLP header and EINJ6_COMPARE_VALUE*) match, the controller inserts errors into the TLP.

Note: This register field is sticky.
                }
            }
            doc {
                Error Injection Control 6 (Compare Point Header DWORD  0).
Program this register for the 1st DWORD of TLP header/prefix. It is necessary to carefully consider the endianness when you program this register.

Bits [31:0] = TLP_DW0[7:0], TLP_DW0[15:8], TLP_DW0[23:16], TLP_DW0[31:24]

The Packet Compare Point registers (EINJ6_COMPARE_POINT*) specify which Tx TLP header bits to compare with the corresponding bits in the Packet Compare Value registers (EINJ6_COMPARE_VALUE*). 
When all specified bits (in the Tx TLP header and EINJ6_COMPARE_VALUE*) match, the controller inserts errors into the TLP.
The type and number of errors are specified by the EINJ6_TLP_REG register.Error Injection Control 6 (Compare Point Header DWORD  0).
Program this register for the 1st DWORD of TLP header/prefix. It is necessary to carefully consider the endianness when you program this register.

Bits [31:0] = TLP_DW0[7:0], TLP_DW0[15:8], TLP_DW0[23:16], TLP_DW0[31:24]

The Packet Compare Point registers (EINJ6_COMPARE_POINT*) specify which Tx TLP header bits to compare with the corresponding bits in the Packet Compare Value registers (EINJ6_COMPARE_VALUE*). 
When all specified bits (in the Tx TLP header and EINJ6_COMPARE_VALUE*) match, the controller inserts errors into the TLP.
The type and number of errors are specified by the EINJ6_TLP_REG register.
            }
        }
        register EINJ6_COMPARE_POINT_H1_REG @'h50 {
            bytes 4;
            field EINJ6_COMPARE_POINT_H1 @'h0 {
                bits 32;
                access rw;
                hard_reset 'h0;
                doc {
                    Packet Compare Point: 2nd DWORD.

Specifies which Tx TLP header DWORD 1 bits to compare with the corresponding bits in the Packet Compare Value registers (EINJ6_COMPARE_VALUE*).

When all specified bits (in the Tx TLP header and EINJ6_COMPARE_VALUE*) match, the controller inserts errors into the TLP.

Note: This register field is sticky.
                }
            }
            doc {
                Error Injection Control 6 (Compare Point Header DWORD  1).
Program this register for the 2nd DWORD of TLP header/prefix. It is necessary to carefully consider the endianness when you program this register.

Bits [31:0] = TLP_DW1[7:0], TLP_DW1[15:8], TLP_DW1[23:16], TLP_DW1[31:24]

The Packet Compare Point registers (EINJ6_COMPARE_POINT*) specify which Tx TLP header bits to compare with the corresponding bits in the Packet Compare Value registers (EINJ6_COMPARE_VALUE*). 
When all specified bits (in the Tx TLP header and EINJ6_COMPARE_VALUE*) match, the controller inserts errors into the TLP.
The type and number of errors are specified by the EINJ6_TLP_REG register.Error Injection Control 6 (Compare Point Header DWORD  1).
Program this register for the 2nd DWORD of TLP header/prefix. It is necessary to carefully consider the endianness when you program this register.

Bits [31:0] = TLP_DW1[7:0], TLP_DW1[15:8], TLP_DW1[23:16], TLP_DW1[31:24]

The Packet Compare Point registers (EINJ6_COMPARE_POINT*) specify which Tx TLP header bits to compare with the corresponding bits in the Packet Compare Value registers (EINJ6_COMPARE_VALUE*). 
When all specified bits (in the Tx TLP header and EINJ6_COMPARE_VALUE*) match, the controller inserts errors into the TLP.
The type and number of errors are specified by the EINJ6_TLP_REG register.
            }
        }
        register EINJ6_COMPARE_POINT_H2_REG @'h54 {
            bytes 4;
            field EINJ6_COMPARE_POINT_H2 @'h0 {
                bits 32;
                access rw;
                hard_reset 'h0;
                doc {
                    Packet Compare Point: 3rd DWORD.
Specifies which Tx TLP header DWORD 2 bits to compare with the corresponding bits in the Packet Compare Value registers (EINJ6_COMPARE_VALUE*).
When all specified bits (in the Tx TLP header and EINJ6_COMPARE_VALUE*) match, the controller inserts errors into the TLP.

Note: This register field is sticky.
                }
            }
            doc {
                Error Injection Control 6 (Compare Point Header DWORD  2).
Program this register for the 3rd DWORD of TLP header/prefix. It is necessary to carefully consider the endianness when you program this register.

Bits [31:0] = TLP_DW2[7:0], TLP_DW2[15:8], TLP_DW2[23:16], TLP_DW2[31:24]

The Packet Compare Point registers (EINJ6_COMPARE_POINT*) specify which Tx TLP header bits to compare with the corresponding bits in the Packet Compare Value registers (EINJ6_COMPARE_VALUE*). 
When all specified bits (in the Tx TLP header and EINJ6_COMPARE_VALUE*) match, the controller inserts errors into the TLP.
The type and number of errors are specified by the EINJ6_TLP_REG register.Error Injection Control 6 (Compare Point Header DWORD  2).
Program this register for the 3rd DWORD of TLP header/prefix. It is necessary to carefully consider the endianness when you program this register.

Bits [31:0] = TLP_DW2[7:0], TLP_DW2[15:8], TLP_DW2[23:16], TLP_DW2[31:24]

The Packet Compare Point registers (EINJ6_COMPARE_POINT*) specify which Tx TLP header bits to compare with the corresponding bits in the Packet Compare Value registers (EINJ6_COMPARE_VALUE*). 
When all specified bits (in the Tx TLP header and EINJ6_COMPARE_VALUE*) match, the controller inserts errors into the TLP.
The type and number of errors are specified by the EINJ6_TLP_REG register.
            }
        }
        register EINJ6_COMPARE_POINT_H3_REG @'h58 {
            bytes 4;
            field EINJ6_COMPARE_POINT_H3 @'h0 {
                bits 32;
                access rw;
                hard_reset 'h0;
                doc {
                    Packet Compare Point: 4th DWORD.

Specifies which Tx TLP header DWORD 3 bits to compare with the corresponding bits in the Packet Compare Value registers (EINJ6_COMPARE_VALUE*).

When all specified bits (in the Tx TLP header and EINJ6_COMPARE_VALUE*) match, the controller inserts errors into the TLP.

Note: This register field is sticky.
                }
            }
            doc {
                Error Injection Control 6 (Compare Point Header DWORD  3).
Program this register for the 4th DWORD of TLP header/prefix. It is necessary to carefully consider the endianness when you program this register.

Bits [31:0] = TLP_DW3[7:0], TLP_DW3[15:8], TLP_DW3[23:16], TLP_DW3[31:24]

The Packet Compare Point registers (EINJ6_COMPARE_POINT*) specify which Tx TLP header bits to compare with the corresponding bits in the Packet Compare Value registers (EINJ6_COMPARE_VALUE*). 
When all specified bits (in the Tx TLP header and EINJ6_COMPARE_VALUE*) match, the controller inserts errors into the TLP.
The type and number of errors are specified by the EINJ6_TLP_REG register.Error Injection Control 6 (Compare Point Header DWORD  3).
Program this register for the 4th DWORD of TLP header/prefix. It is necessary to carefully consider the endianness when you program this register.

Bits [31:0] = TLP_DW3[7:0], TLP_DW3[15:8], TLP_DW3[23:16], TLP_DW3[31:24]

The Packet Compare Point registers (EINJ6_COMPARE_POINT*) specify which Tx TLP header bits to compare with the corresponding bits in the Packet Compare Value registers (EINJ6_COMPARE_VALUE*). 
When all specified bits (in the Tx TLP header and EINJ6_COMPARE_VALUE*) match, the controller inserts errors into the TLP.
The type and number of errors are specified by the EINJ6_TLP_REG register.
            }
        }
        register EINJ6_COMPARE_VALUE_H0_REG @'h5c {
            bytes 4;
            field EINJ6_COMPARE_VALUE_H0 @'h0 {
                bits 32;
                access rw;
                hard_reset 'h0;
                doc {
                    Packet Compare Value: 1st DWORD.

Specifies the value to compare against Tx the TLP header DWORD 0 bits specified in the Packet Compare Point registers (EINJ6_COMPARE_POINT*).

Note: This register field is sticky.
                }
            }
            doc {
                Error Injection Control 6 (Compare Value Header DWORD  0).
Program this register for the 1st DWORD of TLP header/prefix. It is necessary to carefully consider the endianness when you program this register.

Bits [31:0] = TLP_DW0[7:0], TLP_DW0[15:8], TLP_DW0[23:16], TLP_DW0[31:24]

The Packet Compare Point registers (EINJ6_COMPARE_POINT*) specify which Tx TLP header bits to compare with the corresponding bits in the Packet Compare Value registers (EINJ6_COMPARE_VALUE*). 
When all specified bits (in the Tx TLP header and EINJ6_COMPARE_VALUE*) match, the controller inserts errors into the TLP.
The type and number of errors are specified by the EINJ6_TLP_REG register.Error Injection Control 6 (Compare Value Header DWORD  0).
Program this register for the 1st DWORD of TLP header/prefix. It is necessary to carefully consider the endianness when you program this register.

Bits [31:0] = TLP_DW0[7:0], TLP_DW0[15:8], TLP_DW0[23:16], TLP_DW0[31:24]

The Packet Compare Point registers (EINJ6_COMPARE_POINT*) specify which Tx TLP header bits to compare with the corresponding bits in the Packet Compare Value registers (EINJ6_COMPARE_VALUE*). 
When all specified bits (in the Tx TLP header and EINJ6_COMPARE_VALUE*) match, the controller inserts errors into the TLP.
The type and number of errors are specified by the EINJ6_TLP_REG register.
            }
        }
        register EINJ6_COMPARE_VALUE_H1_REG @'h60 {
            bytes 4;
            field EINJ6_COMPARE_VALUE_H1 @'h0 {
                bits 32;
                access rw;
                hard_reset 'h0;
                doc {
                    Packet Compare Value: 2nd DWORD.

Specifies the value to compare against Tx the TLP header DWORD 1 bits specified in the Packet Compare Point registers (EINJ6_COMPARE_POINT*).

Note: This register field is sticky.
                }
            }
            doc {
                Error Injection Control 6 (Compare Value Header DWORD  1).
Program this register for the 2nd DWORD of TLP header/prefix. It is necessary to carefully consider the endianness when you program this register.

Bits [31:0] = TLP_DW1[7:0], TLP_DW1[15:8], TLP_DW1[23:16], TLP_DW1[31:24]

The Packet Compare Point registers (EINJ6_COMPARE_POINT*) specify which Tx TLP header bits to compare with the corresponding bits in the Packet Compare Value registers (EINJ6_COMPARE_VALUE*). 
When all specified bits (in the Tx TLP header and EINJ6_COMPARE_VALUE*) match, the controller inserts errors into the TLP.
The type and number of errors are specified by the EINJ6_TLP_REG register.Error Injection Control 6 (Compare Value Header DWORD  1).
Program this register for the 2nd DWORD of TLP header/prefix. It is necessary to carefully consider the endianness when you program this register.

Bits [31:0] = TLP_DW1[7:0], TLP_DW1[15:8], TLP_DW1[23:16], TLP_DW1[31:24]

The Packet Compare Point registers (EINJ6_COMPARE_POINT*) specify which Tx TLP header bits to compare with the corresponding bits in the Packet Compare Value registers (EINJ6_COMPARE_VALUE*). 
When all specified bits (in the Tx TLP header and EINJ6_COMPARE_VALUE*) match, the controller inserts errors into the TLP.
The type and number of errors are specified by the EINJ6_TLP_REG register.
            }
        }
        register EINJ6_COMPARE_VALUE_H2_REG @'h64 {
            bytes 4;
            field EINJ6_COMPARE_VALUE_H2 @'h0 {
                bits 32;
                access rw;
                hard_reset 'h0;
                doc {
                    Packet Compare Value: 3rd DWORD.

Specifies the value to compare against Tx the TLP header DWORD 2 bits specified in the Packet Compare Point registers (EINJ6_COMPARE_POINT*).

Note: This register field is sticky.
                }
            }
            doc {
                Error Injection Control 6 (Compare Value Header DWORD  2).
Program this register for the 3rd DWORD of TLP header/prefix. It is necessary to carefully consider the endianness when you program this register.

Bits [31:0] = TLP_DW2[7:0], TLP_DW2[15:8], TLP_DW2[23:16], TLP_DW2[31:24]

The Packet Compare Point registers (EINJ6_COMPARE_POINT*) specify which Tx TLP header bits to compare with the corresponding bits in the Packet Compare Value registers (EINJ6_COMPARE_VALUE*). 
When all specified bits (in the Tx TLP header and EINJ6_COMPARE_VALUE*) match, the controller inserts errors into the TLP.
The type and number of errors are specified by the EINJ6_TLP_REG register.Error Injection Control 6 (Compare Value Header DWORD  2).
Program this register for the 3rd DWORD of TLP header/prefix. It is necessary to carefully consider the endianness when you program this register.

Bits [31:0] = TLP_DW2[7:0], TLP_DW2[15:8], TLP_DW2[23:16], TLP_DW2[31:24]

The Packet Compare Point registers (EINJ6_COMPARE_POINT*) specify which Tx TLP header bits to compare with the corresponding bits in the Packet Compare Value registers (EINJ6_COMPARE_VALUE*). 
When all specified bits (in the Tx TLP header and EINJ6_COMPARE_VALUE*) match, the controller inserts errors into the TLP.
The type and number of errors are specified by the EINJ6_TLP_REG register.
            }
        }
        register EINJ6_COMPARE_VALUE_H3_REG @'h68 {
            bytes 4;
            field EINJ6_COMPARE_VALUE_H3 @'h0 {
                bits 32;
                access rw;
                hard_reset 'h0;
                doc {
                    Packet Compare Value: 4th DWORD.

Specifies the value to compare against Tx the TLP header DWORD 3 bits specified in the Packet Compare Point registers (EINJ6_COMPARE_POINT*).

Note: This register field is sticky.
                }
            }
            doc {
                Error Injection Control 6 (Compare Value Header DWORD  3).
Program this register for the 4th DWORD of TLP header/prefix. It is necessary to carefully consider the endianness when you program this register.

Bits [31:0] = TLP_DW3[7:0], TLP_DW3[15:8], TLP_DW3[23:16], TLP_DW3[31:24]

The Packet Compare Point registers (EINJ6_COMPARE_POINT*) specify which Tx TLP header bits to compare with the corresponding bits in the Packet Compare Value registers (EINJ6_COMPARE_VALUE*). 
When all specified bits (in the Tx TLP header and EINJ6_COMPARE_VALUE*) match, the controller inserts errors into the TLP.
The type and number of errors are specified by the EINJ6_TLP_REG register.Error Injection Control 6 (Compare Value Header DWORD  3).
Program this register for the 4th DWORD of TLP header/prefix. It is necessary to carefully consider the endianness when you program this register.

Bits [31:0] = TLP_DW3[7:0], TLP_DW3[15:8], TLP_DW3[23:16], TLP_DW3[31:24]

The Packet Compare Point registers (EINJ6_COMPARE_POINT*) specify which Tx TLP header bits to compare with the corresponding bits in the Packet Compare Value registers (EINJ6_COMPARE_VALUE*). 
When all specified bits (in the Tx TLP header and EINJ6_COMPARE_VALUE*) match, the controller inserts errors into the TLP.
The type and number of errors are specified by the EINJ6_TLP_REG register.
            }
        }
        register EINJ6_CHANGE_POINT_H0_REG @'h6c {
            bytes 4;
            field EINJ6_CHANGE_POINT_H0 @'h0 {
                bits 32;
                access rw;
                hard_reset 'h0;
                doc {
                    Packet Change Point: 1st DWORD.

Specifies which Tx TLP header DWORD 0 bits to replace with the corresponding bits in the Packet Change Value registers (EINJ6_CHANGE_VALUE*).

Note: This register field is sticky.
                }
            }
            doc {
                Error Injection Control 6 (Change Point Header DWORD  0).
Program this register for the 1st DWORD of TLP header/prefix. It is necessary to carefully consider the endianness when you program this register.

Bits [31:0] = TLP_DW0[7:0], TLP_DW0[15:8], TLP_DW0[23:16], TLP_DW0[31:24]

The Packet Change Point registers (EINJ6_CHANGE_POINT*) specify which Tx TLP header bits to replace with the corresponding bits in the Packet Change Value registers (EINJ6_CHANGE_VALUE*). 
The type and number of errors are specified by the EINJ6_TLP_REG register.
Only applies when EINJ6_INVERTED_CONTROL in EINJ6_TLP_REG =0.Error Injection Control 6 (Change Point Header DWORD  0).
Program this register for the 1st DWORD of TLP header/prefix. It is necessary to carefully consider the endianness when you program this register.

Bits [31:0] = TLP_DW0[7:0], TLP_DW0[15:8], TLP_DW0[23:16], TLP_DW0[31:24]

The Packet Change Point registers (EINJ6_CHANGE_POINT*) specify which Tx TLP header bits to replace with the corresponding bits in the Packet Change Value registers (EINJ6_CHANGE_VALUE*). 
The type and number of errors are specified by the EINJ6_TLP_REG register.
Only applies when EINJ6_INVERTED_CONTROL in EINJ6_TLP_REG =0.
            }
        }
        register EINJ6_CHANGE_POINT_H1_REG @'h70 {
            bytes 4;
            field EINJ6_CHANGE_POINT_H1 @'h0 {
                bits 32;
                access rw;
                hard_reset 'h0;
                doc {
                    Packet Change Point: 2nd DWORD.

Specifies which Tx TLP header DWORD 1 bits to replace with the corresponding bits in the Packet Change Value registers (EINJ6_CHANGE_VALUE*).

Note: This register field is sticky.
                }
            }
            doc {
                Error Injection Control 6 (Change Point Header DWORD  1).
Program this register for the 2nd DWORD of TLP header/prefix. It is necessary to carefully consider the endianness when you program this register.

Bits [31:0] = TLP_DW1[7:0], TLP_DW1[15:8], TLP_DW1[23:16], TLP_DW1[31:24]

The Packet Change Point registers (EINJ6_CHANGE_POINT*) specify which Tx TLP header bits to replace with the corresponding bits in the Packet Change Value registers (EINJ6_CHANGE_VALUE*). 
The type and number of errors are specified by the EINJ6_TLP_REG register.
Only applies when EINJ6_INVERTED_CONTROL in EINJ6_TLP_REG =0.Error Injection Control 6 (Change Point Header DWORD  1).
Program this register for the 2nd DWORD of TLP header/prefix. It is necessary to carefully consider the endianness when you program this register.

Bits [31:0] = TLP_DW1[7:0], TLP_DW1[15:8], TLP_DW1[23:16], TLP_DW1[31:24]

The Packet Change Point registers (EINJ6_CHANGE_POINT*) specify which Tx TLP header bits to replace with the corresponding bits in the Packet Change Value registers (EINJ6_CHANGE_VALUE*). 
The type and number of errors are specified by the EINJ6_TLP_REG register.
Only applies when EINJ6_INVERTED_CONTROL in EINJ6_TLP_REG =0.
            }
        }
        register EINJ6_CHANGE_POINT_H2_REG @'h74 {
            bytes 4;
            field EINJ6_CHANGE_POINT_H2 @'h0 {
                bits 32;
                access rw;
                hard_reset 'h0;
                doc {
                    Packet Change Point: 3rd DWORD.

Specifies which Tx TLP header DWORD 2 bits to replace with the corresponding bits in the Packet Change Value registers (EINJ6_CHANGE_VALUE*).

Note: This register field is sticky.
                }
            }
            doc {
                Error Injection Control 6 (Change Point Header DWORD  2).
Program this register for the 3rd DWORD of TLP header/prefix. It is necessary to carefully consider the endianness when you program this register.

Bits [31:0] = TLP_DW2[7:0], TLP_DW2[15:8], TLP_DW2[23:16], TLP_DW2[31:24]

The Packet Change Point registers (EINJ6_CHANGE_POINT*) specify which Tx TLP header bits to replace with the corresponding bits in the Packet Change Value registers (EINJ6_CHANGE_VALUE*). 
The type and number of errors are specified by the EINJ6_TLP_REG register.
Only applies when EINJ6_INVERTED_CONTROL in EINJ6_TLP_REG =0.Error Injection Control 6 (Change Point Header DWORD  2).
Program this register for the 3rd DWORD of TLP header/prefix. It is necessary to carefully consider the endianness when you program this register.

Bits [31:0] = TLP_DW2[7:0], TLP_DW2[15:8], TLP_DW2[23:16], TLP_DW2[31:24]

The Packet Change Point registers (EINJ6_CHANGE_POINT*) specify which Tx TLP header bits to replace with the corresponding bits in the Packet Change Value registers (EINJ6_CHANGE_VALUE*). 
The type and number of errors are specified by the EINJ6_TLP_REG register.
Only applies when EINJ6_INVERTED_CONTROL in EINJ6_TLP_REG =0.
            }
        }
        register EINJ6_CHANGE_POINT_H3_REG @'h78 {
            bytes 4;
            field EINJ6_CHANGE_POINT_H3 @'h0 {
                bits 32;
                access rw;
                hard_reset 'h0;
                doc {
                    Packet Change Point: 4th DWORD.

Specifies which Tx TLP header DWORD 3 bits to replace with the corresponding bits in the Packet Change Value registers (EINJ6_CHANGE_VALUE*).

Note: This register field is sticky.
                }
            }
            doc {
                Error Injection Control 6 (Change Point Header DWORD  3).
Program this register for the 4th DWORD of TLP header/prefix. It is necessary to carefully consider the endianness when you program this register.

Bits [31:0] = TLP_DW3[7:0], TLP_DW3[15:8], TLP_DW3[23:16], TLP_DW3[31:24]

The Packet Change Point registers (EINJ6_CHANGE_POINT*) specify which Tx TLP header bits to replace with the corresponding bits in the Packet Change Value registers (EINJ6_CHANGE_VALUE*). 
The type and number of errors are specified by the EINJ6_TLP_REG register.
Only applies when EINJ6_INVERTED_CONTROL in EINJ6_TLP_REG =0.Error Injection Control 6 (Change Point Header DWORD  3).
Program this register for the 4th DWORD of TLP header/prefix. It is necessary to carefully consider the endianness when you program this register.

Bits [31:0] = TLP_DW3[7:0], TLP_DW3[15:8], TLP_DW3[23:16], TLP_DW3[31:24]

The Packet Change Point registers (EINJ6_CHANGE_POINT*) specify which Tx TLP header bits to replace with the corresponding bits in the Packet Change Value registers (EINJ6_CHANGE_VALUE*). 
The type and number of errors are specified by the EINJ6_TLP_REG register.
Only applies when EINJ6_INVERTED_CONTROL in EINJ6_TLP_REG =0.
            }
        }
        register EINJ6_CHANGE_VALUE_H0_REG @'h7c {
            bytes 4;
            field EINJ6_CHANGE_VALUE_H0 @'h0 {
                bits 32;
                access rw;
                hard_reset 'h0;
                doc {
                    Packet Change Value: 1st DWORD.

Specifies replacement values for the Tx TLP header DWORD 0 bits defined in the Packet Change Point registers (EINJ6_CHANGE_POINT*).

Only applies when the EINJ6_INVERTED_CONTROL field in EINJ6_TLP_REG is '0'.

Note: This register field is sticky.
                }
            }
            doc {
                Error Injection Control 6 (Change Value Header DWORD  0).
Program this register for the 1st DWORD of TLP header/prefix. It is necessary to carefully consider the endianness when you program this register.

Bits [31:0] = TLP_DW0[7:0], TLP_DW0[15:8], TLP_DW0[23:16], TLP_DW0[31:24]

The Packet Change Point registers (EINJ6_CHANGE_POINT*) specify which Tx TLP header bits to replace with the corresponding bits in the Packet Change Value registers (EINJ6_CHANGE_VALUE*). 
The type and number of errors are specified by the EINJ6_TLP_REG register.
Only applies when EINJ6_INVERTED_CONTROL in EINJ6_TLP_REG =0.Error Injection Control 6 (Change Value Header DWORD  0).
Program this register for the 1st DWORD of TLP header/prefix. It is necessary to carefully consider the endianness when you program this register.

Bits [31:0] = TLP_DW0[7:0], TLP_DW0[15:8], TLP_DW0[23:16], TLP_DW0[31:24]

The Packet Change Point registers (EINJ6_CHANGE_POINT*) specify which Tx TLP header bits to replace with the corresponding bits in the Packet Change Value registers (EINJ6_CHANGE_VALUE*). 
The type and number of errors are specified by the EINJ6_TLP_REG register.
Only applies when EINJ6_INVERTED_CONTROL in EINJ6_TLP_REG =0.
            }
        }
        register EINJ6_CHANGE_VALUE_H1_REG @'h80 {
            bytes 4;
            field EINJ6_CHANGE_VALUE_H1 @'h0 {
                bits 32;
                access rw;
                hard_reset 'h0;
                doc {
                    Packet Change Value: 2nd DWORD.

Specifies replacement values for the Tx TLP header DWORD 1 bits defined in the Packet Change Point registers (EINJ6_CHANGE_POINT*).

Only applies when the EINJ6_INVERTED_CONTROL field in EINJ6_TLP_REG is '0'.

Note: This register field is sticky.
                }
            }
            doc {
                Error Injection Control 6 (Change Value Header DWORD  1).
Program this register for the 2nd DWORD of TLP header/prefix. It is necessary to carefully consider the endianness when you program this register.

Bits [31:0] = TLP_DW1[7:0], TLP_DW1[15:8], TLP_DW1[23:16], TLP_DW1[31:24]

The Packet Change Point registers (EINJ6_CHANGE_POINT*) specify which Tx TLP header bits to replace with the corresponding bits in the Packet Change Value registers (EINJ6_CHANGE_VALUE*). 
The type and number of errors are specified by the EINJ6_TLP_REG register.
Only applies when EINJ6_INVERTED_CONTROL in EINJ6_TLP_REG =0.Error Injection Control 6 (Change Value Header DWORD  1).
Program this register for the 2nd DWORD of TLP header/prefix. It is necessary to carefully consider the endianness when you program this register.

Bits [31:0] = TLP_DW1[7:0], TLP_DW1[15:8], TLP_DW1[23:16], TLP_DW1[31:24]

The Packet Change Point registers (EINJ6_CHANGE_POINT*) specify which Tx TLP header bits to replace with the corresponding bits in the Packet Change Value registers (EINJ6_CHANGE_VALUE*). 
The type and number of errors are specified by the EINJ6_TLP_REG register.
Only applies when EINJ6_INVERTED_CONTROL in EINJ6_TLP_REG =0.
            }
        }
        register EINJ6_CHANGE_VALUE_H2_REG @'h84 {
            bytes 4;
            field EINJ6_CHANGE_VALUE_H2 @'h0 {
                bits 32;
                access rw;
                hard_reset 'h0;
                doc {
                    Packet Change Value: 3rd DWORD.

Specifies replacement values for the Tx TLP header DWORD 2 bits defined in the Packet Change Point registers (EINJ6_CHANGE_POINT*).

Only applies when the EINJ6_INVERTED_CONTROL field in EINJ6_TLP_REG is '0'.

Note: This register field is sticky.
                }
            }
            doc {
                Error Injection Control 6 (Change Value Header DWORD  2).
Program this register for the 3rd DWORD of TLP header/prefix. It is necessary to carefully consider the endianness when you program this register.

Bits [31:0] = TLP_DW2[7:0], TLP_DW2[15:8], TLP_DW2[23:16], TLP_DW2[31:24]

The Packet Change Point registers (EINJ6_CHANGE_POINT*) specify which Tx TLP header bits to replace with the corresponding bits in the Packet Change Value registers (EINJ6_CHANGE_VALUE*). 
The type and number of errors are specified by the EINJ6_TLP_REG register.
Only applies when EINJ6_INVERTED_CONTROL in EINJ6_TLP_REG =0.Error Injection Control 6 (Change Value Header DWORD  2).
Program this register for the 3rd DWORD of TLP header/prefix. It is necessary to carefully consider the endianness when you program this register.

Bits [31:0] = TLP_DW2[7:0], TLP_DW2[15:8], TLP_DW2[23:16], TLP_DW2[31:24]

The Packet Change Point registers (EINJ6_CHANGE_POINT*) specify which Tx TLP header bits to replace with the corresponding bits in the Packet Change Value registers (EINJ6_CHANGE_VALUE*). 
The type and number of errors are specified by the EINJ6_TLP_REG register.
Only applies when EINJ6_INVERTED_CONTROL in EINJ6_TLP_REG =0.
            }
        }
        register EINJ6_CHANGE_VALUE_H3_REG @'h88 {
            bytes 4;
            field EINJ6_CHANGE_VALUE_H3 @'h0 {
                bits 32;
                access rw;
                hard_reset 'h0;
                doc {
                    Packet Change Value: 4th DWORD.

Specifies replacement values for the Tx TLP header DWORD 3 bits defined in the Packet Change Point registers (EINJ6_CHANGE_POINT*).

Only applies when the EINJ6_INVERTED_CONTROL field in EINJ6_TLP_REG is '0'.

Note: This register field is sticky.
                }
            }
            doc {
                Error Injection Control 6 (Change Value Header DWORD  3).
Program this register for the 4th DWORD of TLP header/prefix. It is necessary to carefully consider the endianness when you program this register.

Bits [31:0] = TLP_DW3[7:0], TLP_DW3[15:8], TLP_DW3[23:16], TLP_DW3[31:24]

The Packet Change Point registers (EINJ6_CHANGE_POINT*) specify which Tx TLP header bits to replace with the corresponding bits in the Packet Change Value registers (EINJ6_CHANGE_VALUE*). 
The type and number of errors are specified by the EINJ6_TLP_REG register.
Only applies when EINJ6_INVERTED_CONTROL in EINJ6_TLP_REG =0.Error Injection Control 6 (Change Value Header DWORD  3).
Program this register for the 4th DWORD of TLP header/prefix. It is necessary to carefully consider the endianness when you program this register.

Bits [31:0] = TLP_DW3[7:0], TLP_DW3[15:8], TLP_DW3[23:16], TLP_DW3[31:24]

The Packet Change Point registers (EINJ6_CHANGE_POINT*) specify which Tx TLP header bits to replace with the corresponding bits in the Packet Change Value registers (EINJ6_CHANGE_VALUE*). 
The type and number of errors are specified by the EINJ6_TLP_REG register.
Only applies when EINJ6_INVERTED_CONTROL in EINJ6_TLP_REG =0.
            }
        }
        register EINJ6_TLP_REG @'h8c {
            bytes 4;
            field EINJ6_COUNT @'h0 {
                bits 8;
                access rw;
                volatile 1
                hard_reset 'h0;
                doc {
                    Error Injection Count.

Indicates the number of errors to insert.
This counter is decremented while errors are been inserted.
 - If the counter value is 0x01 and error is inserted, ERROR_INJECTION6_ENABLE in EINJ_ENABLE_REG returns '0'.
 - If the counter value is 0x00 and ERROR_INJECTION6_ENABLE=1, errors are inserted until ERROR_INJECTION6_ENABLE is set to '0'. 
Note: This register field is sticky.
                }
            }
            field EINJ6_INVERTED_CONTROL @'h8 {
                access rw;
                hard_reset 'h0;
                doc {
                    Inverted Error Injection Control.
 - 0: EINJ6_CHANGE_VALUE_H[0/1/2/3] is used to replace bits specified by EINJ6_CHANGE_POINT_H[0/1/2/3].
 - 1: EINJ6_CHANGE_VALUE_H[0/1/2/3] is ignored and inverts bits specified by EINJ6_CHANGE_POINT_H[0/1/2/3].
Note: This register field is sticky.
                }
            }
            field EINJ6_PACKET_TYPE @'h9 {
                bits 3;
                access rw;
                hard_reset 'h0;
                doc {
                    Packet type.

Selects the TLP packets to inject errors into.
 - 0: TLP Header
 - 1: TLP Prefix 1st 4-DWORDs
 - 2: TLP Prefix 2nd -DWORDs
 - Else: Reserved
Note: This register field is sticky.
                }
            }
            field RSVDP_12 @'hc {
                bits 20;
                access ro;
                hard_reset 'h0;
                soft_reset 'h0;
                doc {
                    Reserved for future use.
                }
            }
            doc {
                Error Injection Control 6 (Packet Error).

The Packet Compare Point registers (EINJ6_COMPARE_POINT*) specify which Tx TLP header bits to compare with the corresponding bits in the Packet Compare Value registers (EINJ6_COMPARE_VALUE*). 
When all specified bits (in the Tx TLP header and EINJ6_COMPARE_VALUE*) match, the controller inserts errors into the TLP.
The type and number of errors are specified by the this register.

The Packet Change Point registers (EINJ6_CHANGE_POINT*) specify which Tx TLP header bits to replace with the corresponding bits in the Packet Change Value registers (EINJ6_CHANGE_VALUE*). 
The type and number of errors are specified by the this register.
Only applies when EINJ6_INVERTED_CONTROL in this register =0.
The TLP into that errors are injected will not arrive at the transaction layer of the remote device when all of the following conditions are true.
 - Using 128b/130b encoding
 - Injecting errors into TLP Length field / TLP digest bitError Injection Control 6 (Packet Error).

The Packet Compare Point registers (EINJ6_COMPARE_POINT*) specify which Tx TLP header bits to compare with the corresponding bits in the Packet Compare Value registers (EINJ6_COMPARE_VALUE*). 
When all specified bits (in the Tx TLP header and EINJ6_COMPARE_VALUE*) match, the controller inserts errors into the TLP.
The type and number of errors are specified by the this register.

The Packet Change Point registers (EINJ6_CHANGE_POINT*) specify which Tx TLP header bits to replace with the corresponding bits in the Packet Change Value registers (EINJ6_CHANGE_VALUE*). 
The type and number of errors are specified by the this register.
Only applies when EINJ6_INVERTED_CONTROL in this register =0.
The TLP into that errors are injected will not arrive at the transaction layer of the remote device when all of the following conditions are true.
 - Using 128b/130b encoding
 - Injecting errors into TLP Length field / TLP digest bit
            }
        }
        register SD_CONTROL1_REG @'ha0 {
            bytes 4;
            field FORCE_DETECT_LANE @'h0 {
                bits 16;
                access rw;
                hard_reset 'h0;
                doc {
                    Force Detect Lane.

When the FORCE_DETECT_LANE_EN field is set, the controller ignores receiver detection from PHY during LTSSM Detect state and uses this value instead.
 - 0: Lane0
 - 1: Lane1
 - 2: Lane2
 - ..
 - 15: Lane15
Note: This register field is sticky.
                }
            }
            field FORCE_DETECT_LANE_EN @'h10 {
                access rw;
                hard_reset 'h0;
                doc {
                    Force Detect Lane Enable.

When this bit is set, the controller ignores receiver detection from PHY during LTSSM Detect state and uses FORCE_DETECT_LANE.

Note: This register field is sticky.
                }
            }
            field RSVDP_17 @'h11 {
                bits 3;
                access ro;
                hard_reset 'h0;
                soft_reset 'h0;
                doc {
                    Reserved for future use.
                }
            }
            field TX_EIOS_NUM @'h14 {
                bits 2;
                access rw;
                hard_reset 'h0;
                doc {
                    Number of Tx EIOS.

This register sets the number of transmit EIOS for L0s/L1 entry and Disable/Loopback/Hot-reset exit. The controller selects the greater value between this register and the value defined by the PCI-SIG specification.

2.5GT/s, 8.0GT/s or higher:
 - 0x0: 1
 - 0x1: 4
 - 0x2: 8
 - 0x3: 16
5.0GT/s:
 - 0x0: 2
 - 0x1: 8
 - 0x2: 16
 - 0x3: 32
Note: This register field is sticky.
                }
            }
            field LOW_POWER_INTERVAL @'h16 {
                bits 2;
                access rw;
                hard_reset 'h0;
                doc {
                    Low Power Entry Interval Time.

Interval Time that the controller starts monitoring RXELECIDLE signal after L0s/L1/L2 entry. You should set the value according to the latency from receiving EIOS to, RXELECIDLE assertion at the PHY.
 - 0x0: 40ns
 - 0x1: 160ns
 - 0x2: 320ns
 - 0x3: 640ns
Note: This register field is sticky.
                }
            }
            field RSVDP_24 @'h18 {
                bits 8;
                access ro;
                hard_reset 'h0;
                soft_reset 'h0;
                doc {
                    Reserved for future use.
                }
            }
            doc {
                Silicon Debug Control 1.
For more details, see the RAS DES section in the Core Operations chapter of the Databook.Silicon Debug Control 1.
For more details, see the RAS DES section in the Core Operations chapter of the Databook.
            }
        }
        register SD_CONTROL2_REG @'ha4 {
            bytes 4;
            field HOLD_LTSSM @'h0 {
                access rw;
                hard_reset 'h0;
                doc {
                    Hold and Release LTSSM.

For as long as this register is '1', the controller stays in the current LTSSM.

Note: This register field is sticky.
                }
            }
            field RECOVERY_REQUEST @'h1 {
                access wo;
                volatile 1
                hard_reset 'h0;
                doc {
                    Recovery Request.

When this bit is set to '1' in L0 or L0s, the LTSSM starts transitioning to Recovery State. This request does not cause a speed change or re-equalization.
                }
            }
            field NOACK_FORCE_LINKDOWN @'h2 {
                access rw;
                hard_reset 'h0;
                doc {
                    Force LinkDown.

When this bit is set and the controller detects REPLY_NUM rolling over 4 times, the LTSSM transitions to Detect State.

Note: This register field is sticky.
                }
            }
            field RSVDP_3 @'h3 {
                bits 5;
                access ro;
                hard_reset 'h0;
                soft_reset 'h0;
                doc {
                    Reserved for future use.
                }
            }
            field DIRECT_RECIDLE_TO_CONFIG @'h8 {
                access rw;
                hard_reset 'h0;
                doc {
                    Direct Recovery.Idle to Configuration.

When this bit is set and the LTSSM is in Recovery Idle State, the LTSSM transitions to Configuration state.

Note: This register field is sticky.
                }
            }
            field DIRECT_POLCOMP_TO_DETECT @'h9 {
                access rw;
                hard_reset 'h0;
                doc {
                    Direct Polling.Compliance to Detect.

When this bit is set and the LTSSM is in Polling Compliance State, the LTSSM transitions to Detect state.

Note: This register field is sticky.
                }
            }
            field DIRECT_LPBKSLV_TO_EXIT @'ha {
                access rw;
                hard_reset 'h0;
                doc {
                    Direct Loopback Slave To Exit.

When this bit is set and the LTSSM is in Loopback Slave Active State, the LTSSM transitions to Loopback Slave Exit state.

Note: This register field is sticky.
                }
            }
            field RSVDP_11 @'hb {
                bits 5;
                access ro;
                hard_reset 'h0;
                soft_reset 'h0;
                doc {
                    Reserved for future use.
                }
            }
            field FRAMING_ERR_RECOVERY_DISABLE @'h10 {
                access rw;
                hard_reset 'h0;
                doc {
                    Framing Error Recovery Disable.

This bit disables a transition to Recovery state when a Framing Error is occurred.

Note: This register field is sticky.
                }
            }
            field RSVDP_17 @'h11 {
                bits 15;
                access ro;
                hard_reset 'h0;
                soft_reset 'h0;
                doc {
                    Reserved for future use.
                }
            }
            doc {
                Silicon Debug Control 2.
For more details, see the RAS DES section in the Core Operations chapter of the Databook.Silicon Debug Control 2.
For more details, see the RAS DES section in the Core Operations chapter of the Databook.
            }
        }
        register SD_STATUS_L1LANE_REG @'hb0 {
            bytes 4;
            field LANE_SELECT @'h0 {
                bits 4;
                access rw;
                hard_reset 'h0;
                doc {
                    Lane Select.

Lane Select register for Silicon Debug Status Register of Layer1-PerLane.
 - 0x0: Lane0
 - 0x1: Lane1
 - 0x2: Lane2
 - ..
 - 0xF: Lane15
Note: This register field is sticky.
                }
            }
            field RSVDP_4 @'h4 {
                bits 12;
                access ro;
                hard_reset 'h0;
                soft_reset 'h0;
                doc {
                    Reserved for future use.
                }
            }
            field PIPE_RXPOLARITY @'h10 {
                access ro;
                volatile 1
                hard_reset 'h0;
                doc {
                    PIPE:RxPolarity.

Indicates PIPE RXPOLARITY signal of selected lane number(LANE_SELECT).

Note: This register field is sticky.
                }
            }
            field PIPE_DETECT_LANE @'h11 {
                access ro;
                volatile 1
                hard_reset 'h0;
                doc {
                    PIPE:Detect Lane.

Indicates whether PHY indicates receiver detection or not on selected lane number(LANE_SELECT).

Note: This register field is sticky.
                }
            }
            field PIPE_RXVALID @'h12 {
                access ro;
                volatile 1
                hard_reset 'h0;
                doc {
                    PIPE:RxValid.

Indicates PIPE RXVALID signal of selected lane number(LANE_SELECT).

Note: This register field is sticky.
                }
            }
            field PIPE_RXELECIDLE @'h13 {
                access ro;
                volatile 1
                hard_reset 'h0;
                doc {
                    PIPE:RxElecIdle.

Indicates PIPE RXELECIDLE signal of selected lane number(LANE_SELECT).

Note: This register field is sticky.
                }
            }
            field PIPE_TXELECIDLE @'h14 {
                access ro;
                volatile 1
                hard_reset 'h0;
                doc {
                    PIPE:TxElecIdle.

Indicates PIPE TXELECIDLE signal of selected lane number(LANE_SELECT).

Note: This register field is sticky.
                }
            }
            field RSVDP_21 @'h15 {
                bits 3;
                access ro;
                hard_reset 'h0;
                soft_reset 'h0;
                doc {
                    Reserved for future use.
                }
            }
            field DESKEW_POINTER @'h18 {
                bits 8;
                access ro;
                volatile 1
                hard_reset 'h0;
                doc {
                    Deskew Pointer.

Indicates Deskew pointer of internal Deskew buffer of selected lane number(LANE_SELECT).

Note: This register field is sticky.
                }
            }
            doc {
                Silicon Debug Status(Layer1 Per-lane).
This viewport register returns the data selected by the following field:
 - LANE_SELECT in SD_STATUS_L1LANE_REG
For more details, see the RAS DES section in the Core Operations chapter of the Databook.Silicon Debug Status(Layer1 Per-lane).
This viewport register returns the data selected by the following field:
 - LANE_SELECT in SD_STATUS_L1LANE_REG
For more details, see the RAS DES section in the Core Operations chapter of the Databook.
            }
        }
        register SD_STATUS_L1LTSSM_REG @'hb4 {
            bytes 4;
            field FRAMING_ERR_PTR @'h0 {
                bits 7;
                access ro;
                volatile 1
                hard_reset 'h0;
                doc {
                    First Framing Error Pointer.

Identifies the first Framing Error using the following encoding. The field contents are only valid value when FRAMING_ERR =1.

Received Unexpected Framing Token
 - 01h: When non- STP/SDP/IDL Token was received and it was not in TLP/DLLP reception
 - 02h: When current token was not a valid EDB token and previous token was an EDB. (128/256 bit controller only)
 - 03h: When SDP token was received but not expected. (128 bit & (x8 | x16) controller only)
 - 04h: When STP token was received but not expected. (128 bit & (x8 | x16) controller only)
 - 05h: When EDS token was expected but not received or whenever an EDS token was received but not expected.
 - 06h: When a framing error was detected in the deskew block while a packet has been in progress in token_finder.
Received Unexpected STP Token
 - 11h: When Framing CRC in STP token did not match
 - 12h: When Framing Parity in STP token did not match.
 - 13h: When Framing TLP Length in STP token was smaller than 5 DWORDs.
Received Unexpected Block
 - 21h: When Receiving an OS Block following SDS in Datastream state
 - 22h: When Data Block followed by OS Block different from SKP, EI, EIE in Datastream state
 - 23h: When Block with an undefined Block Type in Datastream state
 - 24h: When Data Stream without data over three cycles in Datastream state
 - 25h: When OS Block during Data Stream in Datastream state
 - 26h: When RxStatus Error was detected in Datastream state
 - 27h: When Not all active lanes receiving SKP OS starting at same cycle time in SKPOS state
 - 28h: When a 2-Block timeout occurs for SKP OS in SKPOS state
 - 29h: When Receiving consecutive OS Blocks within a Data Stream in SKPOS state
 - 2Ah: When Phy status error was detected in SKPOS state
 - 2Bh: When Not all active lanes receiving EIOS starting at same cycle time in EIOS state
 - 2Ch: When At least one Symbol from the first 4 Symbols is not EIOS Symbol in EIOS state (CX_NB=2 only)
 - 2Dh: When Not all active lanes receiving EIEOS starting at same cycle time in EIEOS state
 - 2Eh: When Not full 16 eieos symbols are received in EIEOS state
All other values not listed above are Reserved.

Note: This register field is sticky.
                }
            }
            field FRAMING_ERR @'h7 {
                access w1c;
                volatile 1
                hard_reset 'h0;
                doc {
                    Framing Error.

Indicates Framing Error detection status.
                }
            }
            field PIPE_POWER_DOWN @'h8 {
                bits 3;
                access ro;
                volatile 1
                hard_reset 'h0;
                doc {
                    PIPE:PowerDown.

Indicates PIPE PowerDown signal.

Note: This register field is sticky.
                }
            }
            field RSVDP_11 @'hb {
                bits 4;
                access ro;
                hard_reset 'h0;
                soft_reset 'h0;
                doc {
                    Reserved for future use.
                }
            }
            field LANE_REVERSAL @'hf {
                access ro;
                volatile 1
                hard_reset 'h0;
                doc {
                    Lane Reversal Operation.

Receiver detected lane reversal.

This field is only valid in the L0 LTSSM state.

Note: This register field is sticky.
                }
            }
            field LTSSM_VARIABLE @'h10 {
                bits 16;
                access ro;
                volatile 1
                hard_reset 'h0;
                doc {
                    LTSSM Variable.

Indicates internal LTSSM variables defined in the PCI Express Base Specification.

C-PCIe Mode:
 - 0: directed_speed_change
 - 1: changed_speed_recovery
 - 2: successful_speed_negotiation
 - 3: upconfigure_capable; Set to '1' if both ports advertised the UpConfigure capability in the last Config.Complete.
 - 4: select_deemphasis
 - 5: start_equalization_w_preset
 - 6: equalization_done_8GT_data_rate
 - 7: equalization_done_16GT_data_rate
 - 15:8: idle_to_rlock_transitioned
M-PCIe Mode:
 - 0: idle_to_recovery
 - 1: recovery_to_configuration
Note: This register field is sticky.
                }
            }
            doc {
                Silicon Debug Status(Layer1 LTSSM).
For more details, see the RAS DES section in the Core Operations chapter of the Databook.Silicon Debug Status(Layer1 LTSSM).
For more details, see the RAS DES section in the Core Operations chapter of the Databook.
            }
        }
        register SD_STATUS_PM_REG @'hb8 {
            bytes 4;
            field INTERNAL_PM_MSTATE @'h0 {
                bits 5;
                access ro;
                volatile 1
                hard_reset 'h0;
                doc {
                    Internal PM State(Master).

Indicates internal state machine of Power Management Master controller.
 - 00h: IDLE
 - 01h: L0
 - 02h: L0S
 - 03h: ENTER_L0S
 - 04h: L0S_EXIT
 - 05h: WAIT_PMCSR_CPL_SENT
 - 08h: L1
 - 09h: L1_BLOCK_TLP
 - 0Ah: L1_WAIT_LAST_TLP_ACK
 - 0Bh: L1_WAIT_PMDLLP_ACK
 - 0Ch: L1_LINK_ENTR_L1
 - 0Dh: L1_EXIT
 - 0Fh: PREP_4L1
 - 10h: L23_BLOCK_TLP
 - 11h: L23_WAIT_LAST_TLP_ACK
 - 12h: L23_WAIT_PMDLLP_ACK
 - 13h: L23_ENTR_L23
 - 14h: L23RDY
 - 15h: PREP_4L23
 - 16h: L23RDY_WAIT4ALIVE
 - 17h: L0S_BLOCK_TLP
 - 18h: WAIT_LAST_PMDLLP
 - 19h: WAIT_DSTATE_UPDATE
Note: This register field is sticky.
                }
            }
            field RSVDP_5 @'h5 {
                bits 3;
                access ro;
                hard_reset 'h0;
                soft_reset 'h0;
                doc {
                    Reserved for future use.
                }
            }
            field INTERNAL_PM_SSTATE @'h8 {
                bits 4;
                access ro;
                volatile 1
                hard_reset 'h0;
                doc {
                    Internal PM State(Slave).

Indicates internal state machine of Power Management Slave controller.
 - 0h: S_IDLE
 - 1h: S_RESPOND_NAK
 - 2h: S_BLOCK_TLP
 - 3h: S_WAIT_LAST_TLP_ACK
 - 4h: S_WAIT_EIDLE
 - 5h: S_LINK_ENTR_L1
 - 6h: S_L1
 - 7h: S_L1_EXIT
 - 8h: S_L23RDY
 - 9h: S_LINK_ENTR_L23
 - Ah: S_L23RDY_WAIT4ALIVE
 - Bh: S_ACK_WAIT4IDLE
 - Ch: S_WAIT_LAST_PMDLLP
Note: This register field is sticky.
                }
            }
            field PME_RESEND_FLAG @'hc {
                access w1c;
                volatile 1
                hard_reset 'h0;
                doc {
                    PME Re-send flag.

When the DUT sends a PM_PME message TLP, the DUT sets PME_Status bit. If host software does not clear PME_Status bit for 100ms(+50%/-5%), the DUT resends the PM_PME Message. This bit indicates that a PM_PME was resent.
                }
            }
            field LATCHED_NFTS @'h10 {
                bits 8;
                access ro;
                volatile 1
                hard_reset 'h0;
                doc {
                    Latched N_FTS.

Indicates the value of N_FTS in the received TS Ordered Sets from the Link Partner

Note: This register field is sticky.
                }
            }
            field RSVDP_24 @'h18 {
                bits 8;
                access ro;
                hard_reset 'h0;
                soft_reset 'h0;
                doc {
                    Reserved for future use.
                }
            }
            doc {
                Silicon Debug Status(PM).
For more details, see the RAS DES section in the Core Operations chapter of the Databook.Silicon Debug Status(PM).
For more details, see the RAS DES section in the Core Operations chapter of the Databook.
            }
        }
        register SD_STATUS_L2_REG @'hbc {
            bytes 4;
            field TX_TLP_SEQ_NO @'h0 {
                bits 12;
                access ro;
                volatile 1
                hard_reset 'h0;
                doc {
                    Tx Tlp Sequence Number.

Indicates next transmit sequence number for transmit TLP.

Note: This register field is sticky.
                }
            }
            field RX_ACK_SEQ_NO @'hc {
                bits 12;
                access ro;
                volatile 1
                hard_reset 'h0;
                doc {
                    Tx Ack Sequence Number.

Indicates ACKD_SEQ which is updated by receiving ACK/NAK DLLP.

Note: This register field is sticky.
                }
            }
            field DLCMSM @'h18 {
                bits 2;
                access ro;
                volatile 1
                hard_reset 'h0;
                doc {
                    DLCMSM.

Indicates the current DLCMSM.
 - 00b: DL_INACTIVE
 - 01b: DL_FC_INIT
 - 11b: DL_ACTIVE
Note: This register field is sticky.
                }
            }
            field FC_INIT1 @'h1a {
                access ro;
                volatile 1
                hard_reset 'h0;
                doc {
                    FC_INIT1.

Indicates the controller is in FC_INIT1(VC0) state.

Note: This register field is sticky.
                }
            }
            field FC_INIT2 @'h1b {
                access ro;
                volatile 1
                hard_reset 'h0;
                doc {
                    FC_INIT2.
Indicates the controller is in FC_INIT2(VC0) state.

Note: This register field is sticky.
                }
            }
            field RSVDP_28 @'h1c {
                bits 4;
                access ro;
                hard_reset 'h0;
                soft_reset 'h0;
                doc {
                    Reserved for future use.
                }
            }
            doc {
                Silicon Debug Status(Layer2).
For more details, see the RAS DES section in the Core Operations chapter of the Databook.Silicon Debug Status(Layer2).
For more details, see the RAS DES section in the Core Operations chapter of the Databook.
            }
        }
        register SD_STATUS_L3FC_REG @'hc0 {
            bytes 4;
            field CREDIT_SEL_VC @'h0 {
                bits 3;
                access rw;
                hard_reset 'h0;
                doc {
                    Credit Select(VC).

This field in conjunction with the CREDIT_SEL_CREDIT_TYPE, CREDIT_SEL_TLP_TYPE, and CREDIT_SEL_HD viewport-select fields determines that data that is returned by the CREDIT_DATA0 and CREDIT_DATA1 data fields.
 - 0x0: VC0
 - 0x1: VC1
 - 0x2: VC2
 - ..
 - 0x7: VC7
Note: This register field is sticky.
                }
            }
            field CREDIT_SEL_CREDIT_TYPE @'h3 {
                access rw;
                hard_reset 'h0;
                doc {
                    Credit Select(Credit Type).

This field in conjunction with the CREDIT_SEL_VC, CREDIT_SEL_TLP_TYPE, and CREDIT_SEL_HD viewport-select fields determines that data that is returned by the CREDIT_DATA0 and CREDIT_DATA1 data fields.
 - 0x0: Rx
 - 0x1: Tx
Note: This register field is sticky.
                }
            }
            field CREDIT_SEL_TLP_TYPE @'h4 {
                bits 2;
                access rw;
                hard_reset 'h0;
                doc {
                    Credit Select(TLP Type).

This field in conjunction with the CREDIT_SEL_VC, CREDIT_SEL_CREDIT_TYPE, and CREDIT_SEL_HD viewport-select fields determines that data that is returned by the CREDIT_DATA0 and CREDIT_DATA1 data fields.
 - 0x0: Posted
 - 0x1: Non-Posted
 - 0x2: Completion
Note: This register field is sticky.
                }
            }
            field CREDIT_SEL_HD @'h6 {
                access rw;
                hard_reset 'h0;
                doc {
                    Credit Select(HeaderData).

This field in conjunction with the CREDIT_SEL_VC, CREDIT_SEL_CREDIT_TYPE, and CREDIT_SEL_TLP_TYPE viewport-select fields determines that data that is returned by the CREDIT_DATA0 and CREDIT_DATA1 data fields.
 - 0x0: Header Credit
 - 0x1: Data Credit
Note: This register field is sticky.
                }
            }
            field RSVDP_7 @'h7 {
                access ro;
                hard_reset 'h0;
                soft_reset 'h0;
                doc {
                    Reserved for future use.
                }
            }
            field CREDIT_DATA0 @'h8 {
                bits 12;
                access ro;
                volatile 1
                hard_reset 'h0;
                doc {
                    Credit Data0.

Current FC credit data selected by the CREDIT_SEL_VC, CREDIT_SEL_CREDIT_TYPE, CREDIT_SEL_TLP_TYPE, and CREDIT_SEL_HD viewport-select fields.
 - Rx: Credit Received Value
 - Tx: Credit Consumed Value
Note: This register field is sticky.
                }
            }
            field CREDIT_DATA1 @'h14 {
                bits 12;
                access ro;
                volatile 1
                hard_reset 'h0;
                doc {
                    Credit Data1.

Current FC credit data selected by the CREDIT_SEL_VC, CREDIT_SEL_CREDIT_TYPE, CREDIT_SEL_TLP_TYPE, and CREDIT_SEL_HD viewport-select fields.
 - Rx: Credit Allocated Value
 - Tx: Credit Limit Value. This value is valid when DLCMSM=0x3(DL_ACTIVE).
Note: This register field is sticky.
                }
            }
            doc {
                Silicon Debug Status(Layer3 FC).
The CREDIT_DATA[0/1] fields in this viewport register return the data for the VC and TLP Type selected by the following fields:
 - CREDIT_SEL_VC
 - CREDIT_SEL_CREDIT_TYPE
 - CREDIT_SEL_TLP_TYPE
 - CREDIT_SEL_HD
For more details, see the RAS DES section in the Core Operations chapter of the Databook.Silicon Debug Status(Layer3 FC).
The CREDIT_DATA[0/1] fields in this viewport register return the data for the VC and TLP Type selected by the following fields:
 - CREDIT_SEL_VC
 - CREDIT_SEL_CREDIT_TYPE
 - CREDIT_SEL_TLP_TYPE
 - CREDIT_SEL_HD
For more details, see the RAS DES section in the Core Operations chapter of the Databook.
            }
        }
        register SD_STATUS_L3_REG @'hc4 {
            bytes 4;
            field MFTLP_POINTER @'h0 {
                bits 7;
                access ro;
                volatile 1
                hard_reset 'h0;
                doc {
                    First Malformed TLP Error Pointer.

Indicates the element of the received first malformed TLP. This pointer is validated by MFTLP_STATUS.
 - 01h: AtomicOp address alignment
 - 02h: AtomicOp operand
 - 03h: AtomicOp  byte enable
 - 04h: TLP length miss match
 - 05h: Max payload size
 - 06h: Message TLP without TC0
 - 07h: Invalid TC
 - 08h: Unexpected route bit in Message TLP
 - 09h: Unexpected CRS status in Completion TLP
 - 0Ah: Byte enable
 - 0Bh: Memory Address 4KB boundary
 - 0Ch: TLP prefix rules
 - 0Dh: Translation request rules
 - 0Eh: Invalid TLP type
 - 0Fh: Completion rules
 - 7Fh: Application
 - Else: Reserved
Note: This register field is sticky.
                }
            }
            field MFTLP_STATUS @'h7 {
                access w1c;
                volatile 1
                hard_reset 'h0;
                doc {
                    Malformed TLP Status.

Indicates malformed TLP has occurred.
                }
            }
            field RSVDP_8 @'h8 {
                bits 24;
                access ro;
                hard_reset 'h0;
                soft_reset 'h0;
                doc {
                    Reserved for future use.
                }
            }
            doc {
                Silicon Debug Status(Layer3).
For more details, see the RAS DES section in the Core Operations chapter of the Databook.Silicon Debug Status(Layer3).
For more details, see the RAS DES section in the Core Operations chapter of the Databook.
            }
        }
        register SD_EQ_CONTROL1_REG @'hd0 {
            bytes 4;
            field EQ_LANE_SEL @'h0 {
                bits 4;
                access rw;
                hard_reset 'h0;
                doc {
                    EQ Status Lane Select.

Setting this field in conjunction with the EQ_RATE_SEL field determines the per-lane Silicon Debug EQ Status data returned by the SD_EQ_CONTROL[2/3] and SD_EQ_STATUS[1/2/3] viewport registers.
 - 0x0: Lane0
 - 0x1: Lane1
 - 0x2: Lane2
 - ..
 - 0xF: Lane15
Note: This register field is sticky.
                }
            }
            field EQ_RATE_SEL @'h4 {
                access rw;
                hard_reset 'h0;
                doc {
                    EQ Status Rate Select.

Setting this field in conjunction with the EQ_LANE_SEL field determines the per-lane Silicon Debug EQ Status data returned by the SD_EQ_CONTROL[2/3] and SD_EQ_STATUS[1/2/3] viewport registers.
 - 0x0: 8.0GT/s Speed
 - 0x1: 16.0GT/s Speed
Note: This register field is sticky.
                }
            }
            field RSVDP_5 @'h5 {
                bits 3;
                access ro;
                hard_reset 'h0;
                soft_reset 'h0;
                doc {
                    Reserved for future use.
                }
            }
            field EXT_EQ_TIMEOUT @'h8 {
                bits 2;
                access rw;
                hard_reset 'h0;
                doc {
                    Extends EQ Phase2/3 Timeout.

This field is used when the Ltssm is in Recovery.EQ2/3. When this field is set, the value of EQ2/3 timeout is extended.
EQ Master(DSP in EQ Phase3/USP in EQ Phase2).
 - 00: 24ms (default)
 - 01: 48ms (x2)
 - 10: 240ms (x10)
 - 11: No timeout

EQ Slave(DSP in EQ Phase2/USP in EQ Phase3).
 - 00: 32ms (default)
 - 01: 56ms (32ms+24ms)
 - 10: 248ms (32ms +9*24ms)
 - 11: No timeout
Note: This register field is sticky.
                }
            }
            field RSVDP_10 @'ha {
                bits 6;
                access ro;
                hard_reset 'h0;
                soft_reset 'h0;
                doc {
                    Reserved for future use.
                }
            }
            field EVAL_INTERVAL_TIME @'h10 {
                bits 2;
                access rw;
                hard_reset 'h0;
                doc {
                    Eval Interval Time.

Indicates interval time of RxEqEval assertion.
 - 00: 500ns
 - 01: 1us
 - 10: 2us
 - 11: 4us
This field is used for EQ Master(DSP in EQ Phase3/USP in EQ Phase2).

Note: This register field is sticky.
                }
            }
            field RSVDP_18 @'h12 {
                bits 5;
                access ro;
                hard_reset 'h0;
                soft_reset 'h0;
                doc {
                    Reserved for future use.
                }
            }
            field FOM_TARGET_ENABLE @'h17 {
                access rw;
                hard_reset 'h0;
                doc {
                    FOM Target Enable.

Enables the FOM_TARGET fields.

Note: This register field is sticky.
                }
            }
            field FOM_TARGET @'h18 {
                bits 8;
                access rw;
                hard_reset 'h0;
                doc {
                    FOM Target.

Indicates figure of merit target criteria value of EQ Master(DSP in EQ Phase3/USP in EQ Phase2).

This field is only valid when GEN3_EQ_FB_MODE is 0001b(Figure Of Merit).

Note: This register field is sticky.
                }
            }
            doc {
                Silicon Debug EQ Control 1.
This is a viewport control register. Setting the EQ_RATE_SEL and EQ_LANE_SEL fields in this register determine the per-lane Silicon Debug EQ Status data returned by the SD_EQ_STATUS[1/2/3] viewport registers.
For more details, see the RAS DES section in the Core Operations chapter of the Databook.Silicon Debug EQ Control 1.
This is a viewport control register. Setting the EQ_RATE_SEL and EQ_LANE_SEL fields in this register determine the per-lane Silicon Debug EQ Status data returned by the SD_EQ_STATUS[1/2/3] viewport registers.
For more details, see the RAS DES section in the Core Operations chapter of the Databook.
            }
        }
        register SD_EQ_CONTROL2_REG @'hd4 {
            bytes 4;
            field FORCE_LOCAL_TX_PRE_CURSOR @'h0 {
                bits 6;
                access rw;
                volatile 1
                hard_reset 'h0;
                doc {
                    Force Local Transmitter Pre-cursor.

Indicates the coefficient value of EQ Slave(DSP in EQ Phase2/USP in EQ Phase3), instead of the value instructed from link partner.

Note: This register field is sticky.
                }
            }
            field FORCE_LOCAL_TX_CURSOR @'h6 {
                bits 6;
                access rw;
                volatile 1
                hard_reset 'h0;
                doc {
                    Force Local Transmitter Cursor.

Indicates the coefficient value of EQ Slave(DSP in EQ Phase2/USP in EQ Phase3), instead of the value instructed from link partner.

Note: This register field is sticky.
                }
            }
            field FORCE_LOCAL_TX_POST_CURSOR @'hc {
                bits 6;
                access rw;
                volatile 1
                hard_reset 'h0;
                doc {
                    Force Local Transmitter Post-Cursor.

Indicates the coefficient value of EQ Slave(DSP in EQ Phase2/USP in EQ Phase3), instead of the value instructed from link partner.

Note: This register field is sticky.
                }
            }
            field FORCE_LOCAL_RX_HINT @'h12 {
                bits 3;
                access rw;
                volatile 1
                hard_reset 'h0;
                doc {
                    Force Local Receiver Preset Hint.

Indicates the RxPresetHint value of EQ Slave(DSP in EQ Phase2/USP in EQ Phase3), instead of received or set value.

Note: This register field is sticky.
                }
            }
            field RSVDP_21 @'h15 {
                bits 3;
                access ro;
                hard_reset 'h0;
                soft_reset 'h0;
                doc {
                    Reserved for future use.
                }
            }
            field FORCE_LOCAL_TX_PRESET @'h18 {
                bits 4;
                access rw;
                volatile 1
                hard_reset 'h0;
                doc {
                    Force Local Transmitter Preset.

Indicates initial preset value of USP in EQ Slave(EQ Phase2) instead of receiving EQ TS2.

Note: This register field is sticky.
                }
            }
            field FORCE_LOCAL_TX_COEF_ENABLE @'h1c {
                access rw;
                volatile 1
                hard_reset 'h0;
                doc {
                    Force Local Transmitter Coefficient Enable.

Enables the following fields:
 - FORCE_LOCAL_TX_PRE_CURSOR
 - FORCE_LOCAL_TX_CURSOR
 - FORCE_LOCAL_TX_POST_CURSOR
Note: This register field is sticky.
                }
            }
            field FORCE_LOCAL_RX_HINT_ENABLE @'h1d {
                access rw;
                volatile 1
                hard_reset 'h0;
                doc {
                    Force Local Receiver Preset Hint Enable.

Enables the FORCE_LOCAL_RX_HINT field.

Note: This register field is sticky.
                }
            }
            field FORCE_LOCAL_TX_PRESET_ENABLE @'h1e {
                access rw;
                volatile 1
                hard_reset 'h0;
                doc {
                    Force Local Transmitter Preset Enable.

Enables the FORCE_LOCAL_TX_PRESET field.

Note: This register field is sticky.
                }
            }
            field RSVDP_31 @'h1f {
                access ro;
                hard_reset 'h0;
                soft_reset 'h0;
                doc {
                    Reserved for future use.
                }
            }
            doc {
                Silicon Debug EQ Control 2.
This viewport register returns the value for the rate and lane selected by the EQ_RATE_SEL and EQ_LANE_SEL fields in the SD_EQ_CONTROL1_REG register.
For more details, see the RAS DES section in the Core Operations chapter of the Databook.Silicon Debug EQ Control 2.
This viewport register returns the value for the rate and lane selected by the EQ_RATE_SEL and EQ_LANE_SEL fields in the SD_EQ_CONTROL1_REG register.
For more details, see the RAS DES section in the Core Operations chapter of the Databook.
            }
        }
        register SD_EQ_CONTROL3_REG @'hd8 {
            bytes 4;
            field FORCE_REMOTE_TX_PRE_CURSOR @'h0 {
                bits 6;
                access rw;
                volatile 1
                hard_reset 'h0;
                doc {
                    Force Remote Transmitter Pre-Cursor.

Indicates the coefficient value of EQ Master(DSP in EQ Phase3/USP in EQ Phase2), instead of the value instructed from link partner.

Note: This register field is sticky.
                }
            }
            field FORCE_REMOTE_TX_CURSOR @'h6 {
                bits 6;
                access rw;
                volatile 1
                hard_reset 'h0;
                doc {
                    Force Remote Transmitter Cursor.

Indicates the coefficient value of EQ Master(DSP in EQ Phase3/USP in EQ Phase2), instead of the value instructed from link partner.

Note: This register field is sticky.
                }
            }
            field FORCE_REMOTE_TX_POST_CURSOR @'hc {
                bits 6;
                access rw;
                volatile 1
                hard_reset 'h0;
                doc {
                    Force Remote Transmitter Post-Cursor.

Indicates the coefficient value of EQ Master(DSP in EQ Phase3/USP in EQ Phase2), instead of the value instructed from link partner.

Note: This register field is sticky.
                }
            }
            field RSVDP_18 @'h12 {
                bits 10;
                access ro;
                hard_reset 'h0;
                soft_reset 'h0;
                doc {
                    Reserved for future use.
                }
            }
            field FORCE_REMOTE_TX_COEF_ENABLE @'h1c {
                access rw;
                volatile 1
                hard_reset 'h0;
                doc {
                    Force Remote Transmitter Coefficient Enable.

Enables the following fields:
 - FORCE_REMOTE_TX_PRE_CURSOR
 - FORCE_REMOTE_TX_CURSOR
 - FORCE_REMOTE_TX_POST_CURSOR
Note: This register field is sticky.
                }
            }
            field RSVDP_29 @'h1d {
                bits 3;
                access ro;
                hard_reset 'h0;
                soft_reset 'h0;
                doc {
                    Reserved for future use.
                }
            }
            doc {
                Silicon Debug EQ Control 3.
This viewport register returns the value for the rate and lane selected by the EQ_RATE_SEL and EQ_LANE_SEL fields in the SD_EQ_CONTROL1_REG register.
For more details, see the RAS DES section in the Core Operations chapter of the Databook.Silicon Debug EQ Control 3.
This viewport register returns the value for the rate and lane selected by the EQ_RATE_SEL and EQ_LANE_SEL fields in the SD_EQ_CONTROL1_REG register.
For more details, see the RAS DES section in the Core Operations chapter of the Databook.
            }
        }
        register SD_EQ_STATUS1_REG @'he0 {
            bytes 4;
            field EQ_SEQUENCE @'h0 {
                access ro;
                volatile 1
                hard_reset 'h0;
                doc {
                    EQ Sequence.

Indicates that the controller is starting the equalization sequence.

Note: This register field is sticky.
                }
            }
            field EQ_CONVERGENCE_INFO @'h1 {
                bits 2;
                access ro;
                volatile 1
                hard_reset 'h0;
                doc {
                    EQ Convergence Info.

Indicates equalization convergence information.
 - 0x0: Equalization is not attempted
 - 0x1: Equalization finished successfully
 - 0x2: Equalization finished unsuccessfully
 - 0x3: Reserved
This bit is automatically cleared when the controller starts EQ Master phase again.

Note: This register field is sticky.
                }
            }
            field RSVDP_3 @'h3 {
                access ro;
                hard_reset 'h0;
                soft_reset 'h0;
                doc {
                    Reserved for future use.
                }
            }
            field EQ_RULEA_VIOLATION @'h4 {
                access ro;
                volatile 1
                hard_reset 'h0;
                doc {
                    EQ Rule A Violation.

Indicates that coefficients rule A violation is detected in the values provided by PHY using direction change method during EQ Master phase(DSP in EQ Phase3/USP in EQ Phase2). The coefficients rules A correspond to the rules a) from section "Rules for Transmitter Coefficents" in the PCI Express Base Specification.

This bit is automatically cleared when the controller starts EQ Master phase again.

Note: This register field is sticky.
                }
            }
            field EQ_RULEB_VIOLATION @'h5 {
                access ro;
                volatile 1
                hard_reset 'h0;
                doc {
                    EQ Rule B Violation.

Indicates that coefficients rule B violation is detected in the values provided by PHY using direction change method during EQ Master phase(DSP in EQ Phase3/USP in EQ Phase2). The coefficients rules B correspond to the rules b) from section "Rules for Transmitter Coefficents" in the PCI Express Base Specification.

This bit is automatically cleared when the controller starts EQ Master phase again.

Note: This register field is sticky.
                }
            }
            field EQ_RULEC_VIOLATION @'h6 {
                access ro;
                volatile 1
                hard_reset 'h0;
                doc {
                    EQ Rule C Violation.

Indicates that coefficients rule C violation is detected in the values provided by PHY using direction change method during EQ Master phase(DSP in EQ Phase3/USP in EQ Phase2). The coefficients rule C  correspond to the rules c) from section "Rules for Transmitter Coefficents" in the PCI Express Base Specification.

This bit is automatically cleared when the controller starts EQ Master phase again.

Note: This register field is sticky.
                }
            }
            field EQ_REJECT_EVENT @'h7 {
                access ro;
                volatile 1
                hard_reset 'h0;
                doc {
                    EQ Reject Event.

Indicates that the controller receives two consecutive TS1 OS w/Reject=1b during EQ Master phase(DSP in EQ Phase3/USP in EQ Phase2).
This bit is automatically cleared when the controller starts EQ Master phase again.

Note: This register field is sticky.
                }
            }
            field RSVDP_8 @'h8 {
                bits 24;
                access ro;
                hard_reset 'h0;
                soft_reset 'h0;
                doc {
                    Reserved for future use.
                }
            }
            doc {
                Silicon Debug EQ Status 1.
This viewport register returns the first of three words of Silicon Debug EQ Status data for the rate and lane selected by the EQ_RATE_SEL and EQ_LANE_SEL fields in the SD_EQ_CONTROL1_REG register.
The following fields are available when Equalization finished unsuccessfully(EQ_CONVERGENCE_INFO=2).
 - EQ_RULEA_VIOLATION
 - EQ_RULEB_VIOLATION
 - EQ_RULEC_VIOLATION
 - EQ_REJECT_EVENT
For more details, see the RAS DES section in the Core Operations chapter of the Databook.Silicon Debug EQ Status 1.
This viewport register returns the first of three words of Silicon Debug EQ Status data for the rate and lane selected by the EQ_RATE_SEL and EQ_LANE_SEL fields in the SD_EQ_CONTROL1_REG register.
The following fields are available when Equalization finished unsuccessfully(EQ_CONVERGENCE_INFO=2).
 - EQ_RULEA_VIOLATION
 - EQ_RULEB_VIOLATION
 - EQ_RULEC_VIOLATION
 - EQ_REJECT_EVENT
For more details, see the RAS DES section in the Core Operations chapter of the Databook.
            }
        }
        register SD_EQ_STATUS2_REG @'he4 {
            bytes 4;
            field EQ_LOCAL_PRE_CURSOR @'h0 {
                bits 6;
                access ro;
                volatile 1
                hard_reset 'h0;
                doc {
                    EQ Local Pre-Cursor.

Indicates Local pre cursor coefficient value.

Note: This register field is sticky.
                }
            }
            field EQ_LOCAL_CURSOR @'h6 {
                bits 6;
                access ro;
                volatile 1
                hard_reset 'h0;
                doc {
                    EQ Local Cursor.

Indicates Local cursor coefficient value.

Note: This register field is sticky.
                }
            }
            field EQ_LOCAL_POST_CURSOR @'hc {
                bits 6;
                access ro;
                volatile 1
                hard_reset 'h0;
                doc {
                    EQ Local Post-Cursor.

Indicates Local post cursor coefficient value.

Note: This register field is sticky.
                }
            }
            field EQ_LOCAL_RX_HINT @'h12 {
                bits 3;
                access ro;
                volatile 1
                hard_reset 'h0;
                doc {
                    EQ Local Receiver Preset Hint.

Indicates Local Receiver Preset Hint value.

Note: This register field is sticky.
                }
            }
            field RSVDP_21 @'h15 {
                bits 3;
                access ro;
                hard_reset 'h0;
                soft_reset 'h0;
                doc {
                    Reserved for future use.
                }
            }
            field EQ_LOCAL_FOM_VALUE @'h18 {
                bits 8;
                access ro;
                volatile 1
                hard_reset 'h0;
                doc {
                    EQ Local Figure of Merit.

Indicates Local maximum Figure of Merit value.

Note: This register field is sticky.
                }
            }
            doc {
                Silicon Debug EQ Status 2.
This viewport register returns the second of three words of Silicon Debug EQ Status data for the rate and lane selected by the EQ_RATE_SEL and EQ_LANE_SEL fields in the SD_EQ_CONTROL1_REG register.
Each field is available when Equalization finished successfully(EQ_CONVERGENCE_INFO=1).
For more details, see the RAS DES section in the Core Operations chapter of the Databook.Silicon Debug EQ Status 2.
This viewport register returns the second of three words of Silicon Debug EQ Status data for the rate and lane selected by the EQ_RATE_SEL and EQ_LANE_SEL fields in the SD_EQ_CONTROL1_REG register.
Each field is available when Equalization finished successfully(EQ_CONVERGENCE_INFO=1).
For more details, see the RAS DES section in the Core Operations chapter of the Databook.
            }
        }
        register SD_EQ_STATUS3_REG @'he8 {
            bytes 4;
            field EQ_REMOTE_PRE_CURSOR @'h0 {
                bits 6;
                access ro;
                volatile 1
                hard_reset 'h0;
                doc {
                    EQ Remote Pre-Cursor.

Indicates Remote pre cursor coefficient value.

Note: This register field is sticky.
                }
            }
            field EQ_REMOTE_CURSOR @'h6 {
                bits 6;
                access ro;
                volatile 1
                hard_reset 'h0;
                doc {
                    EQ Remote Cursor.

Indicates Remote cursor coefficient value.

Note: This register field is sticky.
                }
            }
            field EQ_REMOTE_POST_CURSOR @'hc {
                bits 6;
                access ro;
                volatile 1
                hard_reset 'h0;
                doc {
                    EQ Remote Post-Cursor.

Indicates Remote post cursor coefficient value.

Note: This register field is sticky.
                }
            }
            field EQ_REMOTE_LF @'h12 {
                bits 6;
                access ro;
                volatile 1
                hard_reset 'h0;
                doc {
                    EQ Remote LF.

Indicates Remote LF value.

Note: This register field is sticky.
                }
            }
            field EQ_REMOTE_FS @'h18 {
                bits 6;
                access ro;
                volatile 1
                hard_reset 'h0;
                doc {
                    EQ Remote FS.

Indicates Remote FS value.

Note: This register field is sticky.
                }
            }
            field RSVDP_30 @'h1e {
                bits 2;
                access ro;
                hard_reset 'h0;
                soft_reset 'h0;
                doc {
                    Reserved for future use.
                }
            }
            doc {
                Silicon Debug EQ Status 3.
This viewport register returns the third of three words of Silicon Debug EQ Status data for the rate and lane selected by the EQ_RATE_SEL and EQ_LANE_SEL fields in the SD_EQ_CONTROL1_REG register.
Each field is available when Equalization finished successfully(EQ_CONVERGENCE_INFO=1).
For more details, see the RAS DES section in the Core Operations chapter of the Databook.Silicon Debug EQ Status 3.
This viewport register returns the third of three words of Silicon Debug EQ Status data for the rate and lane selected by the EQ_RATE_SEL and EQ_LANE_SEL fields in the SD_EQ_CONTROL1_REG register.
Each field is available when Equalization finished successfully(EQ_CONVERGENCE_INFO=1).
For more details, see the RAS DES section in the Core Operations chapter of the Databook.
            }
        }
        doc {
            RAS D.E.S. Capability Structure (VSEC)
        }
    }
    block PF0_VSECRAS_CAP @'h2fc {
        bytes 4;
        register RASDP_EXT_CAP_HDR_OFF @'h0 {
            bytes 4;
            field ID @'h0 {
                bits 16;
                access ro;
                hard_reset 'h0;
                doc {
                    PCI Express Extended Capability ID.
For a description of this standard PCIe register, see the PCI Express Specification.

Note: The access attributes of this field are as follows:
 - Wire: R (sticky) 
 - Dbi: if (DBI_RO_WR_EN == 1) then R/W(sticky) else R(sticky) 
Note: This register field is sticky.
                }
            }
            field CAP @'h10 {
                bits 4;
                access ro;
                hard_reset 'h0;
                doc {
                    Capability Version.
For a description of this standard PCIe register, see the PCI Express Specification.

Note: The access attributes of this field are as follows:
 - Wire: R (sticky) 
 - Dbi: if (DBI_RO_WR_EN == 1) then R/W(sticky) else R(sticky) 
Note: This register field is sticky.
                }
            }
            field NEXT_OFFSET @'h14 {
                bits 12;
                access ro;
                hard_reset 'h0;
                doc {
                    Next Capability Offset.
For a description of this standard PCIe register, see the PCI Express Specification.

Note: The access attributes of this field are as follows:
 - Wire: R (sticky) 
 - Dbi: if (DBI_RO_WR_EN == 1) then R/W(sticky) else R(sticky) 
Note: This register field is sticky.
                }
            }
            doc {
                PCIe Extended capability ID, Capability version and Next capability offset.
For a description of this standard PCIe register, see the PCI Express Specification.PCIe Extended capability ID, Capability version and Next capability offset.
For a description of this standard PCIe register, see the PCI Express Specification.
            }
        }
        register RASDP_VENDOR_SPECIFIC_HDR_OFF @'h4 {
            bytes 4;
            field VSEC_ID @'h0 {
                bits 16;
                access ro;
                hard_reset 'h0;
                doc {
                    VSEC ID.
For a description of this standard PCIe register, see the PCI Express Specification.

Note: This register field is sticky.
                }
            }
            field VSEC_REV @'h10 {
                bits 4;
                access ro;
                hard_reset 'h0;
                doc {
                    VSEC Rev.
For a description of this standard PCIe register, see the PCI Express Specification.

Note: This register field is sticky.
                }
            }
            field VSEC_LENGTH @'h14 {
                bits 12;
                access ro;
                hard_reset 'h0;
                doc {
                    VSEC Length.
For a description of this standard PCIe register, see the PCI Express Specification.

Note: This register field is sticky.
                }
            }
            doc {
                Vendor Specific Header.
For a description of this standard PCIe register, see the PCI Express Specification.Vendor Specific Header.
For a description of this standard PCIe register, see the PCI Express Specification.
            }
        }
        register RASDP_ERROR_PROT_CTRL_OFF @'h8 {
            bytes 4;
            field ERROR_PROT_DISABLE_TX @'h0 {
                access rw;
                hard_reset 'h0;
                doc {
                    Global error correction disable for all Tx layers. Does not disable the error detection reporting for 1-bit and 2-bit ECC errors.

Note: This register field is sticky.
                }
            }
            field ERROR_PROT_DISABLE_AXI_BRIDGE_MASTER @'h1 {
                access rw;
                hard_reset 'h0;
                doc {
                    Error correction disable for AXI bridge master completion buffer.

Note: This register field is sticky.
                }
            }
            field ERROR_PROT_DISABLE_AXI_BRIDGE_OUTBOUND @'h2 {
                access rw;
                hard_reset 'h0;
                doc {
                    Error correction disable for AXI bridge outbound request path.

Note: This register field is sticky.
                }
            }
            field ERROR_PROT_DISABLE_DMA_WRITE @'h3 {
                access rw;
                hard_reset 'h0;
                doc {
                    Error correction disable for DMA write engine.

Note: This register field is sticky.
                }
            }
            field ERROR_PROT_DISABLE_LAYER2_TX @'h4 {
                access rw;
                hard_reset 'h0;
                doc {
                    Error correction disable for layer 2 Tx path.

Note: This register field is sticky.
                }
            }
            field ERROR_PROT_DISABLE_LAYER3_TX @'h5 {
                access rw;
                hard_reset 'h0;
                doc {
                    Error correction disable for layer 3 Tx path.

Note: This register field is sticky.
                }
            }
            field ERROR_PROT_DISABLE_ADM_TX @'h6 {
                access rw;
                hard_reset 'h0;
                doc {
                    Error correction disable for Adm Tx path.

Note: This register field is sticky.
                }
            }
            field ERROR_PROT_DISABLE_CXS_TX @'h7 {
                access rw;
                hard_reset 'h0;
                doc {
                    Error correction disable for CXS Rx path (PCIe Tx path).

Note: This register field is sticky.
                }
            }
            field RSVDP_8 @'h8 {
                bits 8;
                access ro;
                hard_reset 'h0;
                soft_reset 'h0;
                doc {
                    Reserved for future use.
                }
            }
            field ERROR_PROT_DISABLE_RX @'h10 {
                access rw;
                hard_reset 'h0;
                doc {
                    Global error correction disable for all Rx layers.

Note: This register field is sticky.
                }
            }
            field ERROR_PROT_DISABLE_AXI_BRIDGE_INBOUND_COMPLETION @'h11 {
                access rw;
                hard_reset 'h0;
                doc {
                    Error correction disable for AXI bridge inbound completion composer. Does not disable the error detection reporting for 1-bit and 2-bit ECC errors.

Note: This register field is sticky.
                }
            }
            field ERROR_PROT_DISABLE_AXI_BRIDGE_INBOUND_REQUEST @'h12 {
                access rw;
                hard_reset 'h0;
                doc {
                    Error correction disable for AXI bridge inbound request path.

Note: This register field is sticky.
                }
            }
            field ERROR_PROT_DISABLE_DMA_READ @'h13 {
                access rw;
                hard_reset 'h0;
                doc {
                    Error correction disable for DMA read engine.

Note: This register field is sticky.
                }
            }
            field ERROR_PROT_DISABLE_LAYER2_RX @'h14 {
                access rw;
                hard_reset 'h0;
                doc {
                    Error correction disable for layer 2 Rx path.

Note: This register field is sticky.
                }
            }
            field ERROR_PROT_DISABLE_LAYER3_RX @'h15 {
                access rw;
                hard_reset 'h0;
                doc {
                    Error correction disable for layer 3 Rx path.

Note: This register field is sticky.
                }
            }
            field ERROR_PROT_DISABLE_ADM_RX @'h16 {
                access rw;
                hard_reset 'h0;
                doc {
                    Error correction disable for ADM Rx path.

Note: This register field is sticky.
                }
            }
            field ERROR_PROT_DISABLE_CXS_RX @'h17 {
                access rw;
                hard_reset 'h0;
                doc {
                    Error correction disable for CXS Tx path (PCIe Rx path).

Note: This register field is sticky.
                }
            }
            field RSVDP_24 @'h18 {
                bits 8;
                access ro;
                hard_reset 'h0;
                soft_reset 'h0;
                doc {
                    Reserved for future use.
                }
            }
            doc {
                ECC error correction control. Allows you to disable ECC error correction for RAMs and datapath.

When the AXI Bridge Module is implemented and the master / slave clocks are asynchronous to the PCIe native controller clock (core_clk), you must not write this register while operations are in progress in the AXI master / slave interface.ECC error correction control. Allows you to disable ECC error correction for RAMs and datapath.

When the AXI Bridge Module is implemented and the master / slave clocks are asynchronous to the PCIe native controller clock (core_clk), you must not write this register while operations are in progress in the AXI master / slave interface.
            }
        }
        register RASDP_CORR_COUNTER_CTRL_OFF @'hc {
            bytes 4;
            field CORR_CLEAR_COUNTERS @'h0 {
                access wo;
                volatile 1
                hard_reset 'h0;
                doc {
                    Clear all correctable error counters.
                }
            }
            field RSVDP_1 @'h1 {
                bits 3;
                access ro;
                hard_reset 'h0;
                soft_reset 'h0;
                doc {
                    Reserved for future use.
                }
            }
            field CORR_EN_COUNTERS @'h4 {
                access rw;
                hard_reset 'h0;
                doc {
                    Enable correctable errors counters.
 - 1: counters increment when the controller detects a correctable error
 - 0: counters are frozen
The counters are enabled by default.
                }
            }
            field RSVDP_5 @'h5 {
                bits 15;
                access ro;
                hard_reset 'h0;
                soft_reset 'h0;
                doc {
                    Reserved for future use.
                }
            }
            field CORR_COUNTER_SELECTION_REGION @'h14 {
                bits 4;
                access rw;
                hard_reset 'h0;
                doc {
                    Select correctable counter region:
 - 0x0: Region select for Adm Rx path
 - 0x1: Region select for layer 3 Rx path
 - 0x2: Region select for layer 2 Rx path
 - 0x3: Region select for DMA inbound path
 - 0x4: Region select for AXI bridge inbound request path
 - 0x5: Region select for AXI bridge inbound completion composer path
 - 0x6: Region select for Adm Tx path
 - 0x7: Region select for layer 3 Tx path
 - 0x8: Region select for layer 2 Tx path
 - 0x9: Region select for DMA outbound path
 - 0xa: Region select for AXI bridge outbound request path
 - 0xb: Region select for AXI bridge outbound master completion buffer path
 - 0xc: Reserved
 - 0xf: Reserved
                }
            }
            field CORR_COUNTER_SELECTION @'h18 {
                bits 8;
                access rw;
                hard_reset 'h0;
                doc {
                    Counter selection.
This field selects the counter ID (within the region defined by CORR_COUNTER_SELECTION_REGION) whose contents can be read from the RASDP_CORR_COUNT_REPORT_OFF register.
You can cycle this field value from 0 to 255 to access all counters according to the detailed report of check points at http://www.synopsys.com/dw/doc.php/iip/DWC_pcie/latest/doc/RASDP_CheckPoints.pdf
                }
            }
            doc {
                Corrected error (1-bit ECC) counter selection and control.
This is a viewport control register.
Setting the CORR_COUNTER_SELECTION_REGION and CORR_COUNTER_SELECTION fields in this register determine the counter data returned by the RASDP_CORR_COUNT_REPORT_OFF viewport data register.Corrected error (1-bit ECC) counter selection and control.
This is a viewport control register.
Setting the CORR_COUNTER_SELECTION_REGION and CORR_COUNTER_SELECTION fields in this register determine the counter data returned by the RASDP_CORR_COUNT_REPORT_OFF viewport data register.
            }
        }
        register RASDP_CORR_COUNT_REPORT_OFF @'h10 {
            bytes 4;
            field CORR_COUNTER @'h0 {
                bits 8;
                access ro;
                volatile 1
                hard_reset 'h0;
                doc {
                    Current corrected error count for the selected counter.
                }
            }
            field RSVDP_8 @'h8 {
                bits 12;
                access ro;
                hard_reset 'h0;
                soft_reset 'h0;
                doc {
                    Reserved for future use.
                }
            }
            field CORR_COUNTER_SELECTED_REGION @'h14 {
                bits 4;
                access ro;
                volatile 1
                hard_reset 'h0;
                doc {
                    Selected correctable counter region:
 - 0x0: Region select for Adm Rx path
 - 0x1: Region select for layer 3 Rx path
 - 0x2: Region select for layer 2 Rx path
 - 0x3: Region select for DMA inbound path
 - 0x4: Region select for AXI bridge inbound request path
 - 0x5: Region select for AXI bridge inbound completion composer path
 - 0x6: Region select for Adm Tx path
 - 0x7: Region select for layer 3 Tx path
 - 0x8: Region select for layer 2 Tx path
 - 0x9: Region select for DMA outbound path
 - 0xa: Region select for AXI bridge outbound request path
 - 0xb: Region select for AXI bridge outbound master completion buffer path
 - 0xc: Reserved
 - 0xf: Reserved
                }
            }
            field CORR_COUNTER_SELECTED @'h18 {
                bits 8;
                access ro;
                volatile 1
                hard_reset 'h0;
                doc {
                    Counter selection.
Returns the value set in the CORR_COUNTER_SELECTION field of the RASDP_CORR_COUNTER_CTRL_OFF register.
                }
            }
            doc {
                Corrected error (1-bit ECC) counter data.
This viewport register returns the counter data selected by the CORR_COUNTER_SELECTION_REGION and CORR_COUNTER_SELECTION fields in the RASDP_CORR_COUNTER_CTRL_OFF register.Corrected error (1-bit ECC) counter data.
This viewport register returns the counter data selected by the CORR_COUNTER_SELECTION_REGION and CORR_COUNTER_SELECTION fields in the RASDP_CORR_COUNTER_CTRL_OFF register.
            }
        }
        register RASDP_UNCORR_COUNTER_CTRL_OFF @'h14 {
            bytes 4;
            field UNCORR_CLEAR_COUNTERS @'h0 {
                access wo;
                volatile 1
                hard_reset 'h0;
                doc {
                    Clear uncorrectable errors counters.
When asserted causes all counters tracking the uncorrectable errors to be cleared.
                }
            }
            field RSVDP_1 @'h1 {
                bits 3;
                access ro;
                hard_reset 'h0;
                soft_reset 'h0;
                doc {
                    Reserved for future use.
                }
            }
            field UNCORR_EN_COUNTERS @'h4 {
                access rw;
                hard_reset 'h0;
                doc {
                    Enable uncorrectable errors counters.
 - 1: enables the counters to increment on detected correctable errors
 - 0: counters are frozen
The counters are enabled by default.
                }
            }
            field RSVDP_5 @'h5 {
                bits 15;
                access ro;
                hard_reset 'h0;
                soft_reset 'h0;
                doc {
                    Reserved for future use.
                }
            }
            field UNCORR_COUNTER_SELECTION_REGION @'h14 {
                bits 4;
                access rw;
                hard_reset 'h0;
                doc {
                    Select uncorrectable counter region:
 - 0x0: Region select for Adm Rx path
 - 0x1: Region select for layer 3 Rx path
 - 0x2: Region select for layer 2 Rx path
 - 0x3: Region select for DMA inbound path
 - 0x4: Region select for AXI bridge inbound request path
 - 0x5: Region select for AXI bridge inbound completion composer path
 - 0x6: Region select for Adm Tx path
 - 0x7: Region select for layer 3 Tx path
 - 0x8: Region select for layer 2 Tx path
 - 0x9: Region select for DMA outbound path
 - 0xa: Region select for AXI bridge outbound request path
 - 0xb: Region select for AXI bridge outbound master completion buffer path
 - 0xc: Reserved
 - 0xf: Reserved
                }
            }
            field UNCORR_COUNTER_SELECTION @'h18 {
                bits 8;
                access rw;
                hard_reset 'h0;
                doc {
                    Counter selection.
This field selects the counter ID (within the region defined by UNCORR_COUNTER_SELECTION_REGION) whose contents can be read from the RASDP_UNCORR_COUNT_REPORT_OFF register.
You can cycle this field value from 0 to 255 to access all counters according to the detailed report of check points at http://www.synopsys.com/dw/doc.php/iip/DWC_pcie/latest/doc/RASDP_CheckPoints.pdf
                }
            }
            doc {
                Uncorrected error (2-bit ECC and parity) counter selection and control.
This is a viewport control register.
Setting the UNCORR_COUNTER_SELECTION_REGION and UNCORR_COUNTER_SELECTION fields in this register determine the counter data returned by the RASDP_UNCORR_COUNT_REPORT_OFF viewport data register.Uncorrected error (2-bit ECC and parity) counter selection and control.
This is a viewport control register.
Setting the UNCORR_COUNTER_SELECTION_REGION and UNCORR_COUNTER_SELECTION fields in this register determine the counter data returned by the RASDP_UNCORR_COUNT_REPORT_OFF viewport data register.
            }
        }
        register RASDP_UNCORR_COUNT_REPORT_OFF @'h18 {
            bytes 4;
            field UNCORR_COUNTER @'h0 {
                bits 8;
                access ro;
                volatile 1
                hard_reset 'h0;
                doc {
                    Current uncorrected error count for the selected counter
                }
            }
            field RSVDP_8 @'h8 {
                bits 12;
                access ro;
                hard_reset 'h0;
                soft_reset 'h0;
                doc {
                    Reserved for future use.
                }
            }
            field UNCORR_COUNTER_SELECTED_REGION @'h14 {
                bits 4;
                access ro;
                volatile 1
                hard_reset 'h0;
                doc {
                    Selected uncorrectable counter region:
 - 0x0: Region select for Adm Rx path
 - 0x1: Region select for layer 3 Rx path
 - 0x2: Region select for layer 2 Rx path
 - 0x3: Region select for DMA inbound path
 - 0x4: Region select for AXI bridge inbound request path
 - 0x5: Region select for AXI bridge inbound completion composer path
 - 0x6: Region select for Adm Tx path
 - 0x7: Region select for layer 3 Tx path
 - 0x8: Region select for layer 2 Tx path
 - 0x9: Region select for DMA outbound path
 - 0xa: Region select for AXI bridge outbound request path
 - 0xb: Region select for AXI bridge outbound master completion buffer path
 - 0xc: Reserved
 - 0xf: Reserved
                }
            }
            field UNCORR_COUNTER_SELECTED @'h18 {
                bits 8;
                access ro;
                volatile 1
                hard_reset 'h0;
                doc {
                    Counter selection.
Returns the value set in the UNCORR_COUNTER_SELECTION field of the RASDP_UNCORR_COUNTER_CTRL_OFF register.
                }
            }
            doc {
                Uncorrected error (2-bit ECC and parity) counter data.
This viewport register returns the counter data selected by the UNCORR_COUNTER_SELECTION_REGION and UNCORR_COUNTER_SELECTION fields in the RASDP_UNCORR_COUNTER_CTRL_OFF register.Uncorrected error (2-bit ECC and parity) counter data.
This viewport register returns the counter data selected by the UNCORR_COUNTER_SELECTION_REGION and UNCORR_COUNTER_SELECTION fields in the RASDP_UNCORR_COUNTER_CTRL_OFF register.
            }
        }
        register RASDP_ERROR_INJ_CTRL_OFF @'h1c {
            bytes 4;
            field ERROR_INJ_EN @'h0 {
                access rw;
                hard_reset 'h0;
                doc {
                    Error injection global enable.
When set enables the error insertion logic.
                }
            }
            field RSVDP_1 @'h1 {
                bits 3;
                access ro;
                hard_reset 'h0;
                soft_reset 'h0;
                doc {
                    Reserved for future use.
                }
            }
            field ERROR_INJ_TYPE @'h4 {
                bits 2;
                access rw;
                hard_reset 'h0;
                doc {
                    Error injection type:
 - 0: none
 - 1: 1-bit
 - 2: 2-bit
                }
            }
            field RSVDP_6 @'h6 {
                bits 2;
                access ro;
                hard_reset 'h0;
                soft_reset 'h0;
                doc {
                    Reserved for future use.
                }
            }
            field ERROR_INJ_COUNT @'h8 {
                bits 8;
                access rw;
                hard_reset 'h0;
                doc {
                    Error injection count.
 - 0: errors are inserted in every TLP until you clear ERROR_INJ_EN.
 - 1: one errors injected
 - 2: two errors injected
 - n: amount of errors injected
                }
            }
            field ERROR_INJ_LOC @'h10 {
                bits 8;
                access rw;
                hard_reset 'h0;
                doc {
                    Error injection location.
Selects where error injection takes place.
You can cycle this field value from 0 to 255 to access all locations according to the detailed report of check points at http://www.synopsys.com/dw/doc.php/iip/DWC_pcie/latest/doc/RASDP_CheckPoints.pdf
                }
            }
            field RSVDP_24 @'h18 {
                bits 8;
                access ro;
                hard_reset 'h0;
                soft_reset 'h0;
                doc {
                    Reserved for future use.
                }
            }
            doc {
                Error injection control for the following features:
 - 1-bit or 2-bit injection
 - Continuous or fixed-number (n) injection modes
 - Global enable/disable
 - Selectable location where injection occursError injection control for the following features:
 - 1-bit or 2-bit injection
 - Continuous or fixed-number (n) injection modes
 - Global enable/disable
 - Selectable location where injection occurs
            }
        }
        register RASDP_CORR_ERROR_LOCATION_OFF @'h20 {
            bytes 4;
            field RSVDP_0 @'h0 {
                bits 4;
                access ro;
                hard_reset 'h0;
                soft_reset 'h0;
                doc {
                    Reserved for future use.
                }
            }
            field REG_FIRST_CORR_ERROR @'h4 {
                bits 4;
                access ro;
                volatile 1
                hard_reset 'h0;
                doc {
                    Region of the first corrected error:
 - 0x0: Region select for Adm Rx path
 - 0x1: Region select for layer 3 Rx path
 - 0x2: Region select for layer 2 Rx path
 - 0x3: Region select for DMA inbound path
 - 0x4: Region select for AXI bridge inbound request path
 - 0x5: Region select for AXI bridge inbound completion composer path
 - 0x6: Region select for Adm Tx path
 - 0x7: Region select for layer 3 Tx path
 - 0x8: Region select for layer 2 Tx path
 - 0x9: Region select for DMA outbound path
 - 0xa: Region select for AXI bridge outbound request path
 - 0xb: Region select for AXI bridge outbound master completion buffer path
 - 0xc: Reserved
 - 0xf: Reserved
                }
            }
            field LOC_FIRST_CORR_ERROR @'h8 {
                bits 8;
                access ro;
                volatile 1
                hard_reset 'h0;
                doc {
                    Location/ID of the first corrected error within the region defined by REG_FIRST_CORR_ERROR.

You can cycle this field value from 0 to 255 to access all counters according to the detailed report of check points at http://www.synopsys.com/dw/doc.php/iip/DWC_pcie/latest/doc/RASDP_CheckPoints.pdf
                }
            }
            field RSVDP_16 @'h10 {
                bits 4;
                access ro;
                hard_reset 'h0;
                soft_reset 'h0;
                doc {
                    Reserved for future use.
                }
            }
            field REG_LAST_CORR_ERROR @'h14 {
                bits 4;
                access ro;
                volatile 1
                hard_reset 'h0;
                doc {
                    Region of the last corrected error:
 - 0x0: Region select for Adm Rx path
 - 0x1: Region select for layer 3 Rx path
 - 0x2: Region select for layer 2 Rx path
 - 0x3: Region select for DMA inbound path
 - 0x4: Region select for AXI bridge inbound request path
 - 0x5: Region select for AXI bridge inbound completion composer path
 - 0x6: Region select for Adm Tx path
 - 0x7: Region select for layer 3 Tx path
 - 0x8: Region select for layer 2 Tx path
 - 0x9: Region select for DMA outbound path
 - 0xa: Region select for AXI bridge outbound request path
 - 0xb: Region select for AXI bridge outbound master completion buffer path
 - 0xc: Reserved
 - 0xf: Reserved
                }
            }
            field LOC_LAST_CORR_ERROR @'h18 {
                bits 8;
                access ro;
                volatile 1
                hard_reset 'h0;
                doc {
                    Location/ID of the last corrected error within the region defined by REG_LAST_CORR_ERROR.

You can cycle this field value from 0 to 255 to access all counters according to the detailed report of check points at http://www.synopsys.com/dw/doc.php/iip/DWC_pcie/latest/doc/RASDP_CheckPoints.pdf
                }
            }
            doc {
                Corrected errors locations. For more details, see the RAS Data Protection (DP) section in the Core Operations chapter of the Databook.Corrected errors locations. For more details, see the RAS Data Protection (DP) section in the Core Operations chapter of the Databook.
            }
        }
        register RASDP_UNCORR_ERROR_LOCATION_OFF @'h24 {
            bytes 4;
            field RSVDP_0 @'h0 {
                bits 4;
                access ro;
                hard_reset 'h0;
                soft_reset 'h0;
                doc {
                    Reserved for future use.
                }
            }
            field REG_FIRST_UNCORR_ERROR @'h4 {
                bits 4;
                access ro;
                volatile 1
                hard_reset 'h0;
                doc {
                    Region of the first uncorrected error:
 - 0x0: Region select for Adm Rx path
 - 0x1: Region select for layer 3 Rx path
 - 0x2: Region select for layer 2 Rx path
 - 0x3: Region select for DMA inbound path
 - 0x4: Region select for AXI bridge inbound request path
 - 0x5: Region select for AXI bridge inbound completion composer path
 - 0x6: Region select for Adm Tx path
 - 0x7: Region select for layer 3 Tx path
 - 0x8: Region select for layer 2 Tx path
 - 0x9: Region select for DMA outbound path
 - 0xa: Region select for AXI bridge outbound request path
 - 0xb: Region select for AXI bridge outbound master completion buffer path
 - 0xc: Reserved
 - 0xf: Reserved
                }
            }
            field LOC_FIRST_UNCORR_ERROR @'h8 {
                bits 8;
                access ro;
                volatile 1
                hard_reset 'h0;
                doc {
                    Location/ID of the first uncorrected error within the region defined by REG_FIRST_UNCORR_ERROR.

You can cycle this field value from 0 to 255 to access all counters according to the detailed report of check points at http://www.synopsys.com/dw/doc.php/iip/DWC_pcie/latest/doc/RASDP_CheckPoints.pdf
                }
            }
            field RSVDP_16 @'h10 {
                bits 4;
                access ro;
                hard_reset 'h0;
                soft_reset 'h0;
                doc {
                    Reserved for future use.
                }
            }
            field REG_LAST_UNCORR_ERROR @'h14 {
                bits 4;
                access ro;
                volatile 1
                hard_reset 'h0;
                doc {
                    Region of the last uncorrected error:
 - 0x0: Region select for Adm Rx path
 - 0x1: Region select for layer 3 Rx path
 - 0x2: Region select for layer 2 Rx path
 - 0x3: Region select for DMA inbound path
 - 0x4: Region select for AXI bridge inbound request path
 - 0x5: Region select for AXI bridge inbound completion composer path
 - 0x6: Region select for Adm Tx path
 - 0x7: Region select for layer 3 Tx path
 - 0x8: Region select for layer 2 Tx path
 - 0x9: Region select for DMA outbound path
 - 0xa: Region select for AXI bridge outbound request path
 - 0xb: Region select for AXI bridge outbound master completion buffer path
 - 0xc: Reserved
 - 0xf: Reserved
                }
            }
            field LOC_LAST_UNCORR_ERROR @'h18 {
                bits 8;
                access ro;
                volatile 1
                hard_reset 'h0;
                doc {
                    Location/ID of the last uncorrected error within the region defined by REG_LAST_UNCORR_ERROR.

You can cycle this field value from 0 to 255 to access all counters according to the detailed report of check points at http://www.synopsys.com/dw/doc.php/iip/DWC_pcie/latest/doc/RASDP_CheckPoints.pdf
                }
            }
            doc {
                Uncorrected errors locations. For more details, see the RAS Data Protection (DP) section in the Core Operations chapter of the Databook.Uncorrected errors locations. For more details, see the RAS Data Protection (DP) section in the Core Operations chapter of the Databook.
            }
        }
        register RASDP_ERROR_MODE_EN_OFF @'h28 {
            bytes 4;
            field ERROR_MODE_EN @'h0 {
                access rw;
                hard_reset 'h0;
                doc {
                    Write '1' to enable the controller enter RASDP error mode when it detects an uncorrectable error.

Note: This register field is sticky.
                }
            }
            field AUTO_LINK_DOWN_EN @'h1 {
                access rw;
                hard_reset 'h0;
                doc {
                    Write '1' to enable the controller to bring the link down when the controller enters RASDP error mode.

Note: This register field is sticky.
                }
            }
            field RSVDP_2 @'h2 {
                bits 30;
                access ro;
                hard_reset 'h0;
                soft_reset 'h0;
                doc {
                    Reserved for future use.
                }
            }
            doc {
                RASDP error mode enable. The controller enters RASDP error mode (if ERROR_MODE_EN =1) upon detection of the first uncorrectable error. During this mode:
 - Rx TLPs that are forwarded to your application are not guaranteed to be correct; you must discard them.
For more details, see the RAS Data Protection (DP) section in the Core Operations chapter of the Databook.RASDP error mode enable. The controller enters RASDP error mode (if ERROR_MODE_EN =1) upon detection of the first uncorrectable error. During this mode:
 - Rx TLPs that are forwarded to your application are not guaranteed to be correct; you must discard them.
For more details, see the RAS Data Protection (DP) section in the Core Operations chapter of the Databook.
            }
        }
        register RASDP_ERROR_MODE_CLEAR_OFF @'h2c {
            bytes 4;
            field ERROR_MODE_CLEAR @'h0 {
                access wo;
                volatile 1
                hard_reset 'h0;
                doc {
                    Write '1' to take the controller out of RASDP error mode. The controller will then report uncorrectable errors (through AER internal error reporting) and also stop nullifying/discarding TLPs.
                }
            }
            field RSVDP_1 @'h1 {
                bits 31;
                access ro;
                hard_reset 'h0;
                soft_reset 'h0;
                doc {
                    Reserved for future use.
                }
            }
            doc {
                Exit RASDP error mode. For more details, see the RAS Data Protection (DP) section in the Core Operations chapter of the Databook.Exit RASDP error mode. For more details, see the RAS Data Protection (DP) section in the Core Operations chapter of the Databook.
            }
        }
        register RASDP_RAM_ADDR_CORR_ERROR_OFF @'h30 {
            bytes 4;
            field RAM_ADDR_CORR_ERROR @'h0 {
                bits 27;
                access ro;
                volatile 1
                hard_reset 'h0;
                doc {
                    RAM Address where a corrected error (1-bit ECC) has been detected.
                }
            }
            field RSVDP_27 @'h1b {
                access ro;
                hard_reset 'h0;
                soft_reset 'h0;
                doc {
                    Reserved for future use.
                }
            }
            field RAM_INDEX_CORR_ERROR @'h1c {
                bits 4;
                access ro;
                volatile 1
                hard_reset 'h0;
                doc {
                    RAM index where a corrected error (1-bit ECC) has been detected.
                }
            }
            doc {
                RAM Address where a corrected error (1-bit ECC) has been detected. For more details, see the RAS Data Protection (DP) section in the Core Operations chapter of the Databook.RAM Address where a corrected error (1-bit ECC) has been detected. For more details, see the RAS Data Protection (DP) section in the Core Operations chapter of the Databook.
            }
        }
        register RASDP_RAM_ADDR_UNCORR_ERROR_OFF @'h34 {
            bytes 4;
            field RAM_ADDR_UNCORR_ERROR @'h0 {
                bits 27;
                access ro;
                volatile 1
                hard_reset 'h0;
                doc {
                    RAM Address where an uncorrected error (2-bit ECC) has been detected.
                }
            }
            field RSVDP_27 @'h1b {
                access ro;
                hard_reset 'h0;
                soft_reset 'h0;
                doc {
                    Reserved for future use.
                }
            }
            field RAM_INDEX_UNCORR_ERROR @'h1c {
                bits 4;
                access ro;
                volatile 1
                hard_reset 'h0;
                doc {
                    RAM index where an uncorrected error (2-bit ECC) has been detected.
                }
            }
            doc {
                RAM Address where an uncorrected error (2-bit ECC) has been detected. For more details, see the RAS Data Protection (DP) section in the Core Operations chapter of the Databook.RAM Address where an uncorrected error (2-bit ECC) has been detected. For more details, see the RAS Data Protection (DP) section in the Core Operations chapter of the Databook.
            }
        }
        doc {
            PF RAS Datapath Protection Capability Structure (VSEC)
        }
    }
    block PF0_RTR_CAP @'h1f0 {
        bytes 4;
        register RTR_EXT_CAP_HDR_OFF @'h0 {
            bytes 4;
            field RTR_EXT_CAP_ID @'h0 {
                bits 16;
                access ro;
                hard_reset 'h0;
                doc {
                    PCI Express Extended Capability ID.
For a description of this standard PCIe register field, see the PCI Express Specification.

Note: The access attributes of this field are as follows:
 - Wire: R (sticky) 
 - Dbi: if (DBI_RO_WR_EN == 1) then R/W(sticky) else R(sticky) 
Note: This register field is sticky.
                }
            }
            field RTR_CAP_VERSION @'h10 {
                bits 4;
                access ro;
                hard_reset 'h0;
                doc {
                    Capability Version.
For a description of this standard PCIe register field, see the PCI Express Specification.

Note: The access attributes of this field are as follows:
 - Wire: R (sticky) 
 - Dbi: if (DBI_RO_WR_EN == 1) then R/W(sticky) else R(sticky) 
Note: This register field is sticky.
                }
            }
            field RTR_NEXT_OFFSET @'h14 {
                bits 12;
                access ro;
                hard_reset 'h0;
                doc {
                    Next Capability Offset.
For a description of this standard PCIe register field, see the PCI Express Specification.

Note: The access attributes of this field are as follows:
 - Wire: R (sticky) 
 - Dbi: if (DBI_RO_WR_EN == 1) then R/W(sticky) else R(sticky) 
Note: This register field is sticky.
                }
            }
            doc {
                Readiness Time Reporting PCI Express Extended Capability Header.
For a description of this standard PCIe register, see the PCI Express Specification.Readiness Time Reporting PCI Express Extended Capability Header.
For a description of this standard PCIe register, see the PCI Express Specification.
            }
        }
        register READI_TIME_REPORTING1_OFF @'h4 {
            bytes 4;
            field RESET_TIME @'h0 {
                bits 12;
                access ro;
                hard_reset 'h0;
                doc {
                    Reset Time.
For a description of this standard PCIe register field, see the PCI Express Specification.

Note: The access attributes of this field are as follows:
 - Wire: HWINIT 
 - Dbi: if (DBI_RO_WR_EN == 1)  then R/W(sticky) else R(sticky) 
                }
            }
            field DL_UP_TIME @'hc {
                bits 12;
                access ro;
                hard_reset 'h0;
                doc {
                    DL_UP Time.
For a description of this standard PCIe register field, see the PCI Express Specification.

Note: The access attributes of this field are as follows:
 - Wire: HWINIT 
 - Dbi: if (DBI_RO_WR_EN == 1) then R/W(sticky) else R(sticky) 
                }
            }
            field RSVDP_24 @'h18 {
                bits 7;
                access ro;
                hard_reset 'h0;
                soft_reset 'h0;
                doc {
                    Reserved for future use.
                }
            }
            field RTR_TIME_VALID @'h1f {
                access ro;
                hard_reset 'h0;
                doc {
                    Valid.
For a description of this standard PCIe register field, see the PCI Express Specification.

Note: The access attributes of this field are as follows:
 - Wire: HWINIT 
 - Dbi: if (DBI_RO_WR_EN == 1) then R/W(sticky) else R(sticky) 
                }
            }
            doc {
                Readiness Time Reporting 1.
For a description of this standard PCIe register, see the PCI Express Specification.Readiness Time Reporting 1.
For a description of this standard PCIe register, see the PCI Express Specification.
            }
        }
        register READI_TIME_REPORTING2_OFF @'h8 {
            bytes 4;
            field FLR_TIME @'h0 {
                bits 12;
                access ro;
                hard_reset 'h0;
                doc {
                    FLR Time.
For a description of this standard PCIe register field, see the PCI Express Specification.

Note: The access attributes of this field are as follows:
 - Wire: RSVDP 
 - Dbi: if (DBI_RO_WR_EN == 1) then R/W(sticky) else R(sticky) 
                }
            }
            field D3HOT_D0_TIME @'hc {
                bits 12;
                access ro;
                hard_reset 'h0;
                doc {
                    D3hot to D0 Time.
For a description of this standard PCIe register field, see the PCI Express Specification.

Note: The access attributes of this field are as follows:
 - Wire: HWINIT 
 - Dbi: if (DBI_RO_WR_EN == 1) then R/W(sticky) else R(sticky) 
                }
            }
            field RSVDP_24 @'h18 {
                bits 8;
                access ro;
                hard_reset 'h0;
                soft_reset 'h0;
                doc {
                    Reserved for future use.
                }
            }
            doc {
                Readiness Time Reporting 2.
For a description of this standard PCIe register, see the PCI Express Specification.Readiness Time Reporting 2.
For a description of this standard PCIe register, see the PCI Express Specification.
            }
        }
        doc {
            PF RTR Capability Structure
        }
    }
    block PF0_PM_CAP @'h40 {
        bytes 4;
        register CAP_ID_NXT_PTR_REG @'h0 {
            bytes 4;
            field PM_CAP_ID @'h0 {
                bits 8;
                access ro;
                hard_reset 'h0;
                doc {
                    Capability ID.
This field returns 01h to indicate that this is the PCI Power Management Capability. Each function may have only one item in its capability list with Capability ID set to 01h.
                }
            }
            field PM_NEXT_POINTER @'h8 {
                bits 8;
                access ro;
                hard_reset 'h0;
                doc {
                    Next Capability Pointer.
This field provides an offset into the function's configuration space pointing to the location of next item in the capabilities list. If there are no additional items in the capabilities list, this field is set to 00h.

Note: The access attributes of this field are as follows:
 - Wire: R (sticky) 
 - Dbi: if (DBI_RO_WR_EN == 1) then R/W else R 
Note: This register field is sticky.
                }
            }
            field PM_SPEC_VER @'h10 {
                bits 3;
                access ro;
                hard_reset 'h0;
                doc {
                    Version.
This field provides the Power Management specification version. The controller hardwires this field to 011b for functions compliant to PCI Express Base Specification, Revision 4.0, Version 1.0>.

Note: The access attributes of this field are as follows:
 - Wire: R (sticky) 
 - Dbi: if (DBI_RO_WR_EN == 1) then R/W else R 
Note: This register field is sticky.
                }
            }
            field PME_CLK @'h13 {
                access ro;
                hard_reset 'h0;
                doc {
                    PME Clock.
Does not apply to PCI Express, the controller hardwires it to 0b.

Note: This register field is sticky.
                }
            }
            field PME_IMM_READI_RETURN_DO @'h14 {
                access ro;
                hard_reset 'h0;
                doc {
                    Immediate_Readiness_on_Return_to_D0.
 - If this bit is a "1", this function is guaranteed to be ready to successfully complete valid accesses immediately after being set to D0. These accesses include configuration cycles, and if the function returns to D0initialized, they also include Memory and I/O Cycles.
 - When this bit is "1", for accesses to this function, software is exempt from all requirements to delay accesses following a transition to D0, including but not limited to the 10ms delay; the delays described in Section 5.9 of PCI Express Base Specification. How this guarantee is established is beyond the scope of this document.
 - It is permitted that your system software/firmware provides mechanisms that supersede the indication provided by this bit, however such software/firmware mechanisms are outside the scope of this document.
Note: The access attributes of this field are as follows:
 - Wire: R (sticky) 
 - Dbi: if (DBI_RO_WR_EN == 1) then R/W else R 
Note: This register field is sticky.
                }
            }
            field DSI @'h15 {
                access ro;
                hard_reset 'h0;
                doc {
                    Device Specific Initialization.
The DSI bit indicates whether special initialization of this function is required.

When set, indicates that the function requires a device specific initialization sequence following a transition to the D0uninitialized state.

Note: The access attributes of this field are as follows:
 - Wire: R (sticky) 
 - Dbi: if (DBI_RO_WR_EN == 1) then R/W else R 
Note: This register field is sticky.
                }
            }
            field AUX_CURR @'h16 {
                bits 3;
                access ro;
                hard_reset 'h0;
                doc {
                    Aux_Current.
This 3 bit field reports the Vaux auxiliary current requirements for the function.

If this function implements the Data Register, the controller hardwires this field to 000b.

If PME_Support is 0 xxxxb (PME assertion from D3cold is not supported), the controller hardwires this field to 0000b.

For functions where PME_Support is 1 xxxxb (PME assertion from D3cold is supported), and which do not implement the Data field, the following encodings apply:
 - b111 375mA Vaux Max. Current Required
 - b110 320mA Vaux Max. Current Required
 - b101 270mA Vaux Max. Current Required
 - b100 220mA Vaux Max. Current Required
 - b011 160mA Vaux Max. Current Required
 - b010 100mA Vaux Max. Current Required
 - b001 55mA Vaux Max. Current Required
 - b000 0 self powered
Note: The access attributes of this field are as follows:
 - Wire: R (sticky) 
 - Dbi: if (DBI_RO_WR_EN == 1) then R/W else R 
Note: This register field is sticky.
                }
            }
            field D1_SUPPORT @'h19 {
                access ro;
                hard_reset 'h0;
                doc {
                    D1_Support.
If this bit is set, this function supports the D1 Power Management state. Functions that do not support D1 must always return a value of 0b for this bit.

Note: The access attributes of this field are as follows:
 - Wire: R (sticky) 
 - Dbi: if (DBI_RO_WR_EN == 1) then R/W else R 
Note: This register field is sticky.
                }
            }
            field D2_SUPPORT @'h1a {
                access ro;
                hard_reset 'h0;
                doc {
                    D2_Support.
If this bit is set, this function supports the D2 Power Management state. Functions that do not support D2 must always return a value of 0b for this bit.

Note: The access attributes of this field are as follows:
 - Wire: R (sticky) 
 - Dbi: if (DBI_RO_WR_EN == 1) then R/W else R 
Note: This register field is sticky.
                }
            }
            field PME_SUPPORT @'h1b {
                bits 5;
                access ro;
                volatile 1
                hard_reset 'h0;
                doc {
                    PME_Support.
This 5-bit field indicates the power states in which the function may generate a PME and/or forward PME messages.
A value of 0b for any bit indicates that the function is not capable of asserting PME while in that power state.
 - bit(27) X XXX1b - PME can be generated from D0
 - bit(28) X XX1Xb - PME can be generated from D1
 - bit(29) X X1XXb - PME can be generated from D2
 - bit(30) X 1XXXb - PME can be generated from D3hot
 - bit(31) 1 XXXXb - PME can be generated from D3cold
Bit 31 (PME can be asserted from D3cold) represents a special case. Functions that set this bit require some sort of auxiliary power source. Implementation specific mechanisms are recommended to validate that the power source is available before setting this bit.



The read value from this field is the write value && (sys_aux_pwr_det, 1'b1, D2_SUPPORT, D1_SUPPORT, 1'b1), where D1_SUPPORT and D2_SUPPORT are fields in this register.

The reset value PME_SUPPORT_n && (sys_aux_pwr_det, 1'b1, D2_SUPPORT, D1_SUPPORT, 1'b1), where PME_SUPPORT_n is a configuration parameter.

Note: The access attributes of this field are as follows:
 - Wire: R 
 - Dbi: if (DBI_RO_WR_EN == 1) then R/W else R 
Note: This register field is sticky.
                }
            }
            doc {
                Power Management Capabilities Register.Power Management Capabilities Register.
            }
        }
        register CON_STATUS_REG @'h4 {
            bytes 4;
            field POWER_STATE @'h0 {
                bits 2;
                access rw;
                volatile 1
                hard_reset 'h0;
                enum { D0 = 0, D1 = 1, D2 = 2, D3hot = 3 };
                doc {
                    PowerState.
This 2-bit field is used both to determine the current power state of a function and to set the function into a new power state. The definition of the field values is given below.
You can write to this register; however, the read-back value is the actual power state, not the write value. If you attempt to write an unsupported, optional state to this field, the write operation completes normally; however, the data is discarded and no state change occurs.

Note: The access attributes of this field are as follows:
 - Wire: R/W 
 - Dbi: R/W 
                }
            }
            field RSVDP_2 @'h2 {
                access ro;
                hard_reset 'h0;
                soft_reset 'h0;
                doc {
                    Reserved for future use.
                }
            }
            field NO_SOFT_RST @'h3 {
                access ro;
                hard_reset 'h0;
                doc {
                    No_Soft_Reset.
This bit indicates the state of the function after writing the PowerState field to transition the function from D3hot to D0.
 - When set, this transition preserves internal function state. The function is in D0Active and no additional software intervention is required.
 - When clear, this transition results in undefined internal function state.
Regardless of this bit, functions that transition from D3hot to D0 by Fundamental Reset will return to D0Uninitialized with only PME context preserved if PME is supported and enabled.

Note: The access attributes of this field are as follows:
 - Wire: R (sticky) 
 - Dbi: if (DBI_RO_WR_EN == 1) then R/W else R 
Note: This register field is sticky.
                }
            }
            field RSVDP_4 @'h4 {
                bits 4;
                access ro;
                hard_reset 'h0;
                soft_reset 'h0;
                doc {
                    Reserved for future use.
                }
            }
            field PME_ENABLE @'h8 {
                access rw;
                volatile 1
                hard_reset 'h0;
                soft_reset 'h0;
                doc {
                    PME_En.
 - When set, the function is permitted to generate a PME.
 - When clear, the function is not permitted to generate a PME.
If PME_Support is 1 xxxxb (PME generation from D3cold) or the function consumes Aux power and Aux power is available this bit is RWS and the bit is not modified by Conventional Reset or FLR.

If PME_Support is 0 xxxxb, this field is not sticky (RW).

If PME_Support is 0 0000b, the controller hardwires this bit to 0b.

Note: This register field is sticky.
                }
            }
            field DATA_SELECT @'h9 {
                bits 4;
                access ro;
                hard_reset 'h0;
                doc {
                    Data_Select.
This 4-bit field is used to select which data is to be reported through the Data and Data_Scale field. If the Data field is not implemented, this field must be hardwired to 0000b.
                }
            }
            field DATA_SCALE @'hd {
                bits 2;
                access ro;
                hard_reset 'h0;
                doc {
                    Data_Scale.
This field indicates the scaling factor to be used when interpreting the value of the Data field. The value and meaning of this field varies depending on which data value has been selected by the Data_Select field. For more details, see 7.5.2.3 section of PCI Express Base Specification.
                }
            }
            field PME_STATUS @'hf {
                access w1c;
                volatile 1
                hard_reset 'h0;
                doc {
                    PME_Status.
This bit is set when the function normally generates a PME signal. The value of this bit is not affected by the value of the PME_En bit.
If PME_Support bit 31 of the Power Management Capabilities register is clear, this bit is permitted to be hardwired to 0b.
Functions that consume Aux power must preserve the value of this sticky register when Aux power is available. In such functions, this register value is not modified by Conventional Reset or FLR.
                }
            }
            field RSVDP_16 @'h10 {
                bits 6;
                access ro;
                hard_reset 'h0;
                soft_reset 'h0;
                doc {
                    Reserved for future use.
                }
            }
            field B2_B3_SUPPORT @'h16 {
                access ro;
                hard_reset 'h0;
                doc {
                    B2B3 Support for D3hot.
For a description of this standard PCIe register field, see the PCI Express Base Specification.
                }
            }
            field BUS_PWR_CLK_CON_EN @'h17 {
                access ro;
                hard_reset 'h0;
                doc {
                    Bus Power/Clock Control Enable.
For a description of this standard PCIe register field, see the PCI Express Base Specification.
                }
            }
            field DATA_REG_ADD_INFO @'h18 {
                bits 8;
                access ro;
                hard_reset 'h0;
                doc {
                    Data.
This field is used to report the state dependent data requested by the Data_Select field. The value of this field is scaled by the value reported by the Data_Scale field.
                }
            }
            doc {
                Power Management Control and Status Register.
This register is used to manage the PCI function's power management state as well as to enable/monitor PMEs.Power Management Control and Status Register.
This register is used to manage the PCI function's power management state as well as to enable/monitor PMEs.
            }
        }
        doc {
            PF PCI Power Management Capability Structure
        }
    }
    block PF0_PCIE_CAP @'h70 {
        bytes 4;
        register PCIE_CAP_ID_PCIE_NEXT_CAP_PTR_PCIE_CAP_REG @'h0 {
            bytes 4;
            field PCIE_CAP_ID @'h0 {
                bits 8;
                access ro;
                hard_reset 'h0;
                soft_reset 'h0;
                doc {
                    Capability ID. Indicates the PCI Express Capability structure. This field must return a Capability ID of 10h indicating that this is a PCI Express Capability structure.
                }
            }
            field PCIE_CAP_NEXT_PTR @'h8 {
                bits 8;
                access ro;
                hard_reset 'h0;
                doc {
                    Next Capability Pointer. This field contains the offset to the next PCI Capability structure or 00h if no other items exist in the linked list of Capabilities.

Note: The access attributes of this field are as follows:
 - Wire: R (sticky) 
 - Dbi: if (DBI_RO_WR_EN == 1) then R/W else R 
Note: This register field is sticky.
                }
            }
            field PCIE_CAP_REG @'h10 {
                bits 4;
                access ro;
                hard_reset 'h0;
                soft_reset 'h0;
                doc {
                    Capability Version. Indicates PCI-SIG defined PCI Express Capability structure version number.
A version of the specification that changes the PCI Express Capability structure in a way that is not otherwise identifiable (for example, through a new Capability field) is permitted to increment this field. All such changes to the PCI Express Capability structure must be software-compatible. Software must check for Capability Version numbers that are greater than or equal to the highest number defined when the software is written, as functions reporting any such Capability Version numbers will contain a PCI Express Capability structure that is compatible with that piece of software.
The controller hardwires this field to 2h for functions compliant to PCI Express Base Specification, Revision 4.0, Version 1.0.

Note: This register field is sticky.
                }
            }
            field PCIE_DEV_PORT_TYPE @'h14 {
                bits 4;
                access ro;
                volatile 1
                hard_reset 'h0;
                soft_reset 'h0;
                doc {
                    Device/Port Type. Indicates the specific type of this PCI Express function.

Note: Different functions in a Multi-Function Device can generally be of different types.
Defined encodings for functions that implement a Type 00h PCI Configuration Space header are:
 - 0000b PCI Express Endpoint
 - 0001b Legacy PCI Express Endpoint
Defined encodings for functions that implement a Type 01h PCI Configuration Space header are:
 - 0100b Root Port of PCI Express Root Complex
 - 0101b Upstream Port of PCI Express Switch
 - 0110b Downstream Port of PCI Express Switch
All other encodings are Reserved.

Note: Different Endpoint types have notably different requirements in Section 1.3.2 of PCI Express Base Specification regarding I/O resources, Extended Configuration Space, and other capabilities.
                }
            }
            field PCIE_SLOT_IMP @'h18 {
                access ro;
                hard_reset 'h0;
                doc {
                    Slot Implemented. When set, this bit indicates that the Link associated with this Port is connected to a slot (as compared to being connected to a system-integrated device or being disabled). This bit is valid for Downstream Ports. This bit is undefined for Upstream Ports.

Note: The access attributes of this field are as follows:
 - Wire: HWINIT 
 - Dbi: if (DBI_RO_WR_EN == 1) then R/W else R 
                }
            }
            field PCIE_INT_MSG_NUM @'h19 {
                bits 5;
                access ro;
                hard_reset 'h0;
                doc {
                    PCIE Interrupt Message Number.
For a description of this standard PCIe register field, see the PCI Express Base Specification.
Interrupt Message Number. This field indicates which MSI/MSI-X vector is used for the interrupt message generated in association with any of the status bits of this Capability structure.

For MSI, the value in this field indicates the offset between the base Message Data and the interrupt message that is generated. Hardware is required to update this field so that it is correct if the number of MSI Messages assigned to the Function changes when software writes to the Multiple Message Enable field in the MSI Message Control register.

For MSI-X, the value in this field indicates which MSI-X Table entry is used to generate the interrupt message. The entry must be one of the first 32 entries even if the Function implements more than 32 entries. For a given MSI-X implementation, the entry must remain constant.

If both MSI and MSI-X are implemented, they are permitted to use different vectors, though software is permitted to enable only one mechanism at a time. If MSI-X is enabled, the value in this field must indicate the vector for MSI-X. If MSI is enabled or neither is enabled, the value in this field must indicate the vector for MSI. If software enables both MSI and MSI-X at the same time, the value in this field is undefined.

Note: The access attributes of this field are as follows:
 - Wire: R (sticky) 
 - Dbi: if (DBI_RO_WR_EN == 1) then R/W else R 
Note: This register field is sticky.
                }
            }
            field RSVD @'h1e {
                access ro;
                hard_reset 'h0;
                soft_reset 'h0;
                doc {
                    Reserved.
                }
            }
            field RSVDP_31 @'h1f {
                access ro;
                hard_reset 'h0;
                soft_reset 'h0;
                doc {
                    Reserved for future use.
                }
            }
            doc {
                PCI Express Capabilities, ID, Next Pointer Register.PCI Express Capabilities, ID, Next Pointer Register.
            }
        }
        register DEVICE_CAPABILITIES_REG @'h4 {
            bytes 4;
            field PCIE_CAP_MAX_PAYLOAD_SIZE @'h0 {
                bits 3;
                access ro;
                hard_reset 'h0;
                doc {
                    Max_Payload_Size Supported.
This field indicates the maximum payload size that the function can support for TLPs.
Defined encodings are:
 - 000b: 128 bytes max payload size
 - 001b: 256 bytes max payload size
 - 010b: 512 bytes max payload size
 - 011b: 1024 bytes max payload size
 - 100b: 2048 bytes max payload size
 - 101b: 4096 bytes max payload size
 - 110b: Reserved
 - 111b: Reserved
The functions of a Multi-Function Device are permitted to report different values for this field.

Note: The access attributes of this field are as follows:
 - Wire: R (sticky) 
 - Dbi: if (DBI_RO_WR_EN == 1) then R/W else R 
Note: This register field is sticky.
                }
            }
            field PCIE_CAP_PHANTOM_FUNC_SUPPORT @'h3 {
                bits 2;
                access ro;
                hard_reset 'h0;
                doc {
                    Phantom Functions Supported.
This field indicates the support for use of unclaimed function numbers to extend the number of outstanding transactions allowed by logically combining unclaimed function numbers (called Phantom Functions) with the Tag identifier (see Section 2.2.6.2 of PCI Express Base Specification for a description of Tag Extensions).

With every Function in an ARI Device, the Phantom Functions Supported field must be set to 00b. The remainder of this field description applies only to non-ARI Multi-Function Devices.

This field indicates the number of most significant bits of the Function Number portion of Requester ID that are logically combined with the Tag identifier.
Defined encodings are:
 - 00b: No Function Number bits are used for Phantom Functions. Multi-Function Devices are permitted to implement up to 8 independent functions.
 - 01b: The most significant bit of the Function number in Requester ID is used for Phantom Functions; a Multi-Function Device is permitted to implement Functions 0-3. Functions 0, 1, 2, and 3 are permitted to use Function Numbers 4, 5, 6, and 7 respectively as Phantom Functions.
 - 10b: The two most significant bits of Function Number in Requester ID are used for Phantom Functions; a Multi-Function Device is permitted to implement Functions 0-1. Function 0 is permitted to use Function Numbers 2, 4, and 6 for Phantom Functions. Function 1 is permitted to use Function Numbers 3, 5, and 7 as Phantom Functions.
 - 11b: All 3 bits of Function Number in Requester ID used for Phantom Functions. The device must have a single Function 0 that is permitted to use all other Function Numbers as Phantom Functions.
Note: Phantom Function support for the function must be enabled by the Phantom Functions Enable field in the Device Control register before the Function is permitted to use the Function Number field in the Requester ID for Phantom Functions.


Note: The access attributes of this field are as follows:
 - Wire: R (sticky) 
 - Dbi: if (DBI_RO_WR_EN == 1) then R/W else R 
Note: This register field is sticky.
                }
            }
            field PCIE_CAP_EXT_TAG_SUPP @'h5 {
                access ro;
                hard_reset 'h0;
                doc {
                    Extended Tag Field Supported.
This bit, in combination with the 10-Bit Tag Requester Supported bit in the Device Capabilities 2 register, indicates the maximum supported size of the Tag field as a Requester. This bit must be set if the 10-Bit Tag Requester Supported bit is set.
Defined encodings are:
 - 0b: 5-bit Tag field supported
 - 1b: 8-bit Tag field supported
Note: 8-bit Tag field generation must be enabled by the Extended Tag Field Enable bit in the Device Control register of the Requester Function before 8-bit Tags can be generated by the Requester. See Section 2.2.6.2 of PCI Express Base Specificationfor interactions with enabling the use of 10-Bit Tags.

Note: The access attributes of this field are as follows:
 - Wire: R (sticky) 
 - Dbi: if (DBI_RO_WR_EN == 1) then R/W else R 
Note: This register field is sticky.
                }
            }
            field PCIE_CAP_EP_L0S_ACCPT_LATENCY @'h6 {
                bits 3;
                access ro;
                hard_reset 'h0;
                doc {
                    Endpoint L0s Acceptable Latency. This field indicates the acceptable total latency that an Endpoint can withstand due to the transition from L0s state to the L0 state. It is essentially an indirect measure of the Endpoint’s internal buffering.

Power management software uses the reported L0s Acceptable Latency number to compare against the L0s exit latencies reported by all components comprising the data path from this Endpoint to the Root Complex Root Port to determine whether ASPM L0s entry can be used with no loss of performance.
Defined encodings are:
 - 000b: Maximum of 64 ns
 - 001b: Maximum of 128 ns
 - 010b: Maximum of 256 ns
 - 011b: Maximum of 512 ns
 - 100b: Maximum of 1 us
 - 101b: Maximum of 2 us
 - 110b: Maximum of 4 us
 - 111b: No limit
For functions other than Endpoints, this field is Reserved and the controller hardwires it to 000b.

Note: The access attributes of this field are as follows:
 - Wire: R (sticky) 
 - Dbi: if (DBI_RO_WR_EN == 1) then R/W else R 
Note: This register field is sticky.
                }
            }
            field PCIE_CAP_EP_L1_ACCPT_LATENCY @'h9 {
                bits 3;
                access ro;
                hard_reset 'h0;
                doc {
                    Endpoint L1 Acceptable Latency. This field indicates the acceptable latency that an Endpoint can withstand due to the transition from L1 state to the L0 state. It is essentially an indirect measure of the Endpoint’s internal buffering.
Power management software uses the reported L1 Acceptable Latency number to compare against the L1 Exit Latencies reported (see below) by all components comprising the data path from this Endpoint to the Root Complex Root Port to determine whether ASPM L1 entry can be used with no loss of performance.
Defined encodings are:
 - 000b: Maximum of 1 us
 - 001b Maximum of 2 us
 - 010b Maximum of 4 us
 - 011b Maximum of 8 us
 - 100b Maximum of 16 us
 - 101b Maximum of 32 us
 - 110b Maximum of 64 us
 - 111b No limit
For functions other than Endpoints, this field is Reserved and the controller hardwires it to 000b.

Note: The access attributes of this field are as follows:
 - Wire: R (sticky) 
 - Dbi: if (DBI_RO_WR_EN == 1) then R/W (Sticky) else R(Sticky) 
Note: This register field is sticky.
                }
            }
            field RSVDP_12 @'hc {
                bits 3;
                access ro;
                hard_reset 'h0;
                soft_reset 'h0;
                doc {
                    Reserved for future use.
                }
            }
            field PCIE_CAP_ROLE_BASED_ERR_REPORT @'hf {
                access ro;
                hard_reset 'h0;
                doc {
                    Role-Based Error Reporting. When set, this bit indicates that the function implements the functionality originally defined in the Error Reporting ECN for PCI Express Base Specification, Revision 1.0a, and later incorporated into PCI Express Base Specification, Revision 1.1. This bit must be set by all functions conforming to the ECN, PCI Express Base Specification, Revision 1.1., or subsequent PCI Express Base Specification revisions.

Note: The access attributes of this field are as follows:
 - Wire: R (sticky) 
 - Dbi: if (DBI_RO_WR_EN == 1) then R/W else R 
Note: This register field is sticky.
                }
            }
            field RSVDP_16 @'h10 {
                bits 2;
                access ro;
                hard_reset 'h0;
                soft_reset 'h0;
                doc {
                    Reserved for future use.
                }
            }
            field PCIE_CAP_CAP_SLOT_PWR_LMT_VALUE @'h12 {
                bits 8;
                access ro;
                volatile 1
                hard_reset 'h0;
                soft_reset 'h0;
                doc {
                    Captured Slot Power Limit Value.
For a description of this standard PCIe register field, see the PCI Express Base Specification.
Captured Slot Power Limit Value (Upstream Ports only). In combination with the Captured Slot Power Limit Scale value, specifies the upper limit on power available to the adapter.

Power limit (in Watts) is calculated by multiplying the value in this field by the value in the Captured Slot Power Limit Scale field except when the Captured Slot Power Limit Scale field equals 00b (1.0x) and the Captured Slot Power Limit Value exceeds EFh, then alternative encodings are used (for more details, see section 7.5.3.9 of PCI Express Base Specification).

This value is set by the Set_Slot_Power_Limit Message or hardwired to 00h (for more details, see section 6.9 of PCI Express Base Specification).
                }
            }
            field PCIE_CAP_CAP_SLOT_PWR_LMT_SCALE @'h1a {
                bits 2;
                access ro;
                volatile 1
                hard_reset 'h0;
                soft_reset 'h0;
                doc {
                    Captured Slot Power Limit Scale.
For a description of this standard PCIe register field, see the PCI Express Base Specification.
Captured Slot Power Limit Scale (Upstream Ports only). Specifies the scale used for the Slot Power Limit Value.
Range of Values:
 - 00b: 1.0x
 - 01b: 0.1x
 - 10b: 0.01x
 - 11b: 0.001x
This value is set by the Set_Slot_Power_Limit Message or hardwired to 00b (for more details, see section 6.9 of PCI Express Base Specification).
                }
            }
            field PCIE_CAP_FLR_CAP @'h1c {
                access ro;
                hard_reset 'h0;
                doc {
                    Function Level Reset Capability. A value of 1b indicates the function supports the optional Function Level Reset mechanism described in section 6.6.2 of of PCI Express Base Specification.

This bit applies to Endpoints only. For all other function types the controller hardwires this bit to 0b.

Note: The access attributes of this field are as follows:
 - Wire: R (sticky) 
 - Dbi: if (DBI_RO_WR_EN == 1) then R/W else R 
Note: This register field is sticky.
                }
            }
            field RSVDP_29 @'h1d {
                bits 3;
                access ro;
                hard_reset 'h0;
                soft_reset 'h0;
                doc {
                    Reserved for future use.
                }
            }
            doc {
                Device Capabilities Register.
The Device Capabilities register identifies PCI Express device function specific capabilities.Device Capabilities Register.
The Device Capabilities register identifies PCI Express device function specific capabilities.
            }
        }
        register DEVICE_CONTROL_DEVICE_STATUS @'h8 {
            bytes 4;
            field PCIE_CAP_CORR_ERR_REPORT_EN @'h0 {
                access rw;
                hard_reset 'h0;
                soft_reset 'h0;
                doc {
                    Correctable Error Reporting Enable.
This bit, in conjunction with other bits, controls sending ERR_COR Messages (for more details, see section 6.2.5, section 6.2.6, and section 6.2.10.2 of PCI Express Base Specification). For a Multi-Function device, this bit controls error reporting for each function from point-of-view of the respective function.

For a Root Port, the reporting of correctable errors is internal to the root. No external ERR_COR Message is generated.
                }
            }
            field PCIE_CAP_NON_FATAL_ERR_REPORT_EN @'h1 {
                access rw;
                hard_reset 'h0;
                soft_reset 'h0;
                doc {
                    Non-Fatal Error Reporting Enable.
This bit, in conjunction with other bits, controls sending ERR_NONFATAL Messages (for more details, see section 6.2.5 and Section 6.2.6 of PCI Express Base Specification). For a Multi-Function Device, this bit controls error reporting for each function from point-of-view of the respective Function.

For a Root Port, the reporting of Non-fatal errors is internal to the root. No external ERR_NONFATAL Message is generated.
                }
            }
            field PCIE_CAP_FATAL_ERR_REPORT_EN @'h2 {
                access rw;
                hard_reset 'h0;
                soft_reset 'h0;
                doc {
                    Fatal Error Reporting Enable.
This bit, in conjunction with other bits, controls sending ERR_FATAL Messages (for more details, see section 6.2.5 and section 6.2.6 of of PCI Express Base Specification). For a Multi-Function device, this bit controls error reporting for each function from point-of-view of the respective function.

For a Root Port, the reporting of Fatal errors is internal to the root. No external ERR_FATAL Message is generated.
                }
            }
            field PCIE_CAP_UNSUPPORT_REQ_REP_EN @'h3 {
                access rw;
                hard_reset 'h0;
                soft_reset 'h0;
                doc {
                    Unsupported Request Reporting Enable.
This bit, in conjunction with other bits, controls the signaling of Unsupported Request Errors by sending error Messages (for more details, see section 6.2.5 and section 6.2.6 of PCI Express Base Specification). For a Multi-Function Device, this bit controls error reporting for each Function from point-of-view of the respective Function.
                }
            }
            field PCIE_CAP_EN_REL_ORDER @'h4 {
                access rw;
                hard_reset 'h0;
                soft_reset 'h0;
                doc {
                    Enable Relaxed Ordering.
If this bit is set, the function is permitted to set the Relaxed Ordering bit in the Attributes field of transactions it initiates that do not require strong write ordering (for more details, see section 2.2.6.4 and section 2.4 of PCI Express Base Specification).

For a function that never sets the Relaxed Ordering attribute in transactions it initiates as a Requester, the controller hardwires this bit to 0b.

Note: The access attributes of this field are as follows:
 - Wire: R/W 
 - Dbi: R/W 
                }
            }
            field PCIE_CAP_MAX_PAYLOAD_SIZE_CS @'h5 {
                bits 3;
                access rw;
                hard_reset 'h0;
                doc {
                    Max_Payload_Size.
This field sets maximum TLP payload size for the Function. As a Receiver, the Function must handle TLPs as large as the set value. As a Transmitter, the Function must not generate TLPs exceeding the set value. Permissible values that can be programmed are indicated by the Max_Payload_Size Supported field (PCIE_CAP_MAX_PAYLOAD_SIZE) in the Device Capabilities (DEVICE_CAPABILITIES_REG) register (for more details, see section 7.5.3.3 of PCI Express Base Specification).
Defined encodings for this field are:
 - 000b: 128 bytes max payload size
 - 001b: 256 bytes max payload size
 - 010b: 512 bytes max payload size
 - 011b: 1024 bytes max payload size
 - 100b: 2048 bytes max payload size
 - 101b: 4096 bytes max payload size
 - 110b: Reserved
 - 111b: Reserved
For Functions that support only the 128-byte max payload size, the controller hardwires this field to 000b.

System software is not required to program the same value for this field for all the Functions of a Multi-Function device (for more details, see section 2.2.2 of PCI Express Base Specification).

For ARI Devices, Max_Payload_Size is determined solely by the setting in Function0. The settings in the other Functions always return whatever value software programmed for each, but otherwise are ignored by the component.
                }
            }
            field PCIE_CAP_EXT_TAG_EN @'h8 {
                access rw;
                volatile 1
                hard_reset 'h0;
                soft_reset 'h0;
                doc {
                    Extended Tag Field Enable.
This bit, in combination with the 10-Bit Tag Requester Enable bit in the Device Control 2 register, determines how many Tag field bits a Requester is permitted to use.

When the 10-Bit Tag Requester Enable bit is clear,
 - If the Extended Tag Field Enable bit is set, the function is permitted to use an 8-bit Tag field as a Requester
 - If the Extended Tag Field Enable bit is clear, the Function is restricted to a 5-bit Tag field
See section 2.2.6.2 of PCI Express Base Specification for required behavior when the 10-Bit Tag Requester Enable bit is set.

If software changes the value of the Extended Tag Field Enable bit while the function has outstanding Non-Posted Requests, the result is undefined.

For functions that do not implement this capability, the controller hardwires this bit to 0b.

Note: The access attributes of this field are as follows:
 - Wire: DEVICE_CAPABILITIES_REG.PCIE_CAP_EXT_TAG_SUPP ? RW : RO  
 - Dbi: DEVICE_CAPABILITIES_REG.PCIE_CAP_EXT_TAG_SUPP ? RW : RO  
                }
            }
            field PCIE_CAP_PHANTOM_FUNC_EN @'h9 {
                access ro;
                volatile 1
                hard_reset 'h0;
                soft_reset 'h0;
                doc {
                    Phantom Functions Enable.
This bit, in combination with the 10-Bit Tag Requester Enable bit in the Device Control 2 register, determines how many Tag field bits a Requester is permitted to use.

When the 10-Bit Tag Requester Enable bit is clear,
 - If this bit is set, it enables a function to use unclaimed functions as Phantom functions to extend the number of outstanding transaction identifiers
 - If this bit is clear, the function is not allowed to use Phantom functions
For more details, see section 2.2.6.2 of PCI Express Base Specification.

Software should not change the value of this bit while the function has outstanding Non-Posted Requests; otherwise, the result is undefined.

For functions that do not implement this capability, the controller hardwires this bit to 0b.

Note: The access attributes of this field are as follows:
 - Wire: DEVICE_CAPABILITIES_REG.PCIE_CAP_PHANTOM_FUNC_SUPPORT ? RW : RO  
 - Dbi: DEVICE_CAPABILITIES_REG.PCIE_CAP_PHANTOM_FUNC_SUPPORT ? RW : RO  
                }
            }
            field PCIE_CAP_AUX_POWER_PM_EN @'ha {
                access rw;
                volatile 1
                hard_reset 'h0;
                soft_reset 'h0;
                doc {
                    Aux Power PM Enable.
This bit is derived by sampling the sys_aux_pwr_det input.
When set this bit, enables a function to draw Aux power independent of PME Aux power. Functions that require Aux power on legacy operating systems should continue to indicate PME Aux power requirements. Aux power is allocated as requested in the Aux_Current field of the Power Management Capabilities register (PMC), independent of the PME_En bit in the Power Management Control/Status register (PMCSR). For Multi-Function devices, a component is allowed to draw Aux power if at least one of the functions has this bit set.
Note: Functions that consume Aux power must preserve the value of this sticky register when Aux power is available. In such functions, this bit is not modified by Conventional Reset.

For functions that do not implement this capability, the controller hardwires this bit to 0b.

Note: This register field is sticky.
                }
            }
            field PCIE_CAP_EN_NO_SNOOP @'hb {
                access rw;
                hard_reset 'h0;
                soft_reset 'h0;
                doc {
                    Enable No Snoop.
If this bit is set, the function is permitted to Set the No Snoop bit in the Requester Attributes of transactions it initiates that do not require hardware enforced cache coherency (see section 2.2.6.5 in PCI Express Base Specification).
Note: Setting this bit to 1b should not cause a function to set the No Snoop attribute on all transactions that it initiates. Even when this bit is set, a function is only permitted to set the No Snoop attribute on a transaction when it can guarantee that the address of the transaction is not stored in any cache in the system.

The controller hardwires this bit 0b if a function would never set the No Snoop attribute in transactions it initiates.

Note: The access attributes of this field are as follows:
 - Wire: R 
 - Dbi: R 
                }
            }
            field PCIE_CAP_MAX_READ_REQ_SIZE @'hc {
                bits 3;
                access rw;
                hard_reset 'h0;
                soft_reset 'h0;
                doc {
                    Max_Read_Request_Size.
This field sets the maximum Read Request size for the function as a Requester. The function must not generate Read Requests with a size exceeding the set value. Defined encodings for this field are:
 - 000b: 128 bytes maximum Read Request size
 - 001b: 256 bytes maximum Read Request size
 - 010b: 512 bytes maximum Read Request size
 - 011b: 1024 bytes maximum Read Request size
 - 100b: 2048 bytes maximum Read Request size
 - 101b: 4096 bytes maximum Read Request size
 - 110b: Reserved
 - 111b: Reserved
For functions that do not generate Read Requests larger than 128 bytes and functions that do not generate Read Requests on their own behalf, the controller implements this field as Read Only (RO) with a value of 000b.
                }
            }
            field PCIE_CAP_INITIATE_FLR @'hf {
                access rw;
                volatile 1
                hard_reset 'h0;
                soft_reset 'h0;
                doc {
                    Initiate Function Level Reset (applicable to Endpoints with Function Level Reset Capability set to 1b).
A write of 1b initiates Function Level Reset to the Function. The value read by software from this bit is always 0b.
                }
            }
            field PCIE_CAP_NON_FATAL_ERR_DETECTED @'h11 {
                access w1c;
                volatile 1
                hard_reset 'h0;
                soft_reset 'h0;
                doc {
                    Non-Fatal Error Detected. This bit indicates status of Non-fatal errors detected. Errors are logged in this register regardless of whether error reporting is enabled or not in the Device Control register. For a Multi-Function device, each function indicates status of errors as perceived by the respective Function.

For functions supporting Advanced Error Handling, errors are logged in this register regardless of the settings of the Uncorrectable Error Mask register.
                }
            }
            field PCIE_CAP_UNSUPPORTED_REQ_DETECTED @'h13 {
                access w1c;
                volatile 1
                hard_reset 'h0;
                soft_reset 'h0;
                doc {
                    Unsupported Request Detected.
This bit indicates that the function received an Unsupported Request. Errors are logged in this register regardless of whether error reporting is enabled or not in the Device Control register. For a Multi-Function Device, each function indicates status of errors as perceived by the respective function.
                }
            }
            field PCIE_CAP_AUX_POWER_DETECTED @'h14 {
                access ro;
                volatile 1
                hard_reset 'h0;
                soft_reset 'h0;
                doc {
                    AUX Power Detected.
Functions that require Aux power report this bit as set if Aux power is detected by the function.

This bit is derived by sampling the sys_aux_pwr_det input.
                }
            }
            field PCIE_CAP_TRANS_PENDING @'h15 {
                access ro;
                volatile 1
                hard_reset 'h0;
                soft_reset 'h0;
                doc {
                    Transactions Pending.

Endpoints:

When set, this bit indicates that the function has issued Non-Posted Requests that have not been completed. A Function reports this bit cleared only when all outstanding Non-Posted Requests have completed or have been terminated by the Completion Timeout mechanism. This bit must also be cleared upon the completion of an FLR.

                }
            }
            field RSVDP_22 @'h16 {
                bits 10;
                access ro;
                hard_reset 'h0;
                soft_reset 'h0;
                doc {
                    Reserved for future use.
                }
            }
            doc {
                Device Control and Device Status Register.
This register controls PCI Express device specific parameters and provides information about PCI Express device (function) specific parameters.Device Control and Device Status Register.
This register controls PCI Express device specific parameters and provides information about PCI Express device (function) specific parameters.
            }
        }
        register LINK_CAPABILITIES_REG @'hc {
            bytes 4;
            field PCIE_CAP_MAX_LINK_SPEED @'h0 {
                bits 4;
                access ro;
                volatile 1
                hard_reset 'h0;
                doc {
                    Max Link Speed.
This field indicates the maximum Link speed of the associated Port.
The encoded value specifies a bit location in the Supported Link Speeds Vector (in the Link Capabilities 2 register) that corresponds to the maximum Link speed.
Defined encodings are:
 - 0001b: Supported Link Speeds Vector field bit 0
 - 0010b: Supported Link Speeds Vector field bit 1
 - 0011b: Supported Link Speeds Vector field bit 2
 - 0100b: Supported Link Speeds Vector field bit 3
 - 0101b: Supported Link Speeds Vector field bit 4
 - 0110b: Supported Link Speeds Vector field bit 5
 - 0111b: Supported Link Speeds Vector field bit 6
All other encodings are reserved.

Multi-Function Devices associated with an Upstream Port must report the same value in this field for all functions.

In M-PCIe mode, the reset and dynamic values of this field are calculated by the controller.

Note: The access attributes of this field are as follows:
 - Wire: R (sticky) 
 - Dbi: if (DBI_RO_WR_EN == 1) then R/W else R 
Note: This register field is sticky.
                }
            }
            field PCIE_CAP_MAX_LINK_WIDTH @'h4 {
                bits 6;
                access ro;
                volatile 1
                hard_reset 'h0;
                doc {
                    Maximum Link Width.
This field indicates the maximum Link width (xN – corresponding to N Lanes) implemented by the component. This value is permitted to exceed the number of Lanes routed to the slot (Downstream Port), adapter connector (Upstream Port), or in the case of component-to-component connections, the actual wired connection width.
Defined encodings are:
 - 00 0001b x1
 - 00 0010b x2
 - 00 0100b x4
 - 00 1000b x8
 - 00 1100b x12
 - 01 0000b x16
 - 10 0000b x32
All other encodings are Reserved.
Multi-Function devices associated with an Upstream Port must report the same value in this field for all functions.
For a description of this standard PCIe register field, see the PCI Express Base Specification.

In M-PCIe mode, the reset and dynamic values of this field are calculated by the controller.

Note: The access attributes of this field are as follows:
 - Wire: R (sticky) 
 - Dbi: if (DBI_RO_WR_EN == 1) then R/W else R 
Note: This register field is sticky.
                }
            }
            field PCIE_CAP_ACTIVE_STATE_LINK_PM_SUPPORT @'ha {
                bits 2;
                access ro;
                hard_reset 'h0;
                doc {
                    Active State Power Management (ASPM) Support. This field indicates the level of ASPM supported on the given PCI Express Link. For more details on ASPM support requirements, see section 5.4.1 of PCI Express Base Specification.
Defined encodings are:
 - 00b: No ASPM Support
 - 01b: L0s Supported
 - 10b: L1 Supported
 - 11b: L0s and L1 Supported
Multi-Function devices associated with an Upstream Port must report the same value in this field for all functions.

Note: The access attributes of this field are as follows:
 - Wire: R (sticky) 
 - Dbi: if (DBI_RO_WR_EN == 1) then R/W else R 
Note: This register field is sticky.
                }
            }
            field PCIE_CAP_L0S_EXIT_LATENCY @'hc {
                bits 3;
                access ro;
                volatile 1
                hard_reset 'h0;
                doc {
                    L0s Exit Latency.
This field indicates the L0s exit latency for the given PCI Express Link. The value reported indicates the length of time this Port requires to complete transition from L0s to L0. If L0s is not supported, the value is undefined; however, see the Implementation Note "Potential Issues With Legacy Software When L0s is Not Supported" in section 5.4.1.1 of PCI Express Base Specification for the recommended value.
Defined encodings are:
 - 000b: Less than 64 ns
 - 001b: 64 ns to less than 128 ns
 - 010b: 128 ns to less than 256 ns
 - 011b: 256 ns to less than 512 ns
 - 100b: 512 ns to less than 1 us
 - 101b: 1 us to less than 2 us
 - 110b: 2 us to 4 us
 - 111b: More than 4 us
Note: Exit latencies may be influenced by PCI Express reference clock configuration depending upon whether a component uses a common or separate reference clock.

Multi-Function Devices associated with an Upstream Port must report the same value in this field for all functions.

There are two each of these register fields, this one and a shadow one at the same address.
The Common Clock bit (PCIE_CAP_COMMON_CLK_CONFIG) of the Link Control Register (LINK_CONTROL_LINK_STATUS_REG) determines which one is used by the controller and which one is accessed by a read request.
Common Clock operation is supported (possible) in the controller when one or more of the following expressions is true:
 - CX_NFTS !=CX_COMM_NFTS
 - DEFAULT_L0S_EXIT_LATENCY !=DEFAULT_COMM_L0S_EXIT_LATENCY
 - DEFAULT_L1_EXIT_LATENCY !=DEFAULT_COMM_L1_EXIT_LATENCY
Common Clock operation is enabled in the controller when you set the Common Clock bit (PCIE_CAP_COMMON_CLK_CONFIG) of the Link Control Register (LINK_CONTROL_LINK_STATUS_REG).
The assertion of CS2 (that is, assert the dbi_cs2 input, or the CS2 address bit for the AXI bridge) is required to write to the shadow field at this location.

Note: The access attributes of this field are as follows:
 - Wire: R (sticky) 
 - Dbi: if (DBI_RO_WR_EN == 1) then R/W else R 
Note: This register field is sticky.
                }
            }
            field PCIE_CAP_L1_EXIT_LATENCY @'hf {
                bits 3;
                access ro;
                volatile 1
                hard_reset 'h0;
                doc {
                    L1 Exit Latency. This field indicates the L1 exit latency for the given PCI Express Link. The value reported indicates the length of time this Port requires to complete transition from ASPM L1 to L0. If ASPM L1 is not supported, the value is undefined.
Defined encodings are:
 - 000b: Less than 1us
 - 001b: 1 us to less than 2 us
 - 010b: 2 us to less than 4 us
 - 011b: 4 us to less than 8 us
 - 100b: 8 us to less than 16 us
 - 101b: 16 us to less than 32 us
 - 110b: 32 us to 64 us
 - 111b: More than 64 μs
Note: Exit latencies may be influenced by PCI Express reference clock configuration depending upon whether a component uses a common or separate reference clock.

Multi-Function Devices associated with an Upstream Port must report the same value in this field for all functions.

There are two each of these register fields, this one and a shadow one at the same address.
The Common Clock bit (PCIE_CAP_COMMON_CLK_CONFIG) of the Link Control Register (LINK_CONTROL_LINK_STATUS_REG) determines which one is used by the controller and which one is accessed by a read request.
Common Clock operation is supported (possible) in the controller when one or more of the following expressions is true:
 - CX_NFTS !=CX_COMM_NFTS
 - DEFAULT_L0S_EXIT_LATENCY !=DEFAULT_COMM_L0S_EXIT_LATENCY
 - DEFAULT_L1_EXIT_LATENCY !=DEFAULT_COMM_L1_EXIT_LATENCY
Common Clock operation is enabled in the controller when you set the Common Clock bit (PCIE_CAP_COMMON_CLK_CONFIG) of the Link Control Register (LINK_CONTROL_LINK_STATUS_REG).
The assertion of CS2 (that is, assert the dbi_cs2 input, or the CS2 address bit for the AXI bridge) is required to write to the shadow field at this location.

Note: The access attributes of this field are as follows:
 - Wire: R (sticky) 
 - Dbi: if (DBI_RO_WR_EN == 1) then R/W else R 
Note: This register field is sticky.
                }
            }
            field PCIE_CAP_CLOCK_POWER_MAN @'h12 {
                access ro;
                hard_reset 'h0;
                doc {
                    Clock Power Management. For Upstream Ports, a value of 1b in this bit indicates that the component tolerates the removal of any reference clock(s) via the "clock request" (CLKREQ ) mechanism when the Link is in the L1 and L2/L3 Ready Link states. A value of 0b indicates the component does not have this capability and that reference clock(s) must not be removed in these Link states.

L1 PM Substates defines other semantics for the CLKREQ  signal, which are managed independently of Clock Power Management.

This Capability is applicable only in form factors that support "clock request" (CLKREQ ) capability.

For a Multi-Function device associated with an Upstream Port, each Function indicates its capability independently. Power Management configuration software must only permit reference clock removal if all functions of the Multi-Function device indicate a 1b in this bit. For ARI Devices, all Functions must indicate the same value in this bit.

For Downstream Ports, the controller hardwires this bit to 0b.

Note: The access attributes of this field are as follows:
 - Wire: R (sticky) 
 - Dbi: if (DBI_RO_WR_EN == 1) then R/W(sticky) else R(sticky) 
Note: This register field is sticky.
                }
            }
            field PCIE_CAP_SURPRISE_DOWN_ERR_REP_CAP @'h13 {
                access ro;
                hard_reset 'h0;
                doc {
                    Surprise Down Error Reporting Capable. For a Downstream Port, this bit must be set if the component supports the optional capability of detecting and reporting a Surprise Down error condition.

For Upstream Ports and components that do not support this optional capability, the controller hardwires this bit to 0b.

Note: This register field is sticky.
                }
            }
            field PCIE_CAP_DLL_ACTIVE_REP_CAP @'h14 {
                access ro;
                hard_reset 'h0;
                soft_reset 'h0;
                doc {
                    Data Link Layer Link Active Reporting Capable. For a Downstream Port, the controller hardwires this bit to 1b if the component supports the optional capability of reporting the DL_Active state of the Data Link Control and Management State Machine. For a hot-plug capable Downstream Port (as indicated by the Hot-Plug Capable bit of the Slot Capabilities register) or a Downstream Port that supports Link speeds greater than 5.0 GT/s, the controller hardwires this bit to 1b.

For Upstream Ports and components that do not support this optional capability, the controller hardwires this bit to 0b.
                }
            }
            field PCIE_CAP_LINK_BW_NOT_CAP @'h15 {
                access ro;
                hard_reset 'h0;
                doc {
                    Link Bandwidth Notification Capability. A value of 1b indicates support for the Link Bandwidth Notification status and interrupt mechanisms. This capability is required for all Root Ports and Switch Downstream Ports supporting Links wider than x1 and/or multiple Link speeds.

This field is not applicable and is Reserved for Endpoints, PCI Express to PCI/PCI-X bridges, and Upstream Ports of Switches.

For functions that do not implement the Link Bandwidth Notification Capability the controller hardwires this bit to 0b.

Note: This register field is sticky.
                }
            }
            field PCIE_CAP_ASPM_OPT_COMPLIANCE @'h16 {
                access ro;
                hard_reset 'h0;
                doc {
                    ASPM Optionality Compliance. This bit must be set to 1b in all functions. Components implemented against certain earlier versions of this specification will have this bit set to 0b.

Software is permitted to use the value of this bit to help determine whether to enable ASPM or whether to run ASPM compliance tests.

Note: The access attributes of this field are as follows:
 - Wire: HWINIT 
 - Dbi: if (DBI_RO_WR_EN == 1) then R/W else R 
                }
            }
            field RSVDP_23 @'h17 {
                access ro;
                hard_reset 'h0;
                soft_reset 'h0;
                doc {
                    Reserved for future use.
                }
            }
            field PCIE_CAP_PORT_NUM @'h18 {
                bits 8;
                access ro;
                hard_reset 'h0;
                doc {
                    Port Number. This field indicates the PCI Express Port number for the given PCI Express Link.
Multi-Function Devices associated with an Upstream Port must report the same value in this field for all functions.

Note: The access attributes of this field are as follows:
 - Wire: HWINIT 
 - Dbi: if (DBI_RO_WR_EN == 1) then R/W else R 
                }
            }
            doc {
                Link Capabilities Register.
The Link Capabilities register identifies PCI Express Link specific capabilities.Link Capabilities Register.
The Link Capabilities register identifies PCI Express Link specific capabilities.
            }
        }
        register LINK_CONTROL_LINK_STATUS_REG @'h10 {
            bytes 4;
            field PCIE_CAP_ACTIVE_STATE_LINK_PM_CONTROL @'h0 {
                bits 2;
                access rw;
                hard_reset 'h0;
                doc {
                    Active State Power Management (ASPM) Control.
This field controls the level of ASPM enabled on the given PCI Express Link. See section 5.4.1.3 of PCI Express Base Specification for requirements on when and how to enable ASPM.
Defined encodings are:
 - 00b: Disabled
 - 01b: L0s Entry Enabled
 - 10b: L1 Entry Enabled
 - 11b: L0s and L1 Entry Enabled
Note: "L0s Entry Enabled" enables the Transmitter to enter L0s. If L0s is supported, the Receiver must be capable of entering L0s even when the Transmitter is disabled from entering L0s (00b or 10b).

ASPM L1 must be enabled by software in the Upstream component on a Link prior to enabling ASPM L1 in the Downstream component on that Link. When disabling ASPM L1, software must disable ASPM L1 in the Downstream component on a Link prior to disabling ASPM L1 in the Upstream component on that Link. ASPM L1 must only be enabled on the Downstream component if both components on a Link support ASPM L1.

For Multi-Function Devices (including ARI Devices), it is recommended that software program the same value for this field in all Functions. For non-ARI Multi-Function Devices, only capabilities enabled in all Functions are enabled for the component as a whole.

For ARI Devices, ASPM Control is determined solely by the setting in Function0, regardless of Function 0's D-state. The settings in the other Functions always return whatever value software programmed for each, but otherwise are ignored by the component.

Software must not enable L0s in either direction on a given Link unless components on both sides of the Link each support L0s; otherwise, the result is undefined.
                }
            }
            field RSVDP_2 @'h2 {
                access ro;
                hard_reset 'h0;
                soft_reset 'h0;
                doc {
                    Reserved for future use.
                }
            }
            field PCIE_CAP_RCB @'h3 {
                access rw;
                hard_reset 'h0;
                doc {
                    Read Completion Boundary (RCB).


Endpoints and Bridges:
Optionally set by configuration software to indicate the RCB value of the Root Port Upstream from the Endpoint or Bridge. Refer to Section 2.3.1.1 of PCI Express Base Specification for the definition of the parameter RCB.
Defined encodings are:
 - 0b 64 byte
 - 1b 128 byte
Configuration software must only set this bit if the Root Port Upstream from the Endpoint or Bridge reports an RCB value of 128 bytes (a value of 1b in the Read Completion Boundary bit).
For functions that do not implement this feature, the controller hardwires this bit to 0b.


Note: The access attributes of this field are as follows:
 - Wire: R/W 
 - Dbi: R/W 
                }
            }
            field PCIE_CAP_LINK_DISABLE @'h4 {
                access rw;
                volatile 1
                hard_reset 'h0;
                soft_reset 'h0;
                doc {
                    Link Disable.
This bit disables the Link by directing the LTSSM to the Disabled state when set; this bit is Reserved on Endpoints, PCI Express to PCI/PCI-X bridges, and Upstream Ports of Switches.

Writes to this bit are immediately reflected in the value read from the bit, regardless of actual Link state.

After clearing this bit, software must honor timing requirements defined in Section 6.6.1 with respect to the first Configuration Read following a Conventional Reset.

In a DSP that supports crosslink, the controller gates the write value with the CROSS_LINK_EN field in PORT_LINK_CTRL_OFF.

Note: The access attributes of this field are as follows:
 - Wire: CX_CROSSLINK_ENABLE=1 && PORT_LINK_CTRL_OFF.CROSS_LINK_EN=1||CX_CROSSLINK_ENABLE=0 && dsp=1 ? RW : RO 
 - Dbi: CX_CROSSLINK_ENABLE=1 && PORT_LINK_CTRL_OFF.CROSS_LINK_EN=1||CX_CROSSLINK_ENABLE=0 && dsp=1? RW : RO 
                }
            }
            field PCIE_CAP_RETRAIN_LINK @'h5 {
                access rw;
                volatile 1
                hard_reset 'h0;
                soft_reset 'h0;
                doc {
                    Retrain Link.
A write of 1b to this bit initiates Link retraining by directing the Physical Layer LTSSM to the Recovery state. If the LTSSM is already in Recovery or Configuration, re-entering Recovery is permitted but not required. If the Port is in DPC when a write of 1b to this bit occurs, the result is undefined. Reads of this bit always return 0b.

It is permitted to write 1b to this bit while simultaneously writing modified values to other fields in this register. If the LTSSM is not already in Recovery or Configuration, the resulting Link training must use the modified values. If the LTSSM is already in Recovery or Configuration, the modified values are not required to affect the Link training that's already in progress.

This bit is not applicable and is Reserved for Endpoints, PCI Express to PCI/PCI-X bridges, and Upstream Ports of Switches.

This bit always returns 0b when read.

Note: The access attributes of this field are as follows:
 - Wire: see description 
 - Dbi: see description 
                }
            }
            field PCIE_CAP_COMMON_CLK_CONFIG @'h6 {
                access rw;
                hard_reset 'h0;
                doc {
                    Common Clock Configuration. When set, this bit indicates that this component and the component at the opposite end of this Link are operating with a distributed common reference clock.

A value of 0b indicates that this component and the component at the opposite end of this Link are operating with asynchronous reference clock.

For non-ARI Multi-Function Devices, software must program the same value for this bit in all Functions. If not all Functions are Set, then the component must as a whole assume that its reference clock is not common with the Upstream component.

For ARI Devices, Common Clock Configuration is determined solely by the setting in Function 0. The settings in the other Functions always return whatever value software programmed for each, but otherwise are ignored by the component.

Components utilize this common clock configuration information to report the correct L0s and L1 Exit Latencies.

After changing the value in this bit in both components on a Link, software must trigger the Link to retrain by writing a 1b to the Retrain Link bit of the Downstream Port.
                }
            }
            field PCIE_CAP_EXTENDED_SYNCH @'h7 {
                access rw;
                volatile 1
                hard_reset 'h0;
                doc {
                    Extended Synch. When set, this bit forces the transmission of additional Ordered Sets when exiting the L0s state (see section 4.2.4.5 of PCI Express Base Specification) and when in the Recovery state (see section 4.2.6.4.1 of PCI Express Base Specification). This mode provides external devices (for example, logic analyzers) monitoring the Link time to achieve bit and Symbol lock before the Link enters the L0 state and resumes communication.

For Multi-Function devices if any function has this bit set, then the component must transmit the additional Ordered Sets when exiting L0s or when in Recovery.
                }
            }
            field PCIE_CAP_EN_CLK_POWER_MAN @'h8 {
                access rw;
                volatile 1
                hard_reset 'h0;
                doc {
                    Enable Clock Power Management.
Applicable only for Upstream Ports and with form factors that support a "Clock Request" (CLKREQ ) mechanism, this bit operates as follows:
 - 0b: Clock power management is disabled and device must hold CLKREQ  signal low.
 - 1b: When this bit is set, the device is permitted to use CLKREQ  signal to power manage Link clock according to protocol defined in appropriate form factor specification.
For a non-ARI Multi-Function Device, power-management-configuration software must only Set this bit if all Functions of the Multi-Function Device indicate a 1b in the Clock Power Management bit of the Link Capabilities register. The component is permitted to use the CLKREQ  signal to power manage Link clock only if this bit is Set for all Functions.

For ARI Devices, Clock Power Management is enabled solely by the setting in Function 0. The settings in the other Functions always return whatever value software programmed for each, but otherwise are ignored by the component.
The CLKREQ  signal may also be controlled via the L1 PM Substates mechanism. Such control is not affected by the setting of this bit.

For Downstream Ports and components that do not support Clock Power Management (as indicated by a 0b value in the Clock Power Management bit of the Link Capabilities register), the controller hardwires this bit to 0b.

The write value is gated with the PCIE_CAP_CLOCK_POWER_MAN field in LINK_CAPABILITIES_REG.

Note: The access attributes of this field are as follows:
 - Wire: LINK_CAPABILITIES_REG.PCIE_CAP_CLOCK_POWER_MAN ? RWS : ROS 
 - Dbi: LINK_CAPABILITIES_REG.PCIE_CAP_CLOCK_POWER_MAN ? RWS : ROS 
Note: This register field is sticky.
                }
            }
            field PCIE_CAP_HW_AUTO_WIDTH_DISABLE @'h9 {
                access rw;
                hard_reset 'h0;
                doc {
                    Hardware Autonomous Width Disable.
When set, this bit disables hardware from changing the Link width for reasons other than attempting to correct unreliable Link operation by reducing Link width.

For a Multi-Function Device associated with an Upstream Port, the bit in Function 0 is of type RW, and only Function 0 controls the component's Link behavior. In all other Functions of that device, this bit is of type RsvdP.

For components that do not implement the ability autonomously to change Link width, the ciontroller hardwires this bit to 0b.

Note: The access attributes of this field are as follows:
 - Wire: R/W 
 - Dbi: R/W 
                }
            }
            field PCIE_CAP_LINK_BW_MAN_INT_EN @'ha {
                access rw;
                volatile 1
                hard_reset 'h0;
                soft_reset 'h0;
                doc {
                    Link Bandwidth Management Interrupt Enable. When set, this bit enables the generation of an interrupt to indicate that the Link Bandwidth Management Status bit has been set. The write value is gated with the PCIE_CAP_LINK_BW_NOT_CAP field in LINK_CAPABILITIES_REG.

This bit is not applicable and is Reserved for Endpoints, PCI Express-to-PCI/PCI-X bridges, and Upstream Ports of Switches.

For functions that do not implement the Link Bandwidth Notification Capability, the controller hardwires this bit to 0b.

Note: The access attributes of this field are as follows:
 - Wire: LINK_CAPABILITIES_REG.PCIE_CAP_LINK_BW_NOT_CAP ? RW : RO  
 - Dbi: LINK_CAPABILITIES_REG.PCIE_CAP_LINK_BW_NOT_CAP ? RW : RO  
                }
            }
            field PCIE_CAP_LINK_AUTO_BW_INT_EN @'hb {
                access rw;
                volatile 1
                hard_reset 'h0;
                soft_reset 'h0;
                doc {
                    Link Autonomous Bandwidth Management Interrupt Enable.
When set, this bit enables the generation of an interrupt to indicate that the Link Autonomous Bandwidth Status bit has been set. The write value is gated with the PCIE_CAP_LINK_BW_NOT_CAP field in LINK_CAPABILITIES_REG.

This bit is not applicable and is Reserved for Endpoints, PCI Express-to-PCI/PCI-X bridges, and Upstream Ports of Switches.

For functions that do not implement the Link Bandwidth Notification Capability, the controller hardwires this bit to 0b.

Note: The access attributes of this field are as follows:
 - Wire: LINK_CAPABILITIES_REG.PCIE_CAP_LINK_BW_NOT_CAP ? RW : RO 
 - Dbi: LINK_CAPABILITIES_REG.PCIE_CAP_LINK_BW_NOT_CAP ? RW : RO 
                }
            }
            field RSVDP_12 @'hc {
                bits 2;
                access ro;
                hard_reset 'h0;
                soft_reset 'h0;
                doc {
                    Reserved for future use.
                }
            }
            field PCIE_CAP_DRS_SIGNALING_CONTROL @'he {
                bits 2;
                access ro;
                hard_reset 'h0;
                doc {
                    DRS Signaling Control. Indicates the mechanism used to report reception of a DRS message. Must be implemented for Downstream Ports with the DRS Supported bit Set in the Link Capabilities 2 Register. Encodings are:
 - 00b: DRS not Reported
If DRS Supported is set, receiving a DRS Message will set DRS Message Received in the Link Status 2 Register but will otherwise have no effect
 - 01b: DRS Interrupt Enabled
If the DRS Message Received bit in the Link Status 2 Register transitions from 0 to 1, and either MSI or MSI-X is enabled, an MSI or MSI-X interrupt is generated using the vector in Interrupt Message Number (section 7.5.3.2)
 - 10b: DRS to FRS Signaling Enabled
If the DRS Message Received bit in the Link Status 2 Register transitions from 0 to 1, the Port must send an FRS Message Upstream with the FRS Reason field set to DRS Message Received.

Behavior is undefined if this field is set to 10b and the FRS Supported bit in the Device Capabilities 2 Register is Clear.

Behavior is undefined if this field is set to 11b.
For Downstream Ports with the DRS Supported bit clear in the Link Capabilities 2 register, the controller hardwires this field to 00b.
This field is Reserved for Upstream Ports.
                }
            }
            field PCIE_CAP_LINK_SPEED @'h10 {
                bits 4;
                access ro;
                volatile 1
                hard_reset 'h0;
                doc {
                    Current Link Speed. This field indicates the negotiated Link speed of the given PCI Express Link.
The encoded value specifies a bit location in the Supported Link Speeds Vector (in the Link Capabilities 2 register) that corresponds to the current Link speed.
Defined encodings are:
 - 0001b: Supported Link Speeds Vector field bit 0
 - 0010b: Supported Link Speeds Vector field bit 1
 - 0011b: Supported Link Speeds Vector field bit 2
 - 0100b: Supported Link Speeds Vector field bit 3
 - 0101b: Supported Link Speeds Vector field bit 4
 - 0110b: Supported Link Speeds Vector field bit 5
 - 0111b: Supported Link Speeds Vector field bit 6
All other encodings are Reserved.
The value in this field is undefined when the Link is not up.

                }
            }
            field PCIE_CAP_NEGO_LINK_WIDTH @'h14 {
                bits 6;
                access ro;
                volatile 1
                hard_reset 'h0;
                soft_reset 'h0;
                doc {
                    Negotiated Link Width. This field indicates the negotiated width of the given PCI Express Link.
Defined encodings are:
 -00 0001b: x1
 -00 0010b: x2
 -00 0100b: x4
 -00 1000b: x8
 -00 1100b: x12
 -01 0000b: x16
 -10 0000b: x32
All other encodings are Reserved. The value in this field is undefined when the Link is not up.
                }
            }
            field RSVDP_26 @'h1a {
                access ro;
                hard_reset 'h0;
                soft_reset 'h0;
                doc {
                    Reserved for future use.
                }
            }
            field PCIE_CAP_LINK_TRAINING @'h1b {
                access ro;
                volatile 1
                hard_reset 'h0;
                soft_reset 'h0;
                doc {
                    Link Training. This read-only bit indicates that the Physical Layer LTSSM is in the Configuration or Recovery state, or that 1b was written to the Retrain Link bit but Link training has not yet begun. Hardware clears this bit when the LTSSM exits the Configuration/Recovery state.

This bit is not applicable and Reserved for Endpoints, PCI Express to PCI/PCI-X bridges, and Upstream Ports of Switches, and the controller hardwires it to 0b.

Note: The access attributes of this field are as follows:
 - Wire: RSVDP 
 - Dbi: R 
                }
            }
            field PCIE_CAP_SLOT_CLK_CONFIG @'h1c {
                access ro;
                hard_reset 'h0;
                soft_reset 'h0;
                doc {
                    Slot Clock Configuration. This bit indicates that the component uses the same physical reference clock that the platform provides on the connector. If the device uses an independent clock irrespective of the presence of a reference clock on the connector, this bit must be clear.

For a Multi-Function Device, each Function must report the same value for this bit.

Note: The access attributes of this field are as follows:
 - Wire: HWINIT 
 - Dbi: if (DBI_RO_WR_EN == 1) then R/W else R 
                }
            }
            field PCIE_CAP_DLL_ACTIVE @'h1d {
                access ro;
                hard_reset 'h0;
                soft_reset 'h0;
                doc {
                    Data Link Layer Link Active. This bit indicates the status of the Data Link Control and Management State Machine. It returns a 1b to indicate the DL_Active state, 0b otherwise.

This bit must be implemented if the Data Link Layer Link Active Reporting Capable bit is 1b. Otherwise, the controller hardwires it to 0b.
                }
            }
            field PCIE_CAP_LINK_BW_MAN_STATUS @'h1e {
                access ro;
                hard_reset 'h0;
                soft_reset 'h0;
                doc {
                    Link Bandwidth Management Status. This bit is set by hardware to indicate that either of the following has occurred without the Port transitioning through DL_Down status:
 - A Link retraining has completed following a write of 1b to the Retrain Link bit.
Note: This bit is set following any write of 1b to the Retrain Link bit, including when the Link is in the process of retraining for some other reason.
 - Hardware has changed Link speed or width to attempt to correct unreliable Link operation, either through an LTSSM timeout or a higher level process.
This bit must be set if the Physical Layer reports a speed or width change was initiated by the Downstream component that was not indicated as an autonomous change.
This bit is not applicable and is Reserved for Endpoints, PCI Express-to-PCI/PCI-X bridges, and Upstream Ports of Switches.

For functions that do not implement the Link Bandwidth Notification Capability, the controller hardwires this bit to 0b.
The default value of this bit is 0b.

The write value is gated with the PCIE_CAP_LINK_BW_NOT_CAP field in LINK_CAPABILITIES_REG.

Note: The access attributes of this field are as follows:
 - Wire: RSVDP 
 - Dbi: R 
                }
            }
            field PCIE_CAP_LINK_AUTO_BW_STATUS @'h1f {
                access ro;
                hard_reset 'h0;
                soft_reset 'h0;
                doc {
                    Link Autonomous Bandwidth Status. This bit is set by hardware to indicate that hardware has autonomously changed Link speed or width, without the Port transitioning through DL_Down status, for reasons other than to attempt to correct unreliable Link operation.

This bit must be set if the Physical Layer reports a speed or width change was initiated by the Downstream component that was indicated as an autonomous change.

The write value is gated with the PCIE_CAP_LINK_BW_NOT_CAP field in LINK_CAPABILITIES_REG.

This bit is not applicable and is Reserved for Endpoints, PCI Express-to-PCI/PCI-X bridges, and Upstream Ports of Switches.

For functions that do not implement the Link Bandwidth Notification Capability, the controller hardwires this bit to 0b.

Note: The access attributes of this field are as follows:
 - Wire: RSVDP 
 - Dbi: R 
                }
            }
            doc {
                Link Control and Link Status Register.
This register controls and provides information about PCI Express Link specific parameters.Link Control and Link Status Register.
This register controls and provides information about PCI Express Link specific parameters.
            }
        }
        register DEVICE_CAPABILITIES2_REG @'h24 {
            bytes 4;
            field PCIE_CAP_CPL_TIMEOUT_RANGE @'h0 {
                bits 4;
                access ro;
                hard_reset 'h0;
                doc {
                    Completion Timeout Ranges Supported. This field indicates device Function support for the optional Completion Timeout programmability mechanism. This mechanism allows system software to modify the Completion Timeout value.
This field is applicable only to Root Ports, Endpoints that issue Requests on their own behalf, and PCI Express to PCI/PCI-X Bridges that take ownership of Requests issued on PCI Express. For all other Functions this field is Reserved and must be hardwired to 0000b.
Four time value ranges are defined:
 - Range A: 50 us to 10 ms
 - Range B: 10 ms to 250 ms
 - Range C: 250 ms to 4 s
 - Range D: 4 s to 64 s
Bits are set according to the list below to show timeout value ranges supported.
 - 0000b Completion Timeout programming not supported – the Function must implement a timeout value in the range 50 μs to 50 ms.
 - 0001b Range A
 - 0010b Range B
 - 0011b Ranges A and B
 - 0110b Ranges B and C
 - 0111b Ranges A, B, and C
 - 1110b Ranges B, C, and D
 - 1111b Ranges A, B, C, and D
All other values are Reserved.
It is strongly recommended that the Completion Timeout mechanism not expire in less than 10 ms.
                }
            }
            field PCIE_CAP_CPL_TIMEOUT_DISABLE_SUPPORT @'h4 {
                access ro;
                hard_reset 'h0;
                soft_reset 'h0;
                doc {
                    Completion Timeout Disable Supported. A value of 1b indicates support for the Completion Timeout Disable mechanism.
The Completion Timeout Disable mechanism is required for Endpoints that issue Requests on their own behalf and PCI Express to PCI/PCI-X Bridges that take ownership of Requests issued on PCI Express.

This mechanism is optional for Root Ports.

For all other Functions this field is Reserved and the controller hardwires this bit to 0b.
                }
            }
            field PCIE_CAP_ARI_FORWARD_SUPPORT @'h5 {
                access ro;
                hard_reset 'h0;
                soft_reset 'h0;
                doc {
                    ARI Forwarding Supported. Applicable only to Switch Downstream Ports and Root Ports; must be 0b for other Function types. This bit must be set to 1b if a Switch Downstream Port or Root Port supports this optional capability. For more details, see section 6.13 of PCI Express Base Specification.
                }
            }
            field PCIE_CAP_ATOMIC_ROUTING_SUPP @'h6 {
                access ro;
                hard_reset 'h0;
                soft_reset 'h0;
                doc {
                    AtomicOp Routing Supported. Applicable only to Switch Upstream Ports, Switch Downstream Ports, and Root Ports; must be 0b for other Function types. This bit must be set to 1b if the Port supports this optional capability. For more details, see section 6.15 of PCI Express Base Specification.
                }
            }
            field PCIE_CAP_32_ATOMIC_CPL_SUPP @'h7 {
                access ro;
                hard_reset 'h0;
                soft_reset 'h0;
                doc {
                    32-bit AtomicOp Completer Supported. Applicable to Functions with Memory Space BARs as well as all Root Ports; must be 0b otherwise. Includes FetchAdd, Swap, and CAS AtomicOps. This bit must be set to 1b if the Function supports this optional capability.  For more details on additional RC requirements, see section 6.15.3.1 of PCI Express Base Specification.
                }
            }
            field PCIE_CAP_64_ATOMIC_CPL_SUPP @'h8 {
                access ro;
                hard_reset 'h0;
                soft_reset 'h0;
                doc {
                    64-bit AtomicOp Completer Supported. Applicable to Functions with Memory Space BARs as well as all Root Ports; must be 0b otherwise. Includes FetchAdd, Swap, and CAS AtomicOps. This bit must be set to 1b if the Function supports this optional capability.  For more details on additional RC requirements, see section 6.15.3.1 of PCI Express Base Specification.
                }
            }
            field PCIE_CAP_128_CAS_CPL_SUPP @'h9 {
                access ro;
                hard_reset 'h0;
                soft_reset 'h0;
                doc {
                    128-bit CAS Completer Supported. Applicable to Functions with Memory Space BARs as well as all Root Ports; must be 0b otherwise. This bit must be set to 1b if the Function supports this optional capability. For more details, see section 6.15 of PCI Express Base Specification.
                }
            }
            field PCIE_CAP_NO_RO_EN_PR2PR_PAR @'ha {
                access ro;
                hard_reset 'h0;
                soft_reset 'h0;
                doc {
                    No RO-enabled PR-PR Passing. If this bit is set, the routing element never carries out the passing permitted by Table 2-39 of PCI Express Base Specification entry A2b that is associated with the Relaxed Ordering Attribute field being Set.
This bit applies only for Switches and RCs that support peer-to-peer traffic between Root Ports. This bit applies only to Posted Requests being forwarded through the Switch or RC and does not apply to traffic originating or terminating within the Switch or RC itself. All Ports on a Switch or RC must report the same value for this bit.
For all other functions, this bit must be 0b.
                }
            }
            field PCIE_CAP_LTR_SUPP @'hb {
                access ro;
                hard_reset 'h0;
                soft_reset 'h0;
                doc {
                    LTR Mechanism Supported. A value of 1b indicates support for the optional Latency Tolerance Reporting (LTR) mechanism.
Root Ports, Switches and Endpoints are permitted to implement this capability.
For a Multi-Function Device associated with an Upstream Port, each Function must report the same value for this bit.
For Bridges and other Functions that do not implement this capability, the controller hardwires this bit to 0b.
                }
            }
            field PCIE_CAP_TPH_CMPLT_SUPPORT_0 @'hc {
                access ro;
                hard_reset 'h0;
                soft_reset 'h0;
                doc {
                    TPH Completer Supported Bit 0. Value of this bit along with TPH Completer Supported Bit 1 indicates Completer support for TPH or Extended TPH. Applicable only to Root Ports and Endpoints. For all other Functions, this field is Reserved.
Defined Encodings are:
 - 00b: TPH and Extended TPH Completer not supported.
 - 01b: TPH Completer supported; Extended TPH Completer not supported.
 - 10b: Reserved.
 - 11b: Both TPH and Extended TPH Completer supported.
For more details, see section 6.17 of PCI Express Base Specification.
                }
            }
            field PCIE_CAP_TPH_CMPLT_SUPPORT_1 @'hd {
                access ro;
                hard_reset 'h0;
                soft_reset 'h0;
                doc {
                    TPH Completer Supported Bit 1.
                }
            }
            field PCIE_CAP2_LN_SYS_CLS @'he {
                bits 2;
                access ro;
                hard_reset 'h0;
                soft_reset 'h0;
                doc {
                    LN System CLS. Applicable only to Root Ports and RCRBs; must be 00b for all other Function types. This field indicates if the Root Port or RCRB supports LN protocol as an LN Completer, and if so, what cacheline size is in effect.
Encodings are:
 - 00b LN Completer either not supported or not in effect
 - 01b LN Completer with 64-byte cachelines in effect
 - 10b LN Completer with 128-byte cachelines in effect
 - 11b Reserved
Note: This register field is sticky.
                }
            }
            field PCIE_CAP2_10_BIT_TAG_COMP_SUPPORT @'h10 {
                access ro;
                hard_reset 'h0;
                soft_reset 'h0;
                doc {
                    10-Bit Tag Completer Supported. If this bit is set, the Function supports 10-Bit Tag Completer capability; otherwise, the Function does not. For more details, see section 2.2.6.2. of PCI Express Base Specification.
                }
            }
            field PCIE_CAP2_10_BIT_TAG_REQ_SUPPORT @'h11 {
                access ro;
                hard_reset 'h0;
                doc {
                    10-Bit Tag Requester Supported. If this bit is set, the Function supports 10-Bit Tag Requester capability; otherwise, the Function does not.

This bit must not be set if the 10-Bit Tag Completer Supported bit is clear.

Note: 10-Bit Tag field generation must be enabled by the 10-Bit Tag Requester Enable bit in the Device Control 2 register of the Requester Function before 10-Bit Tags can be generated by the Requester. For more details, see section 2.2.6.2. of PCI Express Base Specification.
                }
            }
            field PCIE_CAP_OBFF_SUPPORT @'h12 {
                bits 2;
                access ro;
                hard_reset 'h0;
                soft_reset 'h0;
                doc {
                    OBFF Supported. This field indicates if OBFF is supported and, if so, what signaling mechanism is used.
 - 00b: OBFF Not Supported
 - 01b: OBFF supported using Message signaling only
 - 10b: OBFF supported using WAKE  signaling only
 - 11b:  OBFF supported using WAKE  and Message signaling
The value reported in this field must indicate support for WAKE  signaling only if:
 - for a Downstream Port, driving the WAKE  signal for OBFF is supported and the connector or component connected Downstream is known to receive that same WAKE  signal
 - for an Upstream Port, receiving the WAKE  signal for OBFF is supported and, if the component is on an add-in-card, that the component is connected to the WAKE  signal on theconnector.
Root Ports, Switch Ports, and Endpoints are permitted to implement this capability.

For a Multi-Function Device associated with an Upstream Port, each Function must report the same value for this field.

For Bridges and Ports that do not implement this capability, the controller hardwires this field to 00b.
                }
            }
            field RSVDP_24 @'h18 {
                bits 7;
                access ro;
                hard_reset 'h0;
                soft_reset 'h0;
                doc {
                    Reserved for future use.
                }
            }
            field PCIE_CAP_FRS_SUPPORTED @'h1f {
                access ro;
                hard_reset 'h0;
                doc {
                    FRS Supported. When set, indicates support for the optional Function Readiness Status (FRS) capability.

Must be set for all Functions that support generation or reception capabilities of FRS Messages.

Must not be set by Switch Functions that do not generate FRS Messages on their own behalf.

Note: The access attributes of this field are as follows:
 - Wire: HWINIT 
 - Dbi: if (DBI_RO_WR_EN == 1) then R/W(sticky) else R(sticky) 
                }
            }
            doc {
                Device Capabilities 2 Register.Device Capabilities 2 Register.
            }
        }
        register DEVICE_CONTROL2_DEVICE_STATUS2_REG @'h28 {
            bytes 4;
            field PCIE_CAP_CPL_TIMEOUT_VALUE @'h0 {
                bits 4;
                access rw;
                hard_reset 'h0;
                soft_reset 'h0;
                doc {
                    Completion Timeout Value. In device Functions that support Completion Timeout programmability, this field allows system software to modify the Completion Timeout value. This field is applicable to Root Ports, Endpoints that issue Requests on their own behalf, and PCI Express to PCI/PCI-X Bridges that take ownership of Requests issued on PCI Express. For all other Functions this field is Reserved and controller hardwires it to 0000b.
A Function that does not support this optional capability must hardwire this field to 0000b and is required to implement a timeout value in the range 50 μs to 50 ms. Functions that support Completion Timeout programmability must support the values given below corresponding to the programmability ranges indicated in the Completion Timeout Ranges Supported field.
Defined encodings:
 - 0000b Default range: 50 μs to 50 ms
It is strongly recommended that the Completion Timeout mechanism not expire in less than 10 ms.

Values available if Range A (50 μs to 10 ms) programmability range is supported:
 - 0001b: 50 μs to 100 μs
 - 0010b: 1 ms to 10 ms
Values available if Range B (10 ms to 250 ms) programmability range is supported:
 - 0101b 16 ms to 55 ms
 - 0110b 65 ms to 210 ms
Values available if Range C (250 ms to 4 s) programmability range is supported:
 - 1001b 260 ms to 900 ms
 - 1010b 1 s to 3.5 s
Values available if the Range D (4 s to 64 s) programmability range is supported:
 - 1101b 4 s to 13 s
 - 1110b 17 s to 64 s
Values not defined above are Reserved.

Software is permitted to change the value in this field at any time. For Requests already pending when the Completion Timeout Value is changed, hardware is permitted to use either the new or the old value for the outstanding Requests, and is permitted to base the start time for each Request either on when this value was changed or on when each request was issued.

Note: The access attributes of this field are as follows:
 - Wire: R/W 
 - Dbi: R/W 
                }
            }
            field PCIE_CAP_CPL_TIMEOUT_DISABLE @'h4 {
                access rw;
                hard_reset 'h0;
                soft_reset 'h0;
                doc {
                    Completion Timeout Disable. When set, this bit disables the Completion Timeout mechanism.
This bit is required for all Functions that support the Completion Timeout Disable Capability. Functions that do not support this optional capability are permitted to hardwire this bit to 0b

Software is permitted to set or clear this bit at any time. When set, the Completion Timeout detection mechanism is disabled. If there are outstanding Requests when the bit is cleared, it is permitted but not required for hardware to apply the completion timeout mechanism to the outstanding Requests. If this is done, it is permitted to base the start time for each Request on either the time this bit was cleared or the time each Request was issued.
                }
            }
            field PCIE_CAP_ARI_FORWARD_SUPPORT_CS @'h5 {
                access ro;
                hard_reset 'h0;
                soft_reset 'h0;
                doc {
                    ARI Forwarding Enable. When set, the Downstream Port disables its traditional Device Number field being 0 enforcement when turning a Type 1 Configuration Request into a Type 0 Configuration Request, permitting access to Extended Functions in an ARI Device immediately below the Port. For more details, see Section 6.13 of PCI Express Base Specification.
                }
            }
            doc {
                Device Control 2 and Status 2 Register.Device Control 2 and Status 2 Register.
            }
        }
        register LINK_CAPABILITIES2_REG @'h2c {
            bytes 4;
            field RSVDP_0 @'h0 {
                access ro;
                hard_reset 'h0;
                soft_reset 'h0;
                doc {
                    Reserved for future use.
                }
            }
            field PCIE_CAP_SUPPORT_LINK_SPEED_VECTOR @'h1 {
                bits 7;
                access ro;
                volatile 1
                hard_reset 'h0;
                soft_reset 'h0;
                doc {
                    Supported Link Speeds Vector. This field indicates the supported Link speed(s) of the associated Port. For each bit, a value of 1b indicates that the corresponding Link speed is supported; otherwise, the Link speed is not supported. For more details, see section 8.2.1 of PCI Express Base Specification.
Bit definitions within this field are:
 - Bit 0 2.5 GT/s
 - Bit 1 5.0 GT/s
 - Bit 2 8.0 GT/s
 - Bit 3 16.0 GT/s
 - Bits 6:4 RsvdP
Multi-Function Devices associated with an Upstream Port must report the same value in this field for all Functions.

This field has a default of (PCIE_CAP_MAX_LINK_SPEED == 0100) ? 0001111 : (PCIE_CAP_MAX_LINK_SPEED == 0011) ? 0000111 : (PCIE_CAP_MAX_LINK_SPEED == 0010) ? 0000011 : 0000001 where PCIE_CAP_MAX_LINK_SPEED is a field in the LINK_CAPABILITIES_REG register.
                }
            }
            field PCIE_CAP_CROSS_LINK_SUPPORT @'h8 {
                access ro;
                hard_reset 'h0;
                soft_reset 'h0;
                doc {
                    Crosslink Supported. When set to 1b, this bit indicates that the associated Port supports crosslinks (for more details, see section 4.2.6.3.1 of PCI Express Base Specification). When set to 0b on a Port that supports Link speeds of 8.0 GT/s or higher, this bit indicates that the associated Port does not support crosslinks. When set to 0b on a Port that only supports Link speeds of 2.5 GT/s or 5.0 GT/s, this bit provides no information regarding the Port’s level of crosslink support.
It is recommended that this bit be Set in any Port that supports crosslinks even though doing so is only required for Ports that also support operating at 8.0 GT/s or higher Link speeds.

Note: Software should use this bit when referencing fields whose definition depends on whether or not the Port supports crosslinks (for more details, see section 7.7.3.4 of PCI Express Base Specification).

Multi-Function Devices associated with an Upstream Port must report the same value in this field for all Functions.
                }
            }
            field RSVDP_9 @'h9 {
                bits 14;
                access ro;
                hard_reset 'h0;
                soft_reset 'h0;
                doc {
                    Reserved for future use.
                }
            }
            field PCIE_CAP_RETIMER_PRE_DET_SUPPORT @'h17 {
                access ro;
                hard_reset 'h0;
                doc {
                    Retimer Presence Detect Supported. When set to 1b, this bit indicates that the associated Port supports detection and reporting of Retimer presence.

This bit must be set to 1b in a Port when the Supported Link Speeds Vector of the Link Capabilities 2 register indicates support for a Link speed of 16.0 GT/s or higher.
It is permitted to be set to 1b regardless of the supported Link speeds.

Multi-Function Devices associated with an Upstream Port must report the same value in this field for all Functions.

Note: The access attributes of this field are as follows:
 - Wire: HWINIT 
 - Dbi: if (DBI_RO_WR_EN == 1) then R/W(sticky) else R(sticky) 
                }
            }
            field PCIE_CAP_TWO_RETIMERS_PRE_DET_SUPPORT @'h18 {
                access ro;
                volatile 1
                hard_reset 'h0;
                doc {
                    Two Retimers Presence Detect Supported. When set to 1b, this bit indicates that the associated Port supports detection and reporting of two Retimers presence.

This bit must be set to 1b in a Port when the Supported Link Speeds Vector of the Link Capabilities 2 register indicates support for a Link speed of 16.0 GT/s or higher.
It is permitted to be set to 1b regardless of the supported Link speeds if the Retimer Presence Detect Supported bit is also set to 1b.

Multi-Function Devices associated with an Upstream Port must report the same value in this field for all Functions.

Note: The access attributes of this field are as follows:
 - Wire: HWINIT 
 - Dbi: if (DBI_RO_WR_EN == 1) then R/W(sticky) else R(sticky) 
                }
            }
            field RSVDP_25 @'h19 {
                bits 6;
                access ro;
                hard_reset 'h0;
                soft_reset 'h0;
                doc {
                    Reserved for future use.
                }
            }
            field DRS_SUPPORTED @'h1f {
                access ro;
                hard_reset 'h0;
                doc {
                    DRS Supported. When set, indicates support for the optional Device Readiness Status (DRS) capability.
Must be Set in Downstream Ports that support DRS.
Must be Set in Downstream Ports that support FRS.

For Upstream Ports that support DRS, it is strongly recommended that this bit be Set in Function 0. For all other Functions associated with an Upstream Port, this bit must be Clear.127

Must be Clear in Functions that are not associated with a Port.

RsvdP in all other Functions.

Note: The access attributes of this field are as follows:
 - Wire: HWINIT 
 - Dbi: if (DBI_RO_WR_EN == 1) then R/W else R 
                }
            }
            doc {
                Link Capabilities 2 Register.Link Capabilities 2 Register.
            }
        }
        register LINK_CONTROL2_LINK_STATUS2_REG @'h30 {
            bytes 4;
            field PCIE_CAP_TARGET_LINK_SPEED @'h0 {
                bits 4;
                access rw;
                volatile 1
                hard_reset 'h0;
                doc {
                    Target Link Speed. For Downstream Ports, this field sets an upper limit on Link operational speed by restricting the values advertised by the Upstream component in its training sequences.
The encoded value specifies a bit location in the Supported Link Speeds Vector (in the Link Capabilities 2 register) that corresponds to the desired target Link speed.
Defined encodings are:
 - 0001b: Supported Link Speeds Vector field bit 0
 - 0010b: Supported Link Speeds Vector field bit 1
 - 0011b: Supported Link Speeds Vector field bit 2
 - 0100b: Supported Link Speeds Vector field bit 3
 - 0101b: Supported Link Speeds Vector field bit 4
 - 0110b: Supported Link Speeds Vector field bit 5
 - 0111b: Supported Link Speeds Vector field bit 6
All other encodings are Reserved.

If a value is written to this field that does not correspond to a supported speed (as indicated by the Supported Link Speeds Vector), the result is undefined.

If either of the Enter Compliance or Enter Modified Compliance bits are implemented, then this field must also be implemented.

The default value of this field is the highest Link speed supported by the component (as reported in the Max Link Speed field of the Link Capabilities register) unless the corresponding platform/form factor requires a different default value.

For both Upstream and Downstream Ports, this field is used to set the target compliance mode speed when software is using the Enter Compliance bit to force a Link into compliance mode.

For Upstream Ports, if the Enter Compliance bit is Clear, this field is permitted to have no effect.

For a Multi-Function Device associated with an Upstream Port, the field in Function 0 is of type RWS, and only Function 0 controls the component’s Link behavior. In all other Functions of that device, this field is of type RsvdP.

Components that support only the 2.5 GT/s speed are permitted to hardwire this field to 0000b.
For a description of this standard PCIe register field, see the PCI Express Base Specification.

 In M-PCIe mode, the contents of this field are derived from other registers.

Note: This register field is sticky.
                }
            }
            field PCIE_CAP_ENTER_COMPLIANCE @'h4 {
                access rw;
                volatile 1
                hard_reset 'h0;
                doc {
                    Enter Compliance. Software is permitted to force a Link to enter Compliance mode (at the speed indicated in the Target Link Speed field and the de-emphasis/preset level indicated by the Compliance Preset/De-emphasis field) by setting this bit to 1b in both components on a Link and then initiating a hot reset on the Link.

Default value of this bit following Fundamental Reset is 0b.

For a Multi-Function Device associated with an Upstream Port, the bit in Function 0 is of type RWS, and only Function 0 controls the component’s Link behavior. In all other Functions of that device, this bit is of type RsvdP.

Components that support only the 2.5 GT/s speed are permitted to hardwire this bit to 0b.

This bit is intended for debug, compliance testing purposes only. System firmware and software is allowed to modify this bit only during debug or compliance testing. In all other cases, the system must ensure that this bit is set to the default value.

Note: This register field is sticky.
                }
            }
            field PCIE_CAP_HW_AUTO_SPEED_DISABLE @'h5 {
                access rw;
                hard_reset 'h0;
                doc {
                    Hardware Autonomous Speed Disable. When set, this bit disables hardware from changing the Link speed for device-specific reasons other than attempting to correct unreliable Link operation by reducing Link speed. Initial transition to the highest supported common link speed is not blocked by this bit.

For a Multi-Function Device associated with an Upstream Port, the bit in Function 0 is of type RWS, and only Function 0 controls the component's Link behavior. In all other Functions of that device, this bit is of type RsvdP.

Functions that do not implement the associated mechanism are permitted to hardwire this bit to 0b.

Note: The access attributes of this field are as follows:
 - Wire: R/W (sticky) 
 - Dbi: R/W (sticky) 
Note: This register field is sticky.
                }
            }
            field PCIE_CAP_SEL_DEEMPHASIS @'h6 {
                access ro;
                hard_reset 'h0;
                doc {
                    Selectable De-emphasis. When the Link is operating at 5.0 GT/s speed, this bit is used to control the transmit de-emphasis of the link in specific situations. For more details, see section 4.2.6 of PCI Express Base Specification.
Encodings:
 - 1b: -3.5 dB
 - 0b: -6 dB
When the Link is not operating at 5.0 GT/s speed, the setting of this bit has no effect. Components that support only the 2.5 GT/s speed are permitted to hardwire this bit to 0b.

This bit is not applicable and Reserved for Endpoints, PCI Express to PCI/PCI-X bridges, and Upstream Ports of Switches.

Note: This register field is sticky.
                }
            }
            field PCIE_CAP_TX_MARGIN @'h7 {
                bits 3;
                access rw;
                volatile 1
                hard_reset 'h0;
                doc {
                    Transmit Margin – This field controls the value of the non-deemphasized voltage level at the Transmitter pins. This field is reset to 000b on entry to the LTSSM Polling.Configuration substate (see Chapter 4 of PCI Express Base Specification for details of how the Transmitter voltage level is determined in various states).
Encodings:
 - 000b: Normal operating range
 - 001b-111b: As defined in Section 8.3.4 not all encodings are required to be implemented.
For a Multi-Function Device associated with an Upstream Port, the field in Function 0 is of type RWS, and only Function 0 controls the component’s Link behavior. In all other Functions of that device, this field is of type RsvdP.

For components that support only the 2.5 GT/s speed, the controller hardwires this bit to 000b.

This field is intended for debug, compliance testing purposes only. System firmware and software is allowed to modify this field only during debug or compliance testing. In all other cases, the system must ensure that this field is set to the default value.

Note: This register field is sticky.
                }
            }
            field PCIE_CAP_ENTER_MODIFIED_COMPLIANCE @'ha {
                access rw;
                hard_reset 'h0;
                doc {
                    Enter Modified Compliance. When this bit is set to 1b, the device transmits Modified Compliance Pattern if the LTSSM enters Polling.Compliance substate.
Components that support only the 2.5 GT/s speed are permitted to hardwire this bit to 0b.

For a Multi-Function Device associated with an Upstream Port, the bit in Function 0 is of type RWS, and only Function 0 controls the component's Link behavior. In all other Functions of that device, this bit is of type RsvdP.

This bit is intended for debug, compliance testing purposes only. System firmware and software is allowed to modify this bit only during debug or compliance testing. In all other cases, the system must ensure that this bit is set to the default value.

Note: The access attributes of this field are as follows:
 - Wire: R/W (sticky) 
 - Dbi: R/W (sticky) 
Note: This register field is sticky.
                }
            }
            field PCIE_CAP_COMPLIANCE_SOS @'hb {
                access rw;
                volatile 1
                hard_reset 'h0;
                doc {
                    Compliance SOS. When set to 1b, the LTSSM is required to send SKP Ordered Sets between sequences when sending the Compliance Pattern or Modified Compliance Pattern.

For a Multi-Function Device associated with an Upstream Port, the bit in Function 0 is of type RWS, and only Function 0 controls the component’s Link behavior. In all other Functions of that device, this bit is of type RsvdP.

This bit is applicable when the Link is operating at 2.5 GT/s or 5.0 GT/s data rates only.

For components that support only the 2.5 GT/s speed, the controller hardwires this bit to 0b.

Note: The access attributes of this field are as follows:
 - Wire: R/W (sticky) 
 - Dbi: R/W (sticky) 
Note: This register field is sticky.
                }
            }
            field PCIE_CAP_COMPLIANCE_PRESET @'hc {
                bits 4;
                access rw;
                volatile 1
                hard_reset 'h0;
                doc {
                    Compliance Preset/De-emphasis.
For 8.0 GT/s and higher Data Rate: This field sets the Transmitter Preset in Polling.Compliance state if the entry occurred due to the Enter Compliance bit being 1b. The encodings are defined in section 4.2.3.2 of PCI Express Base Specification . Results are undefined if a reserved preset encoding is used when entering Polling.Compliance in this way.

For 5.0 GT/s Data Rate: This field sets the de-emphasis level in Polling.Compliance state if the entry occurred due to the Enter Compliance bit being 1b.
Defined Encodings are:
 - 0001b: -3.5 dB
 - 0000b: -6 dB
When the Link is operating at 2.5 GT/s, the setting of this field has no effect. Components that support only 2.5 GT/s speed are permitted to hardwire this field to 0000b.

For a Multi-Function Device associated with an Upstream Port, the field in Function 0 is of type RWS, and only Function 0 controls the component's Link behavior. In all other Functions of that device, this field is of type RsvdP.

This field is intended for debug and compliance testing purposes. System firmware and software is allowed to modify this field only during debug or compliance testing. In all other cases, the system must ensure that this field is set to the default value.

Note: The access attributes of this field are as follows:
 - Wire: R/W (sticky) 
 - Dbi: R/W (sticky) 
Note: This register field is sticky.
                }
            }
            field PCIE_CAP_CURR_DEEMPHASIS @'h10 {
                access ro;
                volatile 1
                hard_reset 'h0;
                soft_reset 'h0;
                doc {
                    Current De-emphasis Level. When the Link is operating at 5.0 GT/s speed, this bit reflects the level of de-emphasis.
Encodings:
 - 1b: -3.5 dB
 - 0b: -6 dB
The value in this bit is undefined when the Link is not operating at 5.0 GT/s speed.
Components that support only the 2.5 GT/s speed are permitted to hardwire this bit to 0b.
For components that support speeds greater than 2.5 GT/s, Multi-Function Devices associated with an Upstream Port must report the same value in this field for all Functions of the Port.

 In M-PCIe mode this register is always 0x0. In C-PCIe mode, its contents are derived by sampling the PIPE.
                }
            }
            field PCIE_CAP_EQ_CPL @'h11 {
                access ro;
                volatile 1
                hard_reset 'h0;
                doc {
                    Equalization 8.0 GT/s Complete. When set to 1b, this bit indicates that the Transmitter Equalization procedure at the 8.0 GT/s data rate has completed. Details of the Transmitter Equalization process and when this bit needs to be set to 1b is provided in section 4.2.6.4.2 of PCI Express Base Specification.

For Multi-Function Upstream Port, this bit must be implemented in Function 0 and RsvdZ in other Functions. For components that only support speeds below 8.0 GT/s, the controller hardwires this bit to 0b.

Note: This register field is sticky.
                }
            }
            field PCIE_CAP_EQ_CPL_P1 @'h12 {
                access ro;
                volatile 1
                hard_reset 'h0;
                doc {
                    Equalization 8.0 GT/s Phase 1 Successful. When set to 1b, this bit indicates that Phase 1 of the 8.0 GT/s Transmitter Equalization procedure has successfully completed. Details of the Transmitter Equalization process and when this bit needs to be set to 1b is provided in section 4.2.6.4.2 of PCI Express Base Specification.

For Multi-Function Upstream Port, this bit must be implemented in Function 0 and RsvdZ in other Functions. For components that only support speeds below 8.0 GT/s, the controller hardwires this bit to 0b.

Note: This register field is sticky.
                }
            }
            field PCIE_CAP_EQ_CPL_P2 @'h13 {
                access ro;
                volatile 1
                hard_reset 'h0;
                doc {
                    Equalization 8.0 GT/s Phase 2 Successful. When set to 1b, this bit indicates that Phase 2 of the 8.0 GT/s Transmitter Equalization procedure has successfully completed. Details of the Transmitter Equalization process and when this bit needs to be set to 1b is provided in section 4.2.6.4.2 of PCI Express Base Specification.

For Multi-Function Upstream Port, this bit must be implemented in Function 0 and RsvdZ in other Functions. For components that only support speeds below 8.0 GT/s, the controller hardwires this bit to 0b.

Note: This register field is sticky.
                }
            }
            field PCIE_CAP_EQ_CPL_P3 @'h14 {
                access ro;
                volatile 1
                hard_reset 'h0;
                doc {
                    EEqualization 8.0 GT/s Phase 3 Successful. When set to 1b, this bit indicates that Phase 3 of the 8.0 GT/s Transmitter Equalization procedure has successfully completed. Details of the Transmitter Equalization process and when this bit needs to be set to 1b is provided in section 4.2.6.4.2 of PCI Express Base Specification.

For Multi-Function Upstream Port, this bit must be implemented in Function 0 and RsvdZ in other Functions. For components that only support speeds below 8.0 GT/s, the controller hardwires this bit to 0b.

Note: This register field is sticky.
                }
            }
            field PCIE_CAP_LINK_EQ_REQ @'h15 {
                access w1c;
                volatile 1
                hard_reset 'h0;
                doc {
                    Link Equalization Request 8.0 GT/s. This bit is set by hardware to request the 8.0 GT/s Link equalization process to be performed on the Link. For more details, see sections 4.2.3 and 4.2.6.4.2 of PCI Express Base Specification.

For Multi-Function Upstream Port, this bit must be implemented in Function 0 and RsvdZ in other Functions. For components that only support speeds below 8.0 GT/s, the controller hardwires this bit to 0b.
                }
            }
            field PCIE_CAP_RETIMER_PRE_DET @'h16 {
                access ro;
                volatile 1
                hard_reset 'h0;
                soft_reset 'h0;
                doc {
                    Retimer Presence Detected. When set to 1b, this bit indicates that a Retimer was present during the most recent Link negotiation. For more details, see section 4.2.6.3.5.1 of PCI Express Base Specification.

This bit is required for Ports that have the Retimer Presence Detect Supported bit of the Link Capabilities 2 register set to 1b.

For Ports that have the Retimer Presence Detect Supported bit set to 0b, the controller hardwires this bit to 0b.

For Multi-Function Devices associated with an Upstream Port, this bit must be implemented in Function 0 and is RsvdZ in all other Functions.

Note: This register field is sticky.
                }
            }
            field PCIE_CAP_TWO_RETIMERS_PRE_DET @'h17 {
                access ro;
                volatile 1
                hard_reset 'h0;
                soft_reset 'h0;
                doc {
                    Two Retimers Presence Detected. When set to 1b, this bit indicates that two Retimers were present during the most recent Link negotiation. For more details, see section 4.2.6.3.5.1  of PCI Express Base Specification.

This bit is required for Ports that have the Two Retimers Presence Detect Supported bit of the Link Capabilities 2 register set to 1b.

Ports that have the Two Retimers Presence Detect Supported bit set to 0b are permitted to hardwire this bit to 0b.

For Multi-Function Devices associated with an Upstream Port, this bit must be implemented in Function 0 and RsvdZ in all other Functions.

Note: This register field is sticky.
                }
            }
            field RSVDP_26 @'h1a {
                bits 2;
                access ro;
                hard_reset 'h0;
                soft_reset 'h0;
                doc {
                    Reserved for future use.
                }
            }
            field DOWNSTREAM_COMPO_PRESENCE @'h1c {
                bits 3;
                access ro;
                hard_reset 'h0;
                soft_reset 'h0;
                doc {
                    Downstream Component Presence. This field indicates the presence and DRS status for the Downstream Component, if any, connected to the Link; defined values are:
 - 000b: Link Down – Presence Not Determined
 - 001b: Link Down – Component Not Present indicates the Downstream Port (DP) has determined that a Downstream Component is not present
 - 010b: Link Down – Component Present indicates the DP has determined that a Downstream Component is present, but the Data Link Layer is not active
 - 011b: Reserved
 - 100b: Link Up – Component Presentindicates the DP has determined that a Downstream Component is present, but no DRS Message has been received since the Data Link Layer became active
 - 101b: Link Up – Component Present and DRS Received indicates the DP has received a DRS Message since the Data Link Layer became active
 - 110b: Reserved
 - 111b: Reserved
Component Presence state must be determined by the logical "OR" of the Physical Layer in-band presence detect mechanism and, if present, any out-of-band presence detect mechanism implemented for the Link. If no out-of-band presence detect mechanism is implemented, then Component Presence state must be determined solely by the Physical Layer in-band presence detect mechanism.

This field must be implemented in any Downstream Port where the DRS Supported bit is Set in the Link Capabilities 2 register.

This field is RsvdZ for all other Functions.
                }
            }
            field DRS_MESSAGE_RECEIVED @'h1f {
                access ro;
                hard_reset 'h0;
                soft_reset 'h0;
                doc {
                    DRS Message Received. This bit must be set whenever the Port receives a DRS Message.
This bit must be cleared in DL_Down.

This bit must be implemented in any Downstream Port where the DRS Supported bit is Set in the Link Capabilities 2 register.

This bit is RsvdZ for all other Functions.
                }
            }
            doc {
                Link Control 2 and Status 2 Register.Link Control 2 and Status 2 Register.
            }
        }
        doc {
            PF PCI Express Capability Structure
        }
    }
    block PF0_AER_CAP @'h100 {
        bytes 4;
        register AER_EXT_CAP_HDR_OFF @'h0 {
            bytes 4;
            field CAP_ID @'h0 {
                bits 16;
                access ro;
                hard_reset 'h0;
                doc {
                    AER Extended Capability ID.
For a description of this standard PCIe register field, see the PCI Express Specification.

Note: The access attributes of this field are as follows:
 - Wire: R (sticky) 
 - Dbi: if (DBI_RO_WR_EN == 1) then R/W(sticky) else R(sticky) 
Note: This register field is sticky.
                }
            }
            field CAP_VERSION @'h10 {
                bits 4;
                access ro;
                hard_reset 'h0;
                doc {
                    Capability Version.
For a description of this standard PCIe register field, see the PCI Express Specification.

Note: The access attributes of this field are as follows:
 - Wire: R (sticky) 
 - Dbi: if (DBI_RO_WR_EN == 1) then R/W(sticky) else R(sticky) 
Note: This register field is sticky.
                }
            }
            field NEXT_OFFSET @'h14 {
                bits 12;
                access ro;
                hard_reset 'h0;
                doc {
                    Next Capability Offset.
For a description of this standard PCIe register field, see the PCI Express Specification.

Note: The access attributes of this field are as follows:
 - Wire: R (sticky) 
 - Dbi: if (DBI_RO_WR_EN == 1) then R/W(sticky) else R(sticky) 
Note: This register field is sticky.
                }
            }
            doc {
                Advanced Error Reporting Extended Capability Header.
For a description of this standard PCIe register, see the PCI Express Specification.Advanced Error Reporting Extended Capability Header.
For a description of this standard PCIe register, see the PCI Express Specification.
            }
        }
        register UNCORR_ERR_STATUS_OFF @'h4 {
            bytes 4;
            field RSVDP_0 @'h0 {
                bits 4;
                access ro;
                hard_reset 'h0;
                soft_reset 'h0;
                doc {
                    Reserved for future use.
                }
            }
            field DL_PROTOCOL_ERR_STATUS @'h4 {
                access w1c;
                volatile 1
                hard_reset 'h0;
                doc {
                    Data Link Protocol Error Status.
For a description of this standard PCIe register field, see the PCI Express Specification.
                }
            }
            field SURPRISE_DOWN_ERR_STATUS @'h5 {
                access w1c;
                volatile 1
                hard_reset 'h0;
                doc {
                    Surprise Down Error Status (Optional).
For a description of this standard PCIe register field, see the PCI Express Specification.
                }
            }
            field RSVDP_6 @'h6 {
                bits 6;
                access ro;
                hard_reset 'h0;
                soft_reset 'h0;
                doc {
                    Reserved for future use.
                }
            }
            field POIS_TLP_ERR_STATUS @'hc {
                access w1c;
                volatile 1
                hard_reset 'h0;
                doc {
                    Poisoned TLP Status.
For a description of this standard PCIe register field, see the PCI Express Specification.
                }
            }
            field FC_PROTOCOL_ERR_STATUS @'hd {
                access w1c;
                volatile 1
                hard_reset 'h0;
                doc {
                    Flow Control Protocol Error Status.
For a description of this standard PCIe register field, see the PCI Express Specification.
                }
            }
            field CMPLT_TIMEOUT_ERR_STATUS @'he {
                access w1c;
                volatile 1
                hard_reset 'h0;
                doc {
                    Completion Timeout Status.
For a description of this standard PCIe register field, see the PCI Express Specification.
                }
            }
            field CMPLT_ABORT_ERR_STATUS @'hf {
                access w1c;
                volatile 1
                hard_reset 'h0;
                doc {
                    Completer Abort Status.
For a description of this standard PCIe register field, see the PCI Express Specification.
                }
            }
            field UNEXP_CMPLT_ERR_STATUS @'h10 {
                access w1c;
                volatile 1
                hard_reset 'h0;
                doc {
                    Unexpected Completion Status.
For a description of this standard PCIe register field, see the PCI Express Specification.
                }
            }
            field REC_OVERFLOW_ERR_STATUS @'h11 {
                access w1c;
                volatile 1
                hard_reset 'h0;
                doc {
                    Receiver Overflow Status.
For a description of this standard PCIe register field, see the PCI Express Specification.
                }
            }
            field MALF_TLP_ERR_STATUS @'h12 {
                access w1c;
                volatile 1
                hard_reset 'h0;
                doc {
                    Malformed TLP Status.
For a description of this standard PCIe register field, see the PCI Express Specification.
                }
            }
            field ECRC_ERR_STATUS @'h13 {
                access w1c;
                volatile 1
                hard_reset 'h0;
                doc {
                    ECRC Error Status.
For a description of this standard PCIe register field, see the PCI Express Specification.

Note:If CX_ECRC_ENABLE=0 the register field always reads 0.
                }
            }
            field UNSUPPORTED_REQ_ERR_STATUS @'h14 {
                access w1c;
                volatile 1
                hard_reset 'h0;
                doc {
                    Unsupported Request Error Status.
For a description of this standard PCIe register field, see the PCI Express Specification.
                }
            }
            field INTERNAL_ERR_STATUS @'h16 {
                access w1c;
                volatile 1
                hard_reset 'h0;
                doc {
                    Uncorrectable Internal Error Status.
For a description of this standard PCIe register field, see the PCI Express Specification.

 The controller sets this bit when your application asserts app_err_bus[9]. It does not set this bit when it detects internal uncorrectable internal errors such as parity and ECC failures. You should use the outputs from these errors to drive the app_err_bus[9] input. For more details, see the "Data Integrity (Wire, Datapath, and RAM Protection)" section in the Databook.
                }
            }
            field RSVDP_23 @'h17 {
                access ro;
                hard_reset 'h0;
                soft_reset 'h0;
                doc {
                    Reserved for future use.
                }
            }
            field RSVDP_27 @'h1b {
                bits 5;
                access ro;
                hard_reset 'h0;
                soft_reset 'h0;
                doc {
                    Reserved for future use.
                }
            }
            doc {
                Uncorrectable Error Status Register.
For a description of this standard PCIe register, see the PCI Express Specification.Uncorrectable Error Status Register.
For a description of this standard PCIe register, see the PCI Express Specification.
            }
        }
        register UNCORR_ERR_MASK_OFF @'h8 {
            bytes 4;
            field RSVDP_0 @'h0 {
                bits 4;
                access ro;
                hard_reset 'h0;
                soft_reset 'h0;
                doc {
                    Reserved for future use.
                }
            }
            field DL_PROTOCOL_ERR_MASK @'h4 {
                access rw;
                hard_reset 'h0;
                doc {
                    Data Link Protocol Error Mask.
For a description of this standard PCIe register field, see the PCI Express Specification.

Note: This register field is sticky.
                }
            }
            field SURPRISE_DOWN_ERR_MASK @'h5 {
                access ro;
                hard_reset 'h0;
                doc {
                    Surprise Down Error Mask.
For a description of this standard PCIe register field, see the PCI Express Specification.

Note: This register field is sticky.
                }
            }
            field RSVDP_6 @'h6 {
                bits 6;
                access ro;
                hard_reset 'h0;
                soft_reset 'h0;
                doc {
                    Reserved for future use.
                }
            }
            field POIS_TLP_ERR_MASK @'hc {
                access rw;
                hard_reset 'h0;
                doc {
                    Poisoned TLP Error Mask.
For a description of this standard PCIe register field, see the PCI Express Specification.

Note: This register field is sticky.
                }
            }
            field FC_PROTOCOL_ERR_MASK @'hd {
                access rw;
                hard_reset 'h0;
                doc {
                    Flow Control Protocol Error Mask.
For a description of this standard PCIe register field, see the PCI Express Specification.

Note: This register field is sticky.
                }
            }
            field CMPLT_TIMEOUT_ERR_MASK @'he {
                access rw;
                hard_reset 'h0;
                doc {
                    Completion Timeout Error Mask.
For a description of this standard PCIe register field, see the PCI Express Specification.

Note: This register field is sticky.
                }
            }
            field CMPLT_ABORT_ERR_MASK @'hf {
                access rw;
                hard_reset 'h0;
                doc {
                    Completer Abort Error Mask (Optional).
For a description of this standard PCIe register field, see the PCI Express Specification.

Note: This register field is sticky.
                }
            }
            field UNEXP_CMPLT_ERR_MASK @'h10 {
                access rw;
                hard_reset 'h0;
                doc {
                    Unexpected Completion Mask.
For a description of this standard PCIe register field, see the PCI Express Specification.

Note: This register field is sticky.
                }
            }
            field REC_OVERFLOW_ERR_MASK @'h11 {
                access rw;
                hard_reset 'h0;
                doc {
                    Receiver Overflow Mask (Optional).
For a description of this standard PCIe register field, see the PCI Express Specification.

Note: This register field is sticky.
                }
            }
            field MALF_TLP_ERR_MASK @'h12 {
                access rw;
                hard_reset 'h0;
                doc {
                    Malformed TLP Mask.
For a description of this standard PCIe register field, see the PCI Express Specification.

Note: This register field is sticky.
                }
            }
            field ECRC_ERR_MASK @'h13 {
                access rw;
                hard_reset 'h0;
                doc {
                    ECRC Error Mask (Optional).
For a description of this standard PCIe register field, see the PCI Express Specification.

Note: The access attributes of this field are as follows:
 - Wire: R/W (sticky) 
 - Dbi: R/W (sticky) 
Note: This register field is sticky.
                }
            }
            field UNSUPPORTED_REQ_ERR_MASK @'h14 {
                access rw;
                hard_reset 'h0;
                doc {
                    Unsupported Request Error Mask.
For a description of this standard PCIe register field, see the PCI Express Specification.

Note: This register field is sticky.
                }
            }
            field ACS_VIOLATION_MASK @'h15 {
                access ro;
                volatile 1
                hard_reset 'h0;
                doc {
                    ACS Violation Mask.
Setting the ACS Violation Mask bit disables error logging and signaling for ACS Violation errors.
The bit is Read-Only Zero for upstream ports, when ACS P2P Egress Control Enable is not set.
For a description of this standard PCIe register field, see the PCI Express Specification.

Note: The access attributes of this field are as follows:
 - Wire: if (acs_viol_svrity_mask_wr_en == 1) then R/W (Sticky)  else R(Sticky)  
 - Dbi: if (acs_viol_svrity_mask_wr_en == 1) then R/W (Sticky) else R(Sticky)  
Note: This register field is sticky.
                }
            }
            field INTERNAL_ERR_MASK @'h16 {
                access rw;
                hard_reset 'h0;
                doc {
                    Uncorrectable Internal Error Mask (Optional).
For a description of this standard PCIe register field, see the PCI Express Specification.

Note: This register field is sticky.
                }
            }
            field RSVDP_23 @'h17 {
                access ro;
                hard_reset 'h0;
                soft_reset 'h0;
                doc {
                    Reserved for future use.
                }
            }
            field ATOMIC_EGRESS_BLOCKED_ERR_MASK @'h18 {
                access ro;
                hard_reset 'h0;
                doc {
                    AtomicOp Egress Block Mask (Optional).
For a description of this standard PCIe register field, see the PCI Express Specification.

Note: This register field is sticky.
                }
            }
            field RSVDP_27 @'h1b {
                bits 5;
                access ro;
                hard_reset 'h0;
                soft_reset 'h0;
                doc {
                    Reserved for future use.
                }
            }
            doc {
                Uncorrectable Error Mask Register.
For a description of this standard PCIe register, see the PCI Express Specification.Uncorrectable Error Mask Register.
For a description of this standard PCIe register, see the PCI Express Specification.
            }
        }
        register UNCORR_ERR_SEV_OFF @'hc {
            bytes 4;
            field RSVDP_0 @'h0 {
                bits 4;
                access ro;
                hard_reset 'h0;
                soft_reset 'h0;
                doc {
                    Reserved for future use.
                }
            }
            field DL_PROTOCOL_ERR_SEVERITY @'h4 {
                access rw;
                hard_reset 'h0;
                doc {
                    Data Link Protocol Error Severity.
For a description of this standard PCIe register field, see the PCI Express Specification.

Note: This register field is sticky.
                }
            }
            field SURPRISE_DOWN_ERR_SVRITY @'h5 {
                access ro;
                hard_reset 'h0;
                doc {
                    Surprise Down Error Severity (Optional).
For a description of this standard PCIe register field, see the PCI Express Specification.

Note: This register field is sticky.
                }
            }
            field RSVDP_6 @'h6 {
                bits 6;
                access ro;
                hard_reset 'h0;
                soft_reset 'h0;
                doc {
                    Reserved for future use.
                }
            }
            field POIS_TLP_ERR_SEVERITY @'hc {
                access rw;
                hard_reset 'h0;
                doc {
                    Poisoned TLP Severity.
For a description of this standard PCIe register field, see the PCI Express Specification.

Note: This register field is sticky.
                }
            }
            field FC_PROTOCOL_ERR_SEVERITY @'hd {
                access rw;
                hard_reset 'h0;
                doc {
                    Flow Control Protocol Error Severity (Optional).
For a description of this standard PCIe register field, see the PCI Express Specification.

Note: This register field is sticky.
                }
            }
            field CMPLT_TIMEOUT_ERR_SEVERITY @'he {
                access rw;
                hard_reset 'h0;
                doc {
                    Completion Timeout Error Severity.
For a description of this standard PCIe register field, see the PCI Express Specification.

Note: This register field is sticky.
                }
            }
            field CMPLT_ABORT_ERR_SEVERITY @'hf {
                access rw;
                hard_reset 'h0;
                doc {
                    Completer Abort Error Severity (Optional).
For a description of this standard PCIe register field, see the PCI Express Specification.

Note: This register field is sticky.
                }
            }
            field UNEXP_CMPLT_ERR_SEVERITY @'h10 {
                access rw;
                hard_reset 'h0;
                doc {
                    Unexpected Completion Error Severity.
For a description of this standard PCIe register field, see the PCI Express Specification.

Note: This register field is sticky.
                }
            }
            field REC_OVERFLOW_ERR_SEVERITY @'h11 {
                access rw;
                hard_reset 'h0;
                doc {
                    Receiver Overflow Error Severity (Optional).
For a description of this standard PCIe register field, see the PCI Express Specification.

Note: This register field is sticky.
                }
            }
            field MALF_TLP_ERR_SEVERITY @'h12 {
                access rw;
                hard_reset 'h0;
                doc {
                    Malformed TLP Severity.
For a description of this standard PCIe register field, see the PCI Express Specification.

Note: This register field is sticky.
                }
            }
            field ECRC_ERR_SEVERITY @'h13 {
                access rw;
                hard_reset 'h0;
                doc {
                    ECRC Error Severity (Optional).
For a description of this standard PCIe register field, see the PCI Express Specification.

Note: The access attributes of this field are as follows:
 - Wire: R/W (sticky) 
 - Dbi: R/W (sticky) 
Note: This register field is sticky.
                }
            }
            field UNSUPPORTED_REQ_ERR_SEVERITY @'h14 {
                access rw;
                hard_reset 'h0;
                doc {
                    Unsupported Request Error Severity.
For a description of this standard PCIe register field, see the PCI Express Specification.

Note: This register field is sticky.
                }
            }
            field INTERNAL_ERR_SEVERITY @'h16 {
                access rw;
                hard_reset 'h0;
                doc {
                    Uncorrectable Internal Error Severity (Optional).
For a description of this standard PCIe register field, see the PCI Express Specification.

Note: This register field is sticky.
                }
            }
            field RSVDP_23 @'h17 {
                access ro;
                hard_reset 'h0;
                soft_reset 'h0;
                doc {
                    Reserved for future use.
                }
            }
            field ATOMIC_EGRESS_BLOCKED_ERR_SEVERITY @'h18 {
                access ro;
                hard_reset 'h0;
                doc {
                    AtomicOp Egress Blocked Severity (Optional).
For a description of this standard PCIe register field, see the PCI Express Specification.

Note: The access attributes of this field are as follows:
 - Wire: R/W (sticky) 
 - Dbi: R/W (sticky) 
Note: This register field is sticky.
                }
            }
            field RSVDP_27 @'h1b {
                bits 5;
                access ro;
                hard_reset 'h0;
                soft_reset 'h0;
                doc {
                    Reserved for future use.
                }
            }
            doc {
                Uncorrectable Error Severity Register.
For a description of this standard PCIe register, see the PCI Express Specification.Uncorrectable Error Severity Register.
For a description of this standard PCIe register, see the PCI Express Specification.
            }
        }
        register CORR_ERR_STATUS_OFF @'h10 {
            bytes 4;
            field RX_ERR_STATUS @'h0 {
                access w1c;
                volatile 1
                hard_reset 'h0;
                doc {
                    Receiver Error Status (Optional).
For a description of this standard PCIe register field, see the PCI Express Specification.
                }
            }
            field RSVDP_1 @'h1 {
                bits 5;
                access ro;
                hard_reset 'h0;
                soft_reset 'h0;
                doc {
                    Reserved for future use.
                }
            }
            field BAD_TLP_STATUS @'h6 {
                access w1c;
                volatile 1
                hard_reset 'h0;
                doc {
                    Bad TLP Status.
For a description of this standard PCIe register field, see the PCI Express Specification.
                }
            }
            field BAD_DLLP_STATUS @'h7 {
                access w1c;
                volatile 1
                hard_reset 'h0;
                doc {
                    Bad DLLP Status.
For a description of this standard PCIe register field, see the PCI Express Specification.
                }
            }
            field REPLAY_NO_ROLEOVER_STATUS @'h8 {
                access w1c;
                volatile 1
                hard_reset 'h0;
                doc {
                    REPLAY_NUM Rollover Status.
For a description of this standard PCIe register field, see the PCI Express Specification.
                }
            }
            field RSVDP_9 @'h9 {
                bits 3;
                access ro;
                hard_reset 'h0;
                soft_reset 'h0;
                doc {
                    Reserved for future use.
                }
            }
            field RPL_TIMER_TIMEOUT_STATUS @'hc {
                access w1c;
                volatile 1
                hard_reset 'h0;
                doc {
                    Replay Timer Timeout Status.
For a description of this standard PCIe register field, see the PCI Express Specification.
                }
            }
            field ADVISORY_NON_FATAL_ERR_STATUS @'hd {
                access w1c;
                volatile 1
                hard_reset 'h0;
                doc {
                    Advisory Non-Fatal Error Status.
For a description of this standard PCIe register field, see the PCI Express Specification.
                }
            }
            field CORRECTED_INT_ERR_STATUS @'he {
                access w1c;
                volatile 1
                hard_reset 'h0;
                doc {
                    Corrected Internal Error Status (Optional).
For a description of this standard PCIe register field, see the PCI Express Specification.
                }
            }
            field HEADER_LOG_OVERFLOW_STATUS @'hf {
                access w1c;
                volatile 1
                hard_reset 'h0;
                doc {
                    Header Log Overflow Error Status (Optional).
For a description of this standard PCIe register field, see the PCI Express Specification.
                }
            }
            field RSVDP_16 @'h10 {
                bits 16;
                access ro;
                hard_reset 'h0;
                soft_reset 'h0;
                doc {
                    Reserved for future use.
                }
            }
            doc {
                Correctable Error Status Register.
For a description of this standard PCIe register, see the PCI Express Specification.Correctable Error Status Register.
For a description of this standard PCIe register, see the PCI Express Specification.
            }
        }
        register CORR_ERR_MASK_OFF @'h14 {
            bytes 4;
            field RX_ERR_MASK @'h0 {
                access rw;
                hard_reset 'h0;
                doc {
                    Receiver Error Mask (Optional).
For a description of this standard PCIe register field, see the PCI Express Specification.

Note: This register field is sticky.
                }
            }
            field RSVDP_1 @'h1 {
                bits 5;
                access ro;
                hard_reset 'h0;
                soft_reset 'h0;
                doc {
                    Reserved for future use.
                }
            }
            field BAD_TLP_MASK @'h6 {
                access rw;
                hard_reset 'h0;
                doc {
                    Bad TLP Mask.
For a description of this standard PCIe register field, see the PCI Express Specification.

Note: This register field is sticky.
                }
            }
            field BAD_DLLP_MASK @'h7 {
                access rw;
                hard_reset 'h0;
                doc {
                    Bad DLLP Mask.
For a description of this standard PCIe register field, see the PCI Express Specification.

Note: This register field is sticky.
                }
            }
            field REPLAY_NO_ROLEOVER_MASK @'h8 {
                access rw;
                hard_reset 'h0;
                doc {
                    REPLAY_NUM Rollover Mask.
For a description of this standard PCIe register field, see the PCI Express Specification.

Note: This register field is sticky.
                }
            }
            field RSVDP_9 @'h9 {
                bits 3;
                access ro;
                hard_reset 'h0;
                soft_reset 'h0;
                doc {
                    Reserved for future use.
                }
            }
            field RPL_TIMER_TIMEOUT_MASK @'hc {
                access rw;
                hard_reset 'h0;
                doc {
                    Replay Timer Timeout Mask.
For a description of this standard PCIe register field, see the PCI Express Specification.

Note: This register field is sticky.
                }
            }
            field ADVISORY_NON_FATAL_ERR_MASK @'hd {
                access rw;
                hard_reset 'h0;
                doc {
                    Advisory Non-Fatal Error Mask.
For a description of this standard PCIe register field, see the PCI Express Specification.

Note: This register field is sticky.
                }
            }
            field CORRECTED_INT_ERR_MASK @'he {
                access rw;
                hard_reset 'h0;
                doc {
                    Corrected Internal Error Mask (Optional).
For a description of this standard PCIe register field, see the PCI Express Specification.

Note: This register field is sticky.
                }
            }
            field HEADER_LOG_OVERFLOW_MASK @'hf {
                access rw;
                hard_reset 'h0;
                doc {
                    Header Log Overflow Error Mask (Optional).
For a description of this standard PCIe register field, see the PCI Express Specification.

Note: This register field is sticky.
                }
            }
            field RSVDP_16 @'h10 {
                bits 16;
                access ro;
                hard_reset 'h0;
                soft_reset 'h0;
                doc {
                    Reserved for future use.
                }
            }
            doc {
                Correctable Error Mask Register.
For a description of this standard PCIe register, see the PCI Express Specification.Correctable Error Mask Register.
For a description of this standard PCIe register, see the PCI Express Specification.
            }
        }
        register ADV_ERR_CAP_CTRL_OFF @'h18 {
            bytes 4;
            field FIRST_ERR_POINTER @'h0 {
                bits 5;
                access ro;
                volatile 1
                hard_reset 'h0;
                doc {
                    First Error Pointer.
For a description of this standard PCIe register field, see the PCI Express Specification.

Note: This register field is sticky.
                }
            }
            field ECRC_GEN_CAP @'h5 {
                access ro;
                hard_reset 'h0;
                doc {
                    ECRC Generation Capable.
For a description of this standard PCIe register field, see the PCI Express Specification.

Note: This register field is sticky.
                }
            }
            field ECRC_GEN_EN @'h6 {
                access rw;
                hard_reset 'h0;
                doc {
                    ECRC Generation Enable.
For a description of this standard PCIe register field, see the PCI Express Specification.

Note: This register field is sticky.
                }
            }
            field ECRC_CHECK_CAP @'h7 {
                access ro;
                hard_reset 'h0;
                doc {
                    ECRC Check Capable.
For a description of this standard PCIe register field, see the PCI Express Specification.

Note: This register field is sticky.
                }
            }
            field ECRC_CHECK_EN @'h8 {
                access rw;
                hard_reset 'h0;
                doc {
                    ECRC Check Enable.
For a description of this standard PCIe register field, see the PCI Express Specification.

Note: This register field is sticky.
                }
            }
            field MULTIPLE_HEADER_CAP @'h9 {
                access ro;
                hard_reset 'h0;
                doc {
                    Multiple Header Recording Capable.
For a description of this standard PCIe register field, see the PCI Express Specification.

Note: This register field is sticky.
                }
            }
            field MULTIPLE_HEADER_EN @'ha {
                access ro;
                hard_reset 'h0;
                doc {
                    Multiple Header Recording Enable.
For a description of this standard PCIe register field, see the PCI Express Specification.

Note: The access attributes of this field are as follows:
 - Wire: R (sticky) 
 - Dbi: R (sticky) 
Note: This register field is sticky.
                }
            }
            field CTO_PRFX_HDR_LOG_CAP @'hc {
                access ro;
                hard_reset 'h0;
                doc {
                    TLP Prefix Log Present.
For a description of this standard PCIe register field, see the PCI Express Specification.
                }
            }
            field RSVDP_13 @'hd {
                bits 19;
                access ro;
                hard_reset 'h0;
                soft_reset 'h0;
                doc {
                    Reserved for future use.
                }
            }
            doc {
                Advanced Error Capabilities and Control Register.
For a description of this standard PCIe register, see the PCI Express Specification.Advanced Error Capabilities and Control Register.
For a description of this standard PCIe register, see the PCI Express Specification.
            }
        }
        register HDR_LOG_0_OFF @'h1c {
            bytes 4;
            field FIRST_DWORD_FIRST_BYTE @'h0 {
                bits 8;
                access ro;
                volatile 1
                hard_reset 'h0;
                doc {
                    Byte 0 of Header log register of First 32 bit Data Word.
For a description of this standard PCIe register field, see the PCI Express Specification.

Note: This register field is sticky.
                }
            }
            field FIRST_DWORD_SECOND_BYTE @'h8 {
                bits 8;
                access ro;
                volatile 1
                hard_reset 'h0;
                doc {
                    Byte 1 of Header log register of First 32 bit Data Word.
For a description of this standard PCIe register field, see the PCI Express Specification.

Note: This register field is sticky.
                }
            }
            field FIRST_DWORD_THIRD_BYTE @'h10 {
                bits 8;
                access ro;
                volatile 1
                hard_reset 'h0;
                doc {
                    Byte 2 of Header log register of First 32 bit Data Word.
For a description of this standard PCIe register field, see the PCI Express Specification.

Note: This register field is sticky.
                }
            }
            field FIRST_DWORD_FOURTH_BYTE @'h18 {
                bits 8;
                access ro;
                volatile 1
                hard_reset 'h0;
                doc {
                    Byte 3 of Header log register of First 32 bit Data Word.
For a description of this standard PCIe register field, see the PCI Express Specification.

Note: This register field is sticky.
                }
            }
            doc {
                Header Log Register 0.
For a description of this standard PCIe register, see the PCI Express Specification.Header Log Register 0.
For a description of this standard PCIe register, see the PCI Express Specification.
            }
        }
        register HDR_LOG_1_OFF @'h20 {
            bytes 4;
            field SECOND_DWORD_FIRST_BYTE @'h0 {
                bits 8;
                access ro;
                volatile 1
                hard_reset 'h0;
                doc {
                    Byte 0 of Header log register of Second 32 bit Data Word.
For a description of this standard PCIe register field, see the PCI Express Specification.

Note: This register field is sticky.
                }
            }
            field SECOND_DWORD_SECOND_BYTE @'h8 {
                bits 8;
                access ro;
                volatile 1
                hard_reset 'h0;
                doc {
                    Byte 1 of Header log register of Second 32 bit Data Word.
For a description of this standard PCIe register field, see the PCI Express Specification.

Note: This register field is sticky.
                }
            }
            field SECOND_DWORD_THIRD_BYTE @'h10 {
                bits 8;
                access ro;
                volatile 1
                hard_reset 'h0;
                doc {
                    Byte 2 of Header log register of Second 32 bit Data Word.
For a description of this standard PCIe register field, see the PCI Express Specification.

Note: This register field is sticky.
                }
            }
            field SECOND_DWORD_FOURTH_BYTE @'h18 {
                bits 8;
                access ro;
                volatile 1
                hard_reset 'h0;
                doc {
                    Byte 3 of Header log register of Second 32 bit Data Word.
For a description of this standard PCIe register field, see the PCI Express Specification.

Note: This register field is sticky.
                }
            }
            doc {
                Header Log Register 1.
For a description of this standard PCIe register, see the PCI Express Specification.Header Log Register 1.
For a description of this standard PCIe register, see the PCI Express Specification.
            }
        }
        register HDR_LOG_2_OFF @'h24 {
            bytes 4;
            field THIRD_DWORD_FIRST_BYTE @'h0 {
                bits 8;
                access ro;
                volatile 1
                hard_reset 'h0;
                doc {
                    Byte 0 of Header log register of Third 32 bit Data Word.
For a description of this standard PCIe register field, see the PCI Express Specification.

Note: This register field is sticky.
                }
            }
            field THIRD_DWORD_SECOND_BYTE @'h8 {
                bits 8;
                access ro;
                volatile 1
                hard_reset 'h0;
                doc {
                    Byte 1 of Header log register of Third 32 bit Data Word.
For a description of this standard PCIe register field, see the PCI Express Specification.

Note: This register field is sticky.
                }
            }
            field THIRD_DWORD_THIRD_BYTE @'h10 {
                bits 8;
                access ro;
                volatile 1
                hard_reset 'h0;
                doc {
                    Byte 2 of Header log register of Third 32 bit Data Word.
For a description of this standard PCIe register field, see the PCI Express Specification.

Note: This register field is sticky.
                }
            }
            field THIRD_DWORD_FOURTH_BYTE @'h18 {
                bits 8;
                access ro;
                volatile 1
                hard_reset 'h0;
                doc {
                    Byte 3 of Header log register of Third 32 bit Data Word.
For a description of this standard PCIe register field, see the PCI Express Specification.

Note: This register field is sticky.
                }
            }
            doc {
                Header Log Register 2.
For a description of this standard PCIe register, see the PCI Express Specification.Header Log Register 2.
For a description of this standard PCIe register, see the PCI Express Specification.
            }
        }
        register HDR_LOG_3_OFF @'h28 {
            bytes 4;
            field FOURTH_DWORD_FIRST_BYTE @'h0 {
                bits 8;
                access ro;
                volatile 1
                hard_reset 'h0;
                doc {
                    Byte 0 of Header log register of Fourth 32 bit Data Word.
For a description of this standard PCIe register field, see the PCI Express Specification.

Note: This register field is sticky.
                }
            }
            field FOURTH_DWORD_SECOND_BYTE @'h8 {
                bits 8;
                access ro;
                volatile 1
                hard_reset 'h0;
                doc {
                    Byte 1 of Header log register of Fourth 32 bit Data Word.
For a description of this standard PCIe register field, see the PCI Express Specification.

Note: This register field is sticky.
                }
            }
            field FOURTH_DWORD_THIRD_BYTE @'h10 {
                bits 8;
                access ro;
                volatile 1
                hard_reset 'h0;
                doc {
                    Byte 2 of Header log register of Fourth 32 bit Data Word.
For a description of this standard PCIe register field, see the PCI Express Specification.

Note: This register field is sticky.
                }
            }
            field FOURTH_DWORD_FOURTH_BYTE @'h18 {
                bits 8;
                access ro;
                volatile 1
                hard_reset 'h0;
                doc {
                    Byte 3 of Header log register of Fourth 32 bit Data Word.
For a description of this standard PCIe register field, see the PCI Express Specification.

Note: This register field is sticky.
                }
            }
            doc {
                Header Log Register 3.
For a description of this standard PCIe register, see the PCI Express Specification.Header Log Register 3.
For a description of this standard PCIe register, see the PCI Express Specification.
            }
        }
        register TLP_PREFIX_LOG_1_OFF @'h38 {
            bytes 4;
            field CFG_TLP_PFX_LOG_1_FIRST_BYTE @'h0 {
                bits 8;
                access ro;
                hard_reset 'h0;
                doc {
                    Byte 0 of Error TLP Prefix Log 1.
For a description of this standard PCIe register field, see the PCI Express Specification.

Note: This register field is sticky.
                }
            }
            field CFG_TLP_PFX_LOG_1_SECOND_BYTE @'h8 {
                bits 8;
                access ro;
                hard_reset 'h0;
                doc {
                    Byte 1 of Error TLP Prefix Log 1.
For a description of this standard PCIe register field, see the PCI Express Specification.

Note: This register field is sticky.
                }
            }
            field CFG_TLP_PFX_LOG_1_THIRD_BYTE @'h10 {
                bits 8;
                access ro;
                hard_reset 'h0;
                doc {
                    Byte 2 of Error TLP Prefix Log 1.
For a description of this standard PCIe register field, see the PCI Express Specification.

Note: This register field is sticky.
                }
            }
            field CFG_TLP_PFX_LOG_1_FOURTH_BYTE @'h18 {
                bits 8;
                access ro;
                hard_reset 'h0;
                doc {
                    Byte 3 of Error TLP Prefix Log 1.
For a description of this standard PCIe register field, see the PCI Express Specification.

Note: This register field is sticky.
                }
            }
            doc {
                TLP Prefix Log Register 1.
For a description of this standard PCIe register, see the PCI Express Specification.TLP Prefix Log Register 1.
For a description of this standard PCIe register, see the PCI Express Specification.
            }
        }
        register TLP_PREFIX_LOG_2_OFF @'h3c {
            bytes 4;
            field CFG_TLP_PFX_LOG_2_FIRST_BYTE @'h0 {
                bits 8;
                access ro;
                hard_reset 'h0;
                doc {
                    Byte 0 Error TLP Prefix Log 2.
For a description of this standard PCIe register field, see the PCI Express Specification.

Note: This register field is sticky.
                }
            }
            field CFG_TLP_PFX_LOG_2_SECOND_BYTE @'h8 {
                bits 8;
                access ro;
                hard_reset 'h0;
                doc {
                    Byte 1 Error TLP Prefix Log 2.
For a description of this standard PCIe register field, see the PCI Express Specification.

Note: This register field is sticky.
                }
            }
            field CFG_TLP_PFX_LOG_2_THIRD_BYTE @'h10 {
                bits 8;
                access ro;
                hard_reset 'h0;
                doc {
                    Byte 2 Error TLP Prefix Log 2.
For a description of this standard PCIe register field, see the PCI Express Specification.

Note: This register field is sticky.
                }
            }
            field CFG_TLP_PFX_LOG_2_FOURTH_BYTE @'h18 {
                bits 8;
                access ro;
                hard_reset 'h0;
                doc {
                    Byte 3 Error TLP Prefix Log 2.
For a description of this standard PCIe register field, see the PCI Express Specification.

Note: This register field is sticky.
                }
            }
            doc {
                TLP Prefix Log Register 2.
For a description of this standard PCIe register, see the PCI Express Specification.TLP Prefix Log Register 2.
For a description of this standard PCIe register, see the PCI Express Specification.
            }
        }
        register TLP_PREFIX_LOG_3_OFF @'h40 {
            bytes 4;
            field CFG_TLP_PFX_LOG_3_FIRST_BYTE @'h0 {
                bits 8;
                access ro;
                hard_reset 'h0;
                doc {
                    Byte 0 Error TLP Prefix Log 3.
For a description of this standard PCIe register field, see the PCI Express Specification.

Note: This register field is sticky.
                }
            }
            field CFG_TLP_PFX_LOG_3_SECOND_BYTE @'h8 {
                bits 8;
                access ro;
                hard_reset 'h0;
                doc {
                    Byte 1 Error TLP Prefix Log 3.
For a description of this standard PCIe register field, see the PCI Express Specification.

Note: This register field is sticky.
                }
            }
            field CFG_TLP_PFX_LOG_3_THIRD_BYTE @'h10 {
                bits 8;
                access ro;
                hard_reset 'h0;
                doc {
                    Byte 2 Error TLP Prefix Log 3.
For a description of this standard PCIe register field, see the PCI Express Specification.

Note: This register field is sticky.
                }
            }
            field CFG_TLP_PFX_LOG_3_FOURTH_BYTE @'h18 {
                bits 8;
                access ro;
                hard_reset 'h0;
                doc {
                    Byte 3 Error TLP Prefix Log 3.
For a description of this standard PCIe register field, see the PCI Express Specification.

Note: This register field is sticky.
                }
            }
            doc {
                TLP Prefix Log Register 3.
For a description of this standard PCIe register, see the PCI Express Specification.TLP Prefix Log Register 3.
For a description of this standard PCIe register, see the PCI Express Specification.
            }
        }
        register TLP_PREFIX_LOG_4_OFF @'h44 {
            bytes 4;
            field CFG_TLP_PFX_LOG_4_FIRST_BYTE @'h0 {
                bits 8;
                access ro;
                hard_reset 'h0;
                doc {
                    Byte 0 Error TLP Prefix Log 4.
For a description of this standard PCIe register field, see the PCI Express Specification.

Note: This register field is sticky.
                }
            }
            field CFG_TLP_PFX_LOG_4_SECOND_BYTE @'h8 {
                bits 8;
                access ro;
                hard_reset 'h0;
                doc {
                    Byte 1 Error TLP Prefix Log 4.
For a description of this standard PCIe register field, see the PCI Express Specification.

Note: This register field is sticky.
                }
            }
            field CFG_TLP_PFX_LOG_4_THIRD_BYTE @'h10 {
                bits 8;
                access ro;
                hard_reset 'h0;
                doc {
                    Byte 2 Error TLP Prefix Log 4.
For a description of this standard PCIe register field, see the PCI Express Specification.

Note: This register field is sticky.
                }
            }
            field CFG_TLP_PFX_LOG_4_FOURTH_BYTE @'h18 {
                bits 8;
                access ro;
                hard_reset 'h0;
                doc {
                    Byte 3 Error TLP Prefix Log 4.
For a description of this standard PCIe register field, see the PCI Express Specification.

Note: This register field is sticky.
                }
            }
            doc {
                TLP Prefix Log Register 4.
For a description of this standard PCIe register, see the PCI Express Specification.TLP Prefix Log Register 4.
For a description of this standard PCIe register, see the PCI Express Specification.
            }
        }
        doc {
            PF Advanced Error Reporting Capability Structure
        }
    }
    block PF0_MSI_CAP @'h50 {
        bytes 4;
        register PCI_MSI_CAP_ID_NEXT_CTRL_REG @'h0 {
            bytes 4;
            field PCI_MSI_CAP_ID @'h0 {
                bits 8;
                access ro;
                hard_reset 'h0;
                soft_reset 'h0;
                doc {
                    Capability ID.
Indicates the MSI Capability structure. This field returns a Capability ID of 05h indicating that this is an MSI Capability structure.
                }
            }
            field PCI_MSI_CAP_NEXT_OFFSET @'h8 {
                bits 8;
                access ro;
                hard_reset 'h0;
                doc {
                    Next Capability Pointer.
This field contains the offset to the next PCI Capability structure or 00h if no other items exist in the linked list of Capabilities.

Note: The access attributes of this field are as follows:
 - Wire: R (sticky) 
 - Dbi: if (DBI_RO_WR_EN == 1) then R/W else R 
Note: This register field is sticky.
                }
            }
            field PCI_MSI_ENABLE @'h10 {
                access rw;
                hard_reset 'h0;
                soft_reset 'h0;
                doc {
                    MSI Enable.
 - If set and the MSI-X Enable bit in the MSI-X Message Control register is clear, the function is permitted to use MSI to request service and is prohibited from using INTx interrupts. System configuration software sets this bit to enable MSI. A device driver is prohibited from writing this bit to mask a function's service request. For more details on control of INTx interrupts, see section 7.5.1.1 of PCI Express Base Specification.
 - If clear, the function is prohibited from using MSI to request service.
                }
            }
            field PCI_MSI_MULTIPLE_MSG_CAP @'h11 {
                bits 3;
                access ro;
                hard_reset 'h0;
                doc {
                    Multiple Message Capable.
System software reads this field to determine the number of requested vectors. The number of requested vectors must be aligned to a power of two (if a function requires three vectors, it requests four by initializing this field to 010b). The encoding is defined as:
 - 000b: 1 vector requested
 - 001b: 2 vectors requested
 - 010b: 4 vectors requested
 - 011b: 8 vectors requested
 - 100b: 16 vectors requested
 - 101b: 32 vectors requested
 - 110b: Reserved
 - 111b: Reserved
Note: The access attributes of this field are as follows:
 - Wire: R (sticky) 
 - Dbi: if (DBI_RO_WR_EN == 1) then R/W else R 
Note: This register field is sticky.
                }
            }
            field PCI_MSI_MULTIPLE_MSG_EN @'h14 {
                bits 3;
                access rw;
                hard_reset 'h0;
                soft_reset 'h0;
                doc {
                    Multiple Message Enable.
Software writes to this field to indicate the number of allocated vectors (equal to or less than the number of requested vectors). The number of allocated vectors is aligned to a power of two. If a function requests four vectors (indicated by a Multiple Message Capable encoding of 010b), system software can allocate either four, two, or one vector by writing a 010b, 001b, or 000b to this field, respectively. When MSI is enabled, a function will be allocated at least 1 vector. The encoding is defined as:
 - 000b: 1 vector allocated
 - 001b: 2 vectors allocated
 - 010b: 4 vectors allocated
 - 011b: 8 vectors allocated
 - 100b: 16 vectors allocated
 - 101b: 32 vectors allocated
 - 110b: Reserved
 - 111b: Reserved
                }
            }
            field PCI_MSI_64_BIT_ADDR_CAP @'h17 {
                access ro;
                hard_reset 'h0;
                doc {
                    64 bit address capable.
 - If set, the function is capable of sending a 64-bit message address.
 - If clear, the function is not capable of sending a 64-bit message address.
This bit must be set if the function is a PCI Express Endpoint.

Note: The access attributes of this field are as follows:
 - Wire: R (sticky) 
 - Dbi: if (DBI_RO_WR_EN == 1) then R/W else R 
Note: This register field is sticky.
                }
            }
            field PCI_PVM_SUPPORT @'h18 {
                access ro;
                hard_reset 'h0;
                soft_reset 'h0;
                doc {
                    Per-Vector Masking Capable.
 - If set, the function supports MSI Per-Vector Masking.
 - If clear, the function does not support MSI Per-Vector Masking.
This bit must be set if the function is a PF or VF within an SR-IOV Device.
                }
            }
            field PCI_MSI_EXT_DATA_CAP @'h19 {
                access ro;
                hard_reset 'h0;
                doc {
                    Extended Message Data Capable.
 - If set, the function is capable of providing Extended Message Data.
 - If clear, the function does not support providing Extended Message Data.
Note: The access attributes of this field are as follows:
 - Wire: R (sticky) 
 - Dbi: if (DBI_RO_WR_EN == 1) then R/W else R 
Note: This register field is sticky.
                }
            }
            field PCI_MSI_EXT_DATA_EN @'h1a {
                access rw;
                hard_reset 'h0;
                soft_reset 'h0;
                doc {
                    Extended Message Data Enable.
 - If set, the function is enabled to provide Extended Message Data.
 - If clear, the function is not enabled to provide Extended Message Data.
Note: The access attributes of this field are as follows:
 - Wire: PCI_MSI_CAP_ID_NEXT_CTRL_REG.PCI_MSI_EXT_DATA_CAP ? RW : RO 
 - Dbi: PCI_MSI_CAP_ID_NEXT_CTRL_REG.PCI_MSI_EXT_DATA_CAP  ? RW : RO 
                }
            }
            field RSVDP_27 @'h1b {
                bits 5;
                access ro;
                hard_reset 'h0;
                soft_reset 'h0;
                doc {
                    Reserved for future use.
                }
            }
            doc {
                MSI Capability Header and Message Control Register.MSI Capability Header and Message Control Register.
            }
        }
        register MSI_CAP_OFF_04H_REG @'h4 {
            bytes 4;
            field RSVDP_0 @'h0 {
                bits 2;
                access ro;
                hard_reset 'h0;
                soft_reset 'h0;
                doc {
                    Reserved for future use.
                }
            }
            field PCI_MSI_CAP_OFF_04H @'h2 {
                bits 30;
                access rw;
                hard_reset 'h0;
                soft_reset 'h0;
                doc {
                    Message Address - System-specified message address.
If the Message Enable bit (bit 16 of the PCI_MSI_CAP_ID_NEXT_CTRL_REG register) is set, the contents of this field specify the DWORD-aligned address (Address[31:02]) for the MSI transaction. Address[1:0] are set to 00b.

Note: The access attributes of this field are as follows:
 - Wire: R/W 
 - Dbi: R/W 
                }
            }
            doc {
                Message Address Register for MSI (Offset 04h).Message Address Register for MSI (Offset 04h).
            }
        }
        register MSI_CAP_OFF_08H_REG @'h8 {
            bytes 4;
            field PCI_MSI_CAP_OFF_08H @'h0 {
                bits 16;
                access rw;
                hard_reset 'h0;
                soft_reset 'h0;
                doc {
                    For a function that supports a 32-bit message address, this field contains Message Data (System-specified message data). If the Message Enable bit (bit 16 of the PCI_MSI_CAP_ID_NEXT_CTRL_REG) is set, the function sends a DWORD Memory Write transaction using Message Data for the lower 16 bits. All 4 Byte Enables are set. The Multiple Message Enable field (bits 22:20 of the PCI_MSI_CAP_ID_NEXT_CTRL_REG) defines the number of low order message data bits the function is permitted to modify to generate its system software allocated vectors. For example, a Multiple Message Enable encoding of 010b indicates the function has been allocated four vectors and is permitted to modify message data bits 1 and 0 (a function modifies the lower message data bits to generate the allocated number of vectors). If the Multiple Message Enable field is 000b, the Function is not permitted to modify the message data.

For a function that supports a 64-bit message address, it contains lower 16 bits of the Message Upper Address.

Note: The access attributes of this field are as follows:
 - Wire: PCI_MSI_64_BIT_ADDR_CAP ? R/W : R 
 - Dbi: PCI_MSI_64_BIT_ADDR_CAP ? R/W : R 
                }
            }
            field PCI_MSI_CAP_OFF_0AH @'h10 {
                bits 16;
                access rw;
                hard_reset 'h0;
                soft_reset 'h0;
                doc {
                    For a function that supports a 32-bit message address, this field contains Extended Message Data (System-specified message data). For the MSI Capability structures without per-vector masking, it must be implemented if the Extended Message Data Capable bit is set; otherwise, it is outside the MSI Capability structure and undefined. For the MSI Capability structures with Per-vector Masking, it must be implemented if the Extended Message Data Capable bit is set; otherwise, it is RsvdP. If the Extended Message Data Enable bit (bit 26 of the PCI_MSI_CAP_ID_NEXT_CTRL_REG) is set, the DWORD Memory Write transaction uses Extended Message Data for the upper 16 bits; otherwise, it uses 0000h for the upper 16 bits.

For a function that supports a 64-bit message address, it contains upper 16 bits of the Message Upper Address.

Note: The access attributes of this field are as follows:
 - Wire: PCI_MSI_64_BIT_ADDR_CAP || `DEFAULT_EXT_MSI_DATA_CAPABLE ? R/W : R 
 - Dbi: PCI_MSI_64_BIT_ADDR_CAP  || `DEFAULT_EXT_MSI_DATA_CAPABLE ? R/W : R 
                }
            }
            doc {
                For a function that supports a 32-bit message address, 
 - bits[31:16] of this register represent the Extended Message Data, and 
 - bits[15:0] of this register represent the Message Data
For a function that supports a 64-bit message address (bit 23 in PCI_MSI_CAP_ID_NEXT_CTRL_REG register set), this register represents the Message Upper Address Register for MSI (Offset 08h). It specifies the Message Upper Address (System-specified message upper address). This register is required for PCI Express Endpoints and is optional for other function types. If the Message Enable bit (bit 0 of the Message Control register) is set, the contents of this register (if non-zero) specify the upper 32-bits of a 64-bit message address (Address[63:32]). If the contents of this register are zero, the Function uses the 32 bit address specified by the Message Address register.
For a function that supports a 32-bit message address, 
 - bits[31:16] of this register represent the Extended Message Data, and 
 - bits[15:0] of this register represent the Message Data
For a function that supports a 64-bit message address (bit 23 in PCI_MSI_CAP_ID_NEXT_CTRL_REG register set), this register represents the Message Upper Address Register for MSI (Offset 08h). It specifies the Message Upper Address (System-specified message upper address). This register is required for PCI Express Endpoints and is optional for other function types. If the Message Enable bit (bit 0 of the Message Control register) is set, the contents of this register (if non-zero) specify the upper 32-bits of a 64-bit message address (Address[63:32]). If the contents of this register are zero, the Function uses the 32 bit address specified by the Message Address register.

            }
        }
        register MSI_CAP_OFF_0CH_REG @'hc {
            bytes 4;
            field PCI_MSI_CAP_OFF_0CH @'h0 {
                bits 16;
                access rw;
                hard_reset 'h0;
                soft_reset 'h0;
                doc {
                    For a function that supports a 32-bit message address, this field contains the lower Mask Bits when the Per Vector Masking Capable bit (PCI_MSI_CAP_ID_NEXT_CTRL_REG.PCI_PVM_SUPPORT) is set.

For a function that supports a 64-bit message address, this field contains Message Data (System-specified message data). If the Message Enable bit (bit 16 of the PCI_MSI_CAP_ID_NEXT_CTRL_REG) is set, the function sends a DWORD Memory Write transaction using Message Data for the lower 16 bits. All 4 Byte Enables are set. The Multiple Message Enable field (bits 22:20 of the PCI_MSI_CAP_ID_NEXT_CTRL_REG) defines the number of low order message data bits the function is permitted to modify to generate its system software allocated vectors. For example, a Multiple Message Enable encoding of 010b indicates the function has been allocated four vectors and is permitted to modify message data bits 1 and 0 (a function modifies the lower message data bits to generate the allocated number of vectors). If the Multiple Message Enable field is 000b, the Function is not permitted to modify the message data.


Note: The access attributes of this field are as follows:
 - Wire: PCI_MSI_64_BIT_ADDR_CAP || MSI_PVM_EN ? R/W : R 
 - Dbi: PCI_MSI_64_BIT_ADDR_CAP || MSI_PVM_EN ? R/W : R 
                }
            }
            field PCI_MSI_CAP_OFF_0EH @'h10 {
                bits 16;
                access rw;
                hard_reset 'h0;
                soft_reset 'h0;
                doc {
                    For a function that supports a 32-bit message address, this field contains the upper Mask Bits when the Per Vector Masking Capable bit (PCI_MSI_CAP_ID_NEXT_CTRL_REG.PCI_PVM_SUPPORT) is set.

For a function that supports a 64-bit message address, this field contains Message Data (System-specified message data).

Note: The access attributes of this field are as follows:
 - Wire: (!MSI_64_EN && MSI_PVM_EN_VALUE) ? RW: MSI_64_EN && DEFAULT_EXT_MSI_DATA_CAPABLE ? RW : RO 
 - Dbi: (!MSI_64_EN && MSI_PVM_EN_VALUE) ? RW: MSI_64_EN && DEFAULT_EXT_MSI_DATA_CAPABLE ? RW : RO 
                }
            }
            doc {
                For a function that supports a 32-bit message address, this register contains the Mask Bits when the Per-Vector Masking Capable bit (bit 24 of PCI_MSI_CAP_ID_NEXT_CTRL_REG) is set.

 For a function that supports a 64-bit message address, this register contains Message Data.
For a function that supports a 32-bit message address, this register contains the Mask Bits when the Per-Vector Masking Capable bit (bit 24 of PCI_MSI_CAP_ID_NEXT_CTRL_REG) is set.

 For a function that supports a 64-bit message address, this register contains Message Data.

            }
        }
        register MSI_CAP_OFF_10H_REG @'h10 {
            bytes 4;
            field PCI_MSI_CAP_OFF_10H @'h0 {
                bits 32;
                access rw;
                hard_reset 'h0;
                soft_reset 'h0;
                doc {
                    Used for MSI when the Per Vector Masking Capable bit (PCI_MSI_CAP_ID_NEXT_CTRL_REG.PCI_PVM_SUPPORT) is set. For 32-bit contains Pending Bits. For 64-bit, contains Mask Bits.
For a description of this standard PCIe register field, see the PCI Express Base Specification.

Note: The access attributes of this field are as follows:
 - Wire: PCI_MSI_64_BIT_ADDR_CAP && MSI_PVM_EN ? R/W : R 
 - Dbi: PCI_MSI_64_BIT_ADDR_CAP && MSI_PVM_EN ? R/W : R 
                }
            }
            doc {
                For a function that supports a 32-bit message address, this register contains the Pending Bits when the Per-Vector Masking Capable bit (bit 24 of PCI_MSI_CAP_ID_NEXT_CTRL_REG) is set.

 For a function that supports a 64-bit message address, this register contains the Mask Bits when the Per-Vector Masking Capable bit (bit 24 of PCI_MSI_CAP_ID_NEXT_CTRL_REG) is set.
For a function that supports a 32-bit message address, this register contains the Pending Bits when the Per-Vector Masking Capable bit (bit 24 of PCI_MSI_CAP_ID_NEXT_CTRL_REG) is set.

 For a function that supports a 64-bit message address, this register contains the Mask Bits when the Per-Vector Masking Capable bit (bit 24 of PCI_MSI_CAP_ID_NEXT_CTRL_REG) is set.

            }
        }
        register MSI_CAP_OFF_14H_REG @'h14 {
            bytes 4;
            field PCI_MSI_CAP_OFF_14H @'h0 {
                bits 32;
                access ro;
                hard_reset 'h0;
                soft_reset 'h0;
                doc {
                    Pending Bits. For each pending bit that is set, the function has a pending associated message.
                }
            }
            doc {
                Pending Bits Register for MSI. This register is used for a function that supports a 64-bit message address when the Per-Vector Masking Capable bit (bit 24 of PCI_MSI_CAP_ID_NEXT_CTRL_REG) is set.Pending Bits Register for MSI. This register is used for a function that supports a 64-bit message address when the Per-Vector Masking Capable bit (bit 24 of PCI_MSI_CAP_ID_NEXT_CTRL_REG) is set.
            }
        }
        doc {
            PF MSI Capability Structure
        }
    }
    block PF0_MSIX_CAP @'hb0 {
        bytes 4;
        register PCI_MSIX_CAP_ID_NEXT_CTRL_REG @'h0 {
            bytes 4;
            field PCI_MSIX_CAP_ID @'h0 {
                bits 8;
                access ro;
                hard_reset 'h0;
                soft_reset 'h0;
                doc {
                    MSI-X Capability ID.
For a description of this standard PCIe register field, see the PCI Express Base Specification.
                }
            }
            field PCI_MSIX_CAP_NEXT_OFFSET @'h8 {
                bits 8;
                access ro;
                hard_reset 'h0;
                doc {
                    MSI-X Next Capability Pointer.
For a description of this standard PCIe register field, see the PCI Express Base Specification.

Note: The access attributes of this field are as follows:
 - Wire: R (sticky) 
 - Dbi: if (DBI_RO_WR_EN == 1) then R/W else R 
Note: This register field is sticky.
                }
            }
            field PCI_MSIX_TABLE_SIZE @'h10 {
                bits 11;
                access ro;
                hard_reset 'h0;
                doc {
                    MSI-X Table Size.
For a description of this standard PCIe register field, see the PCI Express Base Specification.

SRIOV Note: All VFs in a single PF have the same value for "MSI-X Table Size" (PCI_MSIX_TABLE_SIZE field in SHADOW_PCI_MSIX_CAP_ID_NEXT_CTRL_REG). To write this common value, you must perform a
DBI_CS2 write (that is, assert the dbi_cs2 input, or the CS2 address bit for the AXI bridge) while accessing the PCI_MSIX_TABLE_SIZE field in the PF PCI_MSIX_CAP_ID_NEXT_CTRL_REG register.

Note: The access attributes of this field are as follows:
 - Wire: R (sticky) 
 - Dbi: if (DBI_RO_WR_EN == 1) then R/W else R 
Note: This register field is sticky.
                }
            }
            field RSVDP_27 @'h1b {
                bits 3;
                access ro;
                hard_reset 'h0;
                soft_reset 'h0;
                doc {
                    Reserved for future use.
                }
            }
            field PCI_MSIX_FUNCTION_MASK @'h1e {
                access rw;
                hard_reset 'h0;
                soft_reset 'h0;
                doc {
                    Function Mask.
For a description of this standard PCIe register field, see the PCI Express Base Specification.

Note: The access attributes of this field are as follows:
 - Wire: R/W 
 - Dbi: R/W 
                }
            }
            field PCI_MSIX_ENABLE @'h1f {
                access rw;
                hard_reset 'h0;
                soft_reset 'h0;
                doc {
                    MSI-X Enable.
For a description of this standard PCIe register field, see the PCI Express Base Specification.
                }
            }
            doc {
                MSI-X Capability ID, Next Pointer, Control Registers.
For a description of this standard PCIe register, see the PCI Express Base Specification.MSI-X Capability ID, Next Pointer, Control Registers.
For a description of this standard PCIe register, see the PCI Express Base Specification.
            }
        }
        register MSIX_TABLE_OFFSET_REG @'h4 {
            bytes 4;
            field PCI_MSIX_BIR @'h0 {
                bits 3;
                access ro;
                hard_reset 'h0;
                doc {
                    MSI-X Table BAR Indicator Register Field.
For a description of this standard PCIe register field, see the PCI Express Base Specification.

SRIOV Note: All VFs in a single PF have the same value for "MSI-X Table BAR Indicator Register" (PCI_MSIX_BIR field in SHADOW_MSIX_TABLE_OFFSET_REG). To write this common value, you must perform a
DBI_CS2 write (that is, assert the dbi_cs2 input, or the CS2 address bit for the AXI bridge) while accessing the PCI_MSIX_BIR field in the PF MSIX_TABLE_OFFSET_REG register.

Note: The access attributes of this field are as follows:
 - Wire: R (sticky) 
 - Dbi: if (DBI_RO_WR_EN == 1) then R/W else R 
Note: This register field is sticky.
                }
            }
            field PCI_MSIX_TABLE_OFFSET @'h3 {
                bits 29;
                access ro;
                hard_reset 'h0;
                doc {
                    MSI-X Table Offset.
For a description of this standard PCIe register field, see the PCI Express Base Specification.

SRIOV Note: All VFs in a single PF have the same value for "MSI-X Table Offset" (PCI_MSIX_TABLE_OFFSET field in SHADOW_MSIX_TABLE_OFFSET_REG). To write this common value, you must perform a
DBI_CS2 write (that is, assert the dbi_cs2 input, or the CS2 address bit for the AXI bridge) while accessing the PCI_MSIX_TABLE_OFFSET field in the PF MSIX_TABLE_OFFSET_REG register.

Note: The access attributes of this field are as follows:
 - Wire: R (sticky) 
 - Dbi: if (DBI_RO_WR_EN == 1) then R/W else R 
Note: This register field is sticky.
                }
            }
            doc {
                MSI-X Table Offset and BIR Register.
For a description of this standard PCIe register, see the PCI Express Base Specification.MSI-X Table Offset and BIR Register.
For a description of this standard PCIe register, see the PCI Express Base Specification.
            }
        }
        register MSIX_PBA_OFFSET_REG @'h8 {
            bytes 4;
            field PCI_MSIX_PBA_BIR @'h0 {
                bits 3;
                access ro;
                hard_reset 'h0;
                doc {
                    MSI-X PBA BIR.
For a description of this standard PCIe register field, see the PCI Express Base Specification.

SRIOV Note: All VFs in a single PF have the same value for "MSI-X PBA BIR" (PCI_MSIX_PBA_BIR field in SHADOW_MSIX_PBA_OFFSET_REG). To write this common value, you must perform a
DBI_CS2 write (that is, assert the dbi_cs2 input, or the CS2 address bit for the AXI bridge) while accessing the PCI_MSIX_PBA_BIR field in the PF MSIX_PBA_OFFSET_REG register.

Note: The access attributes of this field are as follows:
 - Wire: R (sticky) 
 - Dbi: if (DBI_RO_WR_EN == 1) then R/W else R 
Note: This register field is sticky.
                }
            }
            field PCI_MSIX_PBA_OFFSET @'h3 {
                bits 29;
                access ro;
                hard_reset 'h0;
                doc {
                    MSI-X PBA Offset.
For a description of this standard PCIe register field, see the PCI Express Base Specification.

SRIOV Note: All VFs in a single PF have the same value for "MSI-X PBA Offset" (PCI_MSIX_PBA_OFFSET field in SHADOW_MSIX_PBA_OFFSET_REG). To write this common value, you must perform a
DBI_CS2 write (that is, assert the dbi_cs2 input, or the CS2 address bit for the AXI bridge) while accessing the PCI_MSIX_PBA_OFFSET field in the PF MSIX_PBA_OFFSET_REG register.

Note: The access attributes of this field are as follows:
 - Wire: R (sticky) 
 - Dbi: if (DBI_RO_WR_EN == 1) then R/W else R 
Note: This register field is sticky.
                }
            }
            doc {
                MSI-X PBA Offset and BIR Register.
For a description of this standard PCIe register, see the PCI Express Base Specification.MSI-X PBA Offset and BIR Register.
For a description of this standard PCIe register, see the PCI Express Base Specification.
            }
        }
        doc {
            PF MSI-X Capability Structure
        }
    }
    block PF0_DLINK_CAP @'h334 {
        bytes 4;
        register DATA_LINK_FEATURE_EXT_HDR_OFF @'h0 {
            bytes 4;
            field DLINK_EXT_CAP_ID @'h0 {
                bits 16;
                access ro;
                hard_reset 'h0;
                doc {
                    Capability ID.
For a description of this standard PCIe register, see the PCI Express Specification.

Note: The access attributes of this field are as follows:
 - Wire: R (sticky) 
 - Dbi: if (DBI_RO_WR_EN == 1) then R/W(sticky) else R(sticky) 
Note: This register field is sticky.
                }
            }
            field DLINK_CAP_VERSION @'h10 {
                bits 4;
                access ro;
                hard_reset 'h0;
                doc {
                    Capability Version.
For a description of this standard PCIe register, see the PCI Express Specification.

Note: The access attributes of this field are as follows:
 - Wire: R (sticky) 
 - Dbi: if (DBI_RO_WR_EN == 1) then R/W(sticky) else R(sticky) 
Note: This register field is sticky.
                }
            }
            field DLINK_NEXT_OFFSET @'h14 {
                bits 12;
                access ro;
                volatile 1
                hard_reset 'h0;
                doc {
                    Next Capability Offset.
For a description of this standard PCIe register, see the PCI Express Specification.

Note: The access attributes of this field are as follows:
 - Wire: R (sticky) 
 - Dbi: if (DBI_RO_WR_EN == 1) then R/W(sticky) else R(sticky) 
Note: This register field is sticky.
                }
            }
            doc {
                Data Link Feature Extended Capability Header.
For a description of this standard PCIe register, see the PCI Express Specification.Data Link Feature Extended Capability Header.
For a description of this standard PCIe register, see the PCI Express Specification.
            }
        }
        register DATA_LINK_FEATURE_CAP_OFF @'h4 {
            bytes 4;
            field SCALED_FLOW_CNTL_SUPPORTED @'h0 {
                access ro;
                hard_reset 'h0;
                doc {
                    Local Scaled Flow Control Supported.
For a description of this standard PCIe register, see the PCI Express Specification.

Note: The access attributes of this field are as follows:
 - Wire: HWINIT 
 - Dbi: if (DBI_RO_WR_EN == 1) then R/W(sticky) else R(sticky) 
                }
            }
            field FUTURE_FEATURE_SUPPORTED @'h1 {
                bits 22;
                access ro;
                hard_reset 'h0;
                doc {
                    Local Future Data Link Feature Supported.
For a description of this standard PCIe register, see the PCI Express Specification.

Note: The access attributes of this field are as follows:
 - Wire: R (sticky) 
 - Dbi: if (DBI_RO_WR_EN == 1) then R/W(sticky) else R(sticky) 
Note: This register field is sticky.
                }
            }
            field RSVDP_23 @'h17 {
                bits 8;
                access ro;
                hard_reset 'h0;
                soft_reset 'h0;
                doc {
                    Reserved for future use.
                }
            }
            field DL_FEATURE_EXCHANGE_EN @'h1f {
                access ro;
                hard_reset 'h0;
                doc {
                    Data Link Feature Exchange Enable.
For a description of this standard PCIe register, see the PCI Express Specification.

Note: The access attributes of this field are as follows:
 - Wire: HWINIT 
 - Dbi: if (DBI_RO_WR_EN == 1) then R/W(sticky) else R(sticky) 
                }
            }
            doc {
                Data Link Feature Capabilities.
For a description of this standard PCIe register, see the PCI Express Specification.Data Link Feature Capabilities.
For a description of this standard PCIe register, see the PCI Express Specification.
            }
        }
        register DATA_LINK_FEATURE_STATUS_OFF @'h8 {
            bytes 4;
            field REMOTE_DATA_LINK_FEATURE_SUPPORTED @'h0 {
                bits 23;
                access ro;
                volatile 1
                hard_reset 'h0;
                doc {
                    Features Currently defined are: Bit 0 - Remote Scaled Flow Control Supported.
For a description of this standard PCIe register, see the PCI Express Specification.
                }
            }
            field RSVDP_23 @'h17 {
                bits 8;
                access ro;
                hard_reset 'h0;
                soft_reset 'h0;
                doc {
                    Reserved for future use.
                }
            }
            field DATA_LINK_FEATURE_STATUS_VALID @'h1f {
                access ro;
                volatile 1
                hard_reset 'h0;
                doc {
                    Remote Data Link Feature Supported Valid.
For a description of this standard PCIe register, see the PCI Express Specification.
                }
            }
            doc {
                Data Link Feature Status Register.
For a description of this standard PCIe register, see the PCI Express Specification.Data Link Feature Status Register.
For a description of this standard PCIe register, see the PCI Express Specification.
            }
        }
        doc {
            PF DLINK Capability Structure
        }
    }
    block PF0_PORT_LOGIC @'h700 {
        bytes 4;
        register ACK_LATENCY_TIMER_OFF @'h0 {
            bytes 4;
            field ROUND_TRIP_LATENCY_TIME_LIMIT @'h0 {
                bits 16;
                access rw;
                volatile 1
                hard_reset 'h0;
                doc {
                    Ack Latency Timer Limit. The Ack latency timer expires when it reaches this limit. For more details, see "Ack Scheduling".
You can modify the effective timer limit with the TIMER_MOD_ACK_NAK field of the TIMER_CTRL_MAX_FUNC_NUM_OFF register.
After reset, the controller updates the default according to the Negotiated Link Width, Max_Payload_Size, and speed.
The value is determined from Tables 3-7, 3-8, and 3-9 of the PCIe 3.0 specification.
The limit must reflect the round trip latency from requester to completer.
If there is a change in the payload size or link width, the controller will override any value that you have written to this register field, and reset the field back to the specification-defined value. It will not change the value in the TIMER_MOD_ACK_NAK field of the TIMER_CTRL_MAX_FUNC_NUM_OFF register.
                }
            }
            field REPLAY_TIME_LIMIT @'h10 {
                bits 16;
                access rw;
                volatile 1
                hard_reset 'h0;
                doc {
                    Replay Timer Limit. The replay timer expires when it reaches this limit. The controller initiates a replay upon reception of a NAK or when the replay timer expires. For more details, see "Transmit Replay".
You can modify the effective timer limit with the TIMER_MOD_REPLAY_TIMER field of the TIMER_CTRL_MAX_FUNC_NUM_OFF register.
After reset, the controller updates the default according to the Negotiated Link Width, Max_Payload_Size, and speed.
The value is determined from Tables 3-4, 3-5, and 3-6 of the PCIe 3.0 specification.
If there is a change in the payload size or link speed, the controller will override any value that you have written to this register field, and reset the field back to the specification-defined value. It will not change the value in the TIMER_MOD_REPLAY_TIMER field of the TIMER_CTRL_MAX_FUNC_NUM_OFF register.
                }
            }
            doc {
                Ack Latency Timer and Replay Timer Register.Ack Latency Timer and Replay Timer Register.
            }
        }
        register VENDOR_SPEC_DLLP_OFF @'h4 {
            bytes 4;
            field VENDOR_SPEC_DLLP @'h0 {
                bits 32;
                access rw;
                hard_reset 'h0;
                doc {
                    Vendor Specific DLLP Register. Used to send a specific PCI Express DLLP.
Your application writes the 8-bit DLLP Type and 24-bits of Payload data into this register, then sets the field VENDOR_SPECIFIC_DLLP_REQ of PORT_LINK_CTRL_OFF to send the DLLP.
 - [7:0] = Type
 - [31:8] = Payload (24 bits)
The dllp type is in bits [7:0] while the remainder is the vendor defined payload.

Note: This register field is sticky.
                }
            }
            doc {
                Vendor Specific DLLP Register.Vendor Specific DLLP Register.
            }
        }
        register PORT_FORCE_OFF @'h8 {
            bytes 4;
            field LINK_NUM @'h0 {
                bits 8;
                access rw;
                hard_reset 'h0;
                doc {
                    Link Number. Not used for endpoint. Not used for M-PCIe.

Note: This register field is sticky.
                }
            }
            field FORCED_LTSSM @'h8 {
                bits 4;
                access rw;
                hard_reset 'h0;
                doc {
                    Forced Link Command. The link command that the controller is forced to transmit when you set FORCE_EN bit (Force Link).
Link command encoding is defined by the ltssm_cmd variable in workspace/src/Layer1/smlh_ltssm.v.

Note: This register field is sticky.
                }
            }
            field RSVDP_12 @'hc {
                bits 3;
                access ro;
                hard_reset 'h0;
                soft_reset 'h0;
                doc {
                    Reserved for future use.
                }
            }
            field FORCE_EN @'hf {
                access wo;
                volatile 1
                hard_reset 'h0;
                doc {
                    Force Link. The controller supports a testing and debug capability to allow your software to force the LTSSM state machine into a specific state, and to force the controller to transmit a specific Link Command. Asserting this bit triggers the following actions:
 - Forces the LTSSM to the state specified by the Forced LTSSM State field.
 - Forces the controller to transmit the command specified by the Forced Link Command field.
This is a self-clearing register field. Reading from this register field always returns a "0".
                }
            }
            field LINK_STATE @'h10 {
                bits 6;
                access rw;
                hard_reset 'h0;
                doc {
                    Forced LTSSM State. The LTSSM state that the controller is forced to when you set the FORCE_EN bit (Force Link).
LTSSM state encoding is defined by the lts_state variable in workspace/src/Layer1/smlh_ltssm.v.

Note: This register field is sticky.
                }
            }
            field RSVDP_22 @'h16 {
                access ro;
                hard_reset 'h0;
                soft_reset 'h0;
                doc {
                    Reserved for future use.
                }
            }
            field DO_DESKEW_FOR_SRIS @'h17 {
                access rw;
                hard_reset 'h0;
                doc {
                    Use the transitions from TS2 to Logical Idle Symbol, SKP OS to Logical Idle Symbol, EIEOS to Logical Idle Symbol, and FTS Sequence to SKP OS to do deskew instead of using received SKP OS or TS1 to TS2 transition if DO_DESKEW_FOR_SRIS is set to 1.

Note: This register field is sticky.
                }
            }
            field RSVDP_24 @'h18 {
                bits 8;
                access ro;
                hard_reset 'h0;
                soft_reset 'h0;
                doc {
                    Reserved for future use.
                }
            }
            doc {
                Port Force Link Register.Port Force Link Register.
            }
        }
        register ACK_F_ASPM_CTRL_OFF @'hc {
            bytes 4;
            field ACK_FREQ @'h0 {
                bits 8;
                access rw;
                hard_reset 'h0;
                doc {
                    Ack Frequency. The controller accumulates the number of pending ACKs specified here (up to 255) before scheduling an ACK DLLP.
 - 0: Indicates that this Ack Frequency Counter feature is turned off. The controller generates a low-priority ACK request for every TLP that it receives. The controller waits until the ACK Latency Timer expires, then converts the current low-priority ACK request to a high-priority ACK request and schedules the DLLP for transmission to the remote link partner.
 - 1-255: Indicates that the controller will schedule a high-priority ACK after receiving this number of TLPs. It might schedule the ACK before receiving this number of TLPs if the ACK Latency Timer expires, but never later.
For a typical system, you do not have to modify the default setting. For more details, see "ACK/NAK Scheduling".

Note: This register field is sticky.
                }
            }
            field ACK_N_FTS @'h8 {
                bits 8;
                access rw;
                hard_reset 'h0;
                doc {
                    N_FTS. The number of Fast Training Sequence ordered sets to be transmitted when transitioning from L0s to L0. The maximum number of FTS ordered-sets that a component can request is 255.
The controller does not support a value of zero; a value of zero can cause the LTSSM to go into the recovery state when exiting from L0s.
This field is reserved (fixed to '0') for M-PCIe.

Note: This register field is sticky.
                }
            }
            field COMMON_CLK_N_FTS @'h10 {
                bits 8;
                access ro;
                hard_reset 'h0;
                doc {
                    Common Clock N_FTS. This is the N_FTS when common clock is used.
The number of Fast Training Sequence ordered sets to be transmitted when transitioning from L0s to L0. The maximum number of FTS ordered-sets that a component can request is 255. This field is only writable (sticky) when all of the following configuration parameter equations are true:
 - CX_NFTS !=CX_COMM_NFTS
 - DEFAULT_L0S_EXIT_LATENCY !=DEFAULT_COMM_L0S_EXIT_LATENCY
 - DEFAULT_L1_EXIT_LATENCY !=DEFAULT_COMM_L1_EXIT_LATENCY
The controller does not support a value of zero; a value of zero can cause the LTSSM to go into the recovery state when exiting from L0s.
This field is reserved (fixed to '0') for M-PCIe.

Note: The access attributes of this field are as follows:
 - Wire: R 
 - Dbi: R 
                }
            }
            field L0S_ENTRANCE_LATENCY @'h18 {
                bits 3;
                access rw;
                hard_reset 'h0;
                doc {
                    L0s Entrance Latency. Values correspond to:
 - 000: 1 us
 - 001: 2 us
 - 010: 3 us
 - 011: 4 us
 - 100: 5 us
 - 101: 6 us
 - 110 or 111: 7 us
This field is applicable to STALL while in L0 for M-PCIe.

Note: This register field is sticky.
                }
            }
            field L1_ENTRANCE_LATENCY @'h1b {
                bits 3;
                access rw;
                hard_reset 'h0;
                doc {
                    L1 Entrance Latency. Value range is:
 - 000: 1 us
 - 001: 2 us
 - 010: 4 us
 - 011: 8 us
 - 100: 16 us
 - 101: 32 us
 - 110 or 111: 64 us
Note: Programming this timer with a value greater that 32us has no effect unless extended sync is used, or all of the credits are infinite.

Note: This register field is sticky.
                }
            }
            field ENTER_ASPM @'h1e {
                access rw;
                hard_reset 'h0;
                doc {
                    ASPM L1 Entry Control.
 - 1: Core enters ASPM L1 after a period in which it has been idle.
 - 0: Core enters ASPM L1 only after idle period during which both receive and transmit are in L0s.
Note: This register field is sticky.
                }
            }
            field RSVDP_31 @'h1f {
                access ro;
                hard_reset 'h0;
                soft_reset 'h0;
                doc {
                    Reserved for future use.
                }
            }
            doc {
                Ack Frequency and L0-L1 ASPM Control Register.Ack Frequency and L0-L1 ASPM Control Register.
            }
        }
        register PORT_LINK_CTRL_OFF @'h10 {
            bytes 4;
            field VENDOR_SPECIFIC_DLLP_REQ @'h0 {
                access w1c;
                volatile 1
                hard_reset 'h0;
                doc {
                    Vendor Specific DLLP Request. When software writes a '1' to this bit, the controller transmits the DLLP contained in the VENDOR_SPEC_DLLP field of VENDOR_SPEC_DLLP_OFF.

Reading from this self-clearing register field always returns a '0'.
                }
            }
            field SCRAMBLE_DISABLE @'h1 {
                access rw;
                hard_reset 'h0;
                doc {
                    Scramble Disable. Turns off data scrambling.

Note: This register field is sticky.
                }
            }
            field LOOPBACK_ENABLE @'h2 {
                access rw;
                hard_reset 'h0;
                doc {
                    Loopback Enable. Turns on loopback. For more details, see "Loopback".
For M-PCIe, to force the master to enter Digital Loopback mode, you must set this field to "1" during Configuration.start state(initial discovery/configuration).
M-PCIe doesn't support loopback mode from L0 state - only from Configuration.start.

Note: This register field is sticky.
                }
            }
            field RESET_ASSERT @'h3 {
                access rw;
                hard_reset 'h0;
                doc {
                    Reset Assert. Triggers a recovery and forces the LTSSM to the hot reset state (downstream port only).

Note: This register field is sticky.
                }
            }
            field RSVDP_4 @'h4 {
                access ro;
                hard_reset 'h0;
                soft_reset 'h0;
                doc {
                    Reserved for future use.
                }
            }
            field DLL_LINK_EN @'h5 {
                access rw;
                hard_reset 'h0;
                doc {
                    DLL Link Enable. Enables link initialization. When DLL Link Enable =0, the controller does not transmit InitFC DLLPs and does not establish a link.

Note: This register field is sticky.
                }
            }
            field LINK_DISABLE @'h6 {
                access rw;
                hard_reset 'h0;
                doc {
                    LINK_DISABLE is an internally reserved field. Do not use.

Note: This register field is sticky.
                }
            }
            field FAST_LINK_MODE @'h7 {
                access rw;
                hard_reset 'h0;
                doc {
                    Fast Link Mode. Sets all internal LTSSM millisecond timers to Fast Mode for speeding up simulation. Forces the LTSSM training (link initialization) to use shorter time-outs and to link up faster.
The default scaling factor can be changed using the DEFAULT_FAST_LINK_SCALING_FACTOR parameter or through the FAST_LINK_SCALING_FACTOR field in the TIMER_CTRL_MAX_FUNC_NUM_OFF register.
Fast Link Mode can also be activated by setting the diag_ctrl_bus[2] pin to '1'.
For more details, see the "Fast Link Simulation Mode" section in the "Integrating the Core with the PHY or Application RTL or Verification IP" chapter of the User Guide.

For M-PCIe, this field also affects Remain Hibern8 Time, Minimum Activate Time, and RRAP timeout. If this bit is set to '1', tRRAPInitiatorResponse is set to 1.88 ms(60 ms/32).

Note: This register field is sticky.
                }
            }
            field LINK_RATE @'h8 {
                bits 4;
                access rw;
                hard_reset 'h0;
                doc {
                    LINK_RATE is an internally reserved field. Do not use.

Note: This register field is sticky.
                }
            }
            field RSVDP_12 @'hc {
                bits 4;
                access ro;
                hard_reset 'h0;
                soft_reset 'h0;
                doc {
                    Reserved for future use.
                }
            }
            field LINK_CAPABLE @'h10 {
                bits 6;
                access rw;
                volatile 1
                hard_reset 'h0;
                doc {
                    Link Mode Enable. Sets the number of lanes in the link that you want to connect to the link partner. When you have unused lanes in your system, then you must change the value in this register to reflect the number of lanes. You must also change the value in the "Predetermined Number of Lanes" field of the "Link Width and Speed Change Control Register". For more information, see "How to Tie Off Unused Lanes". For information on upsizing and downsizing the link width, see "Link Establishment".
 - 000001: x1
 - 000011: x2
 - 000111: x4
 - 001111: x8
 - 011111: x16
 - 111111: x32 (not supported)
This field is reserved (fixed to '0') for M-PCIe.

Note: This register field is sticky.
                }
            }
            field BEACON_ENABLE @'h18 {
                access rw;
                hard_reset 'h0;
                doc {
                    BEACON_ENABLE is an internally reserved field. Do not use.

Note: This register field is sticky.
                }
            }
            field CORRUPT_LCRC_ENABLE @'h19 {
                access rw;
                hard_reset 'h0;
                doc {
                    CORRUPT_LCRC_ENABLE is an internally reserved field. Do not use.

Note: This register field is sticky.
                }
            }
            field EXTENDED_SYNCH @'h1a {
                access rw;
                hard_reset 'h0;
                doc {
                    EXTENDED_SYNCH is an internally reserved field. Do not use.

Note: This register field is sticky.
                }
            }
            field TRANSMIT_LANE_REVERSALE_ENABLE @'h1b {
                access rw;
                hard_reset 'h0;
                doc {
                    TRANSMIT_LANE_REVERSALE_ENABLE is an internally reserved field. Do not use.

Note: This register field is sticky.
                }
            }
            field RSVDP_28 @'h1c {
                bits 4;
                access ro;
                hard_reset 'h0;
                soft_reset 'h0;
                doc {
                    Reserved for future use.
                }
            }
            doc {
                Port Link Control Register.Port Link Control Register.
            }
        }
        register LANE_SKEW_OFF @'h14 {
            bytes 4;
            field INSERT_LANE_SKEW @'h0 {
                bits 24;
                access rw;
                hard_reset 'h0;
                doc {
                    INSERT_LANE_SKEW is an internally reserved field. Do not use.

Note: This register field is sticky.
                }
            }
            field FLOW_CTRL_DISABLE @'h18 {
                access rw;
                hard_reset 'h0;
                doc {
                    Flow Control Disable. Prevents the controller from sending FC DLLPs.

Note: This register field is sticky.
                }
            }
            field ACK_NAK_DISABLE @'h19 {
                access rw;
                hard_reset 'h0;
                doc {
                    Ack/Nak Disable. Prevents the controller from sending ACK and NAK DLLPs.

Note: This register field is sticky.
                }
            }
            field ELASTIC_BUFFER_MODE @'h1a {
                access rw;
                hard_reset 'h0;
                doc {
                    Selects Elasticity Buffer operating mode:
0: Nominal Half Full Buffer mode
1: Nominal Empty Buffer Mode

Note: This register field is sticky.
                }
            }
            field IMPLEMENT_NUM_LANES @'h1b {
                bits 4;
                access rw;
                hard_reset 'h0;
                doc {
                    Implementation-specific Number of Lanes. Set the implementation-specific number of lanes. Allowed values are:
 - 4'b0000: 1 lane
 - 4'b0001: 2 lanes
 - 4'b0011: 4 lanes
 - 4'b0111: 8 lanes
 - 4'b1111: 16 lanes
The number of lanes to be used when in Loopback Master. The number of lanes programmed must be equal to or less than the valid number of lanes set in LINK_CAPABLE field. You must configure this field before initiating Loopback by writing in the LOOPBACK_ENABLE field.
The controller will transition from Loopback.Entry to Loopback.Active after receiving two consecutive TS1 Ordered Sets with the Loopback bit asserted on the implementation specific number of lanes configured in this field.

Note: This register field is sticky.
                }
            }
            field DISABLE_LANE_TO_LANE_DESKEW @'h1f {
                access rw;
                hard_reset 'h0;
                doc {
                    Disable Lane-to-Lane Deskew. Causes the controller to disable the internal Lane-to-Lane deskew logic.

Note: This register field is sticky.
                }
            }
            doc {
                Lane Skew Register.Lane Skew Register.
            }
        }
        register TIMER_CTRL_MAX_FUNC_NUM_OFF @'h18 {
            bytes 4;
            field MAX_FUNC_NUM @'h0 {
                bits 8;
                access rw;
                hard_reset 'h0;
                doc {
                    Maximum function number that can be used in a request. Configuration requests targeted at function numbers above this value are returned with UR (unsupported request).

Note: This register field is sticky.
                }
            }
            field RSVDP_8 @'h8 {
                bits 6;
                access ro;
                hard_reset 'h0;
                soft_reset 'h0;
                doc {
                    Reserved for future use.
                }
            }
            field TIMER_MOD_REPLAY_TIMER @'he {
                bits 5;
                access rw;
                volatile 1
                hard_reset 'h0;
                doc {
                    Replay Timer Limit Modifier. Increases the time-out value for the replay timer in increments of 64 clock cycles at Gen1 or Gen2 speed, and in increments of 256 clock cycles at Gen3 speed. A value of "0" represents no modification to the timer limit. For more details, see the REPLAY_TIME_LIMIT field of the ACK_LATENCY_TIMER_OFF register.
At Gen3 speed, the controller automatically changes the value of this field to DEFAULT_GEN3_REPLAY_ADJ.
For M-PCIe, this field increases the time-out value for the replay timer in increments of 64 clock cycles at HS-Gear1, HS-Gear2, or HS-Gear3 speed.

Note: This register field is sticky.
                }
            }
            field TIMER_MOD_ACK_NAK @'h13 {
                bits 5;
                access rw;
                hard_reset 'h0;
                doc {
                    Ack Latency Timer Modifier. Increases the timer value for the Ack latency timer in increments of 64 clock cycles. A value of "0" represents no modification to the timer value. For more details, see the ROUND_TRIP_LATENCY_TIME_LIMIT field of the ACK_LATENCY_TIMER_OFF register.

Note: This register field is sticky.
                }
            }
            field UPDATE_FREQ_TIMER @'h18 {
                bits 5;
                access rw;
                hard_reset 'h0;
                doc {
                    UPDATE_FREQ_TIMER is an internally reserved field. Do not use.

Note: This register field is sticky.
                }
            }
            field FAST_LINK_SCALING_FACTOR @'h1d {
                bits 2;
                access rw;
                hard_reset 'h0;
                doc {
                    Fast Link Timer Scaling Factor. Sets the scaling factor of LTSSM timer when FAST_LINK_MODE field in PORT_LINK_CTRL_OFF is set to '1'.
 - 0: Scaling Factor is 1024 (1ms is 1us *a)
 - 1: Scaling Factor is 256 (1ms is 4us)
 - 2: Scaling Factor is 64 (1ms is 16us)
 - 3: Scaling Factor is 16 (1ms is 64us)
Default is set by the hidden configuration parameter DEFAULT_FAST_LINK_SCALING_FACTOR which defaults to '0'.

*a. When the LTSSM is in Config or L12 Entry State, 1ms timer is 2us, 2ms timer is 4us and 3ms timer is 6us.

Not used for M-PCIe.  

Note: This register field is sticky.
                }
            }
            field RSVDP_31 @'h1f {
                access ro;
                hard_reset 'h0;
                soft_reset 'h0;
                doc {
                    Reserved for future use.
                }
            }
            doc {
                Timer Control and Max Function Number Register.Timer Control and Max Function Number Register.
            }
        }
        register SYMBOL_TIMER_FILTER_1_OFF @'h1c {
            bytes 4;
            field SKP_INT_VAL @'h0 {
                bits 11;
                access rw;
                hard_reset 'h0;
                doc {
                    SKP Interval Value. The number of symbol times to wait between transmitting SKP ordered sets. Note that the controller actually waits the number of symbol times in this register plus 1 between transmitting SKP ordered sets. Your application must program this register accordingly. For example, if 1536 were programmed into this register (in a 250 MHz controller), then the controller actually transmits SKP ordered sets once every 1537 symbol times.
The value programmed to this register is actually clock ticks and not symbol times. In a 125 MHz controller, programming the value programmed to this register should be scaled down by a factor of 2 (because one clock tick = two symbol times in this case).

Note: This value is not used at Gen3 speed; the skip interval is hardcoded to 370 blocks.
For M-PCIe configurations, if the 2K_PPM_DISABLED field in the M-PCIe Configuration Attribute is changed, then this field is changed automatically as follows.
 - 2K_PPM_DISABLED=1: 1280 / CX_NB
 - 2K_PPM_DISABLED=0: 228/CX_NB
You need to set this field again if necessary when 2K_PPM_DISABLED is changed.

Note: This register field is sticky.
                }
            }
            field EIDLE_TIMER @'hb {
                bits 4;
                access rw;
                hard_reset 'h0;
                doc {
                    EIDLE_TIMER is an internally reserved field. Do not use.

Note: This register field is sticky.
                }
            }
            field DISABLE_FC_WD_TIMER @'hf {
                access rw;
                hard_reset 'h0;
                doc {
                    Disable FC Watchdog Timer.

Note: This register field is sticky.
                }
            }
            field MASK_RADM_1 @'h10 {
                bits 16;
                access rw;
                hard_reset 'h0;
                doc {
                    Filter Mask 1. The Filter Mask 1 Register modifies the RADM filtering and error handling rules. For more details, see the "Receive Filtering" section. In each case, '0' applies the associated filtering rule and '1' masks the associated filtering rule.

[31]: CX_FLT_MASK_RC_CFG_DISCARD
 - 0: For RADM RC filter to not allow CFG transaction being received
 - 1: For RADM RC filter to allow CFG transaction being received
[30]: CX_FLT_MASK_RC_IO_DISCARD
 - 0: For RADM RC filter to not allow IO transaction being received
 - 1: For RADM RC filter to allow IO transaction being received
[29]: CX_FLT_MASK_MSG_DROP
 - 0: Drop MSG TLP (except for Vendor MSG). Send decoded message on the SII.
 - 1: Do not Drop MSG (except for Vendor MSG). Send message TLPs to your application on TRGT1 and send decoded message on the SII.
 - The default for this bit is the inverse of FLT_DROP_MSG. That is, if FLT_DROP_MSG =1, then the default of this bit is "0" (drop message TLPs). This bit only controls message TLPs other than Vendor MSGs. Vendor MSGs are controlled by Filter Mask Register 2, bits [1:0]. 
The controller never passes ATS Invalidate messages to the SII interface regardless of this filter rule setting. The controller passes all ATS Invalidate messages to TRGT1 (or AXI bridge master), as they are too big for the SII.
[28]: CX_FLT_MASK_CPL_ECRC_DISCARD
 - Only used when completion queue is advertised with infinite credits and is in store-and-forward mode.
 - 0: Discard completions with ECRC errors
 - 1: Allow completions with ECRC errors to be passed up
 - Reserved field for SW.
[27]: CX_FLT_MASK_ECRC_DISCARD
 - 0: Discard TLPs with ECRC errors
 - 1: Allow TLPs with ECRC errors to be passed up
[26]: CX_FLT_MASK_CPL_LEN_MATCH
 - 0: Enforce length match for completions; a violation results in cpl_abort, and possibly AER of unexp_cpl_err
 - 1: MASK length match for completions
[25]: CX_FLT_MASK_CPL_ATTR_MATCH
 - 0: Enforce attribute match for completions; a violation results in a malformed TLP error, and possibly AER of unexp_cpl_err, cpl_rcvd_ur, cpl_rcvd_ca
 - 1: Mask attribute match for completions
[24]: CX_FLT_MASK_CPL_TC_MATCH
 - 0: Enforce Traffic Class match for completions; a violation results in a malformed TLP error, and possibly AER of unexp_cpl_err, cpl_rcvd_ur, cpl_rcvd_ca
 - 1: Mask Traffic Class match for completions
[23]: CX_FLT_MASK_CPL_FUNC_MATCH
 - 0: Enforce function match for completions; a violation results in cpl_abort, and possibly AER of unexp_cpl_err, cpl_rcvd_ur, cpl_rcvd_ca
 - 1: Mask function match for completions
[22]: CX_FLT_MASK_CPL_REQID_MATCH
 - 0: Enforce Req. Id match for completions; a violation result in cpl_abort, and possibly AER of unexp_cpl_err, cpl_rcvd_ur, cpl_rcvd_ca
 - 1: Mask Req. Id match for completions
[21]: CX_FLT_MASK_CPL_TAGERR_MATCH
 - 0: Enforce Tag Error Rules for completions; a violation result in cpl_abort, and possibly AER of unexp_cpl_err, cpl_rcvd_ur, cpl_rcvd_ca
 - 1: Mask Tag Error Rules for completions
[20]: CX_FLT_MASK_LOCKED_RD_AS_UR
 - 0: Treat locked Read TLPs as UR for EP; Supported for RC
 - 1: Treat locked Read TLPs as Supported for EP; UR for RC
[19]: CX_FLT_MASK_CFG_TYPE1_REQ_AS_UR
 - 0: Treat CFG type1 TLPs as UR for EP; Supported for RC
 - 1: Treat CFG type1 TLPs as Supported for EP; UR for RC
 - When CX_SRIOV_ENABLE is set then this bit is set to allow the filter to process Type 1 Config requests if the EP consumes more than one bus number.
[18]: CX_FLT_MASK_UR_OUTSIDE_BAR
 - 0: Treat out-of-bar TLPs as UR
 - 1: Do not treat out-of-bar TLPs as UR
[17]: CX_FLT_MASK_UR_POIS
 - 0: Treat poisoned request TLPs as UR
 - 1: Do not treat poisoned request TLPs as UR
 - The native controller always passes poisoned completions to your application except when you are using the DMA read channel.
[16]: CX_FLT_MASK_UR_FUNC_MISMATCH
 - 0: Treat Function MisMatched TLPs as UR
 - 1: Do not treat Function MisMatched TLPs as UR
Note: This register field is sticky.
                }
            }
            doc {
                Symbol Timer Register and Filter Mask 1 Register. The Filter Mask 1 Register modifies the RADM filtering and error handling rules. For more details, see the "Receive Filtering" section. In each case, '0' applies the associated filtering rule and '1' masks the associated filtering rule.Symbol Timer Register and Filter Mask 1 Register. The Filter Mask 1 Register modifies the RADM filtering and error handling rules. For more details, see the "Receive Filtering" section. In each case, '0' applies the associated filtering rule and '1' masks the associated filtering rule.
            }
        }
        register FILTER_MASK_2_OFF @'h20 {
            bytes 4;
            field MASK_RADM_2 @'h0 {
                bits 32;
                access rw;
                hard_reset 'h0;
                doc {
                    Filter Mask 2. This field modifies the RADM filtering and error handling rules. For more details, see the "Receive Filtering" section. In each case, '0' applies the associated filtering rule and '1' masks the associated filtering rule.

[31:9]: Reserved


[8]: CX_FLT_MASK_POIS_ERROR_REPORTING
 - 0: Disable masking of error reporting for Poisoned TLPs
 - 1: Enable masking of error reporting for Poisoned TLPs
[7]: CX_FLT_MASK_PRS_DROP
 - 0: Allow PRS message to pass through
 - 1: Drop PRS Messages silently
 - This bit is ignored when the CX_FLT_MASK_MSG_DROP bit in the MASK_RADM_1 field of the SYMBOL_TIMER_FILTER_1_OFF register is set to '1'.
[6]: CX_FLT_UNMASK_TD
 - 0: Disable unmask TD bit if CX_STRIP_ECRC_ENABLE
 - 1: Enable unmask TD bit if CX_STRIP_ECRC_ENABLE
[5]: CX_FLT_UNMASK_UR_POIS_TRGT0
 - 0: Disable unmask CX_FLT_MASK_UR_POIS with TRGT0 destination
 - 1: Enable unmask CX_FLT_MASK_UR_POIS with TRGT0 destination
[4]: CX_FLT_MASK_LN_VENMSG1_DROP
 - 0: Allow LN message to pass through
 - 1: Drop LN Messages silently
[3]: CX_FLT_MASK_HANDLE_FLUSH
 - 0: Disable controller Filter to handle flush request
 - 1: Enable controller Filter to handle flush request
[2]: CX_FLT_MASK_DABORT_4UCPL
 - 0: Enable DLLP abort for unexpected completion
 - 1: Do not enable DLLP abort for unexpected completion
[1]: CX_FLT_MASK_VENMSG1_DROP
 - 0: Vendor MSG Type 1 dropped silently
 - 1: Vendor MSG Type 1 not dropped
[0]: CX_FLT_MASK_VENMSG0_DROP
 - 0: Vendor MSG Type 0 dropped with UR error reporting
 - 1: Vendor MSG Type 0 not dropped
Note: This register field is sticky.
                }
            }
            doc {
                Filter Mask 2 Register. This register modifies the RADM filtering and error handling rules. For more details, see the "Receive Filtering" section. In each case, '0' applies the associated filtering rule and '1' masks the associated filtering rule.Filter Mask 2 Register. This register modifies the RADM filtering and error handling rules. For more details, see the "Receive Filtering" section. In each case, '0' applies the associated filtering rule and '1' masks the associated filtering rule.
            }
        }
        register AMBA_MUL_OB_DECOMP_NP_SUB_REQ_CTRL_OFF @'h24 {
            bytes 4;
            field OB_RD_SPLIT_BURST_EN @'h0 {
                access rw;
                hard_reset 'h0;
                doc {
                    Enable AMBA Multiple Outbound Decomposed NP SubRequests. This bit when set to "0" disables the possibility of having multiple outstanding non-posted requests that were derived from decomposition of an outbound AMBA request. For more details, see "AXI Bridge Ordering" in the AXI chapter of the Databook.
You should not clear this register unless your application master is requesting an amount of read data greater than Max_Read_Request_Size, and the remote device (or switch) is reordering completions that have different tags.

Note: The access attributes of this field are as follows:
 - Wire: R/W (sticky) 
 - Dbi: R/W (sticky) 
Note: This register field is sticky.
                }
            }
            field RSVDP_1 @'h1 {
                bits 31;
                access ro;
                hard_reset 'h0;
                soft_reset 'h0;
                doc {
                    Reserved for future use.
                }
            }
            doc {
                AMBA Multiple Outbound Decomposed NP SubRequests Control Register.AMBA Multiple Outbound Decomposed NP SubRequests Control Register.
            }
        }
        register PL_DEBUG0_OFF @'h28 {
            bytes 4;
            field DEB_REG_0 @'h0 {
                bits 32;
                access ro;
                volatile 1
                hard_reset 'h0;
                doc {
                    The value on cxpl_debug_info[31:0].
                }
            }
            doc {
                Debug Register 0Debug Register 0
            }
        }
        register PL_DEBUG1_OFF @'h2c {
            bytes 4;
            field DEB_REG_1 @'h0 {
                bits 32;
                access ro;
                volatile 1
                hard_reset 'h0;
                doc {
                    The value on cxpl_debug_info[63:32].
                }
            }
            doc {
                Debug Register 1Debug Register 1
            }
        }
        register TX_P_FC_CREDIT_STATUS_OFF @'h30 {
            bytes 4;
            field TX_P_DATA_FC_CREDIT @'h0 {
                bits 16;
                access ro;
                volatile 1
                hard_reset 'h0;
                doc {
                    Transmit Posted Data FC Credits. The posted Data credits advertised by the receiver at the other end of the link, updated with each UpdateFC DLLP.
Default value depends on the number of advertised credits for header and data
Scaled Flow Control: [4'b0, xtlh_xadm_ph_cdts, xtlh_xadm_pd_cdts]; When the number of advertised posted credits (both header and data) are infinite, then the default would be [4'b0, 12'hFFF, 16'hFFFF].
No Scaling: [12'b0, xtlh_xadm_ph_cdts, xtlh_xadm_pd_cdts]; When the number of advertised posted credits (both header and data) are infinite, then the default would be [12'b0, 8'hFF, 12'hFFF].
                }
            }
            field TX_P_HEADER_FC_CREDIT @'h10 {
                bits 12;
                access ro;
                volatile 1
                hard_reset 'h0;
                doc {
                    Transmit Posted Header FC Credits. The posted Header credits advertised by the receiver at the other end of the link, updated with each UpdateFC DLLP.
Default value depends on the number of advertised credits for header and data
Scaled Flow Control: [4'b0, xtlh_xadm_ph_cdts, xtlh_xadm_pd_cdts]; When the number of advertised posted credits (both header and data) are infinite, then the default would be [4'b0, 12'hFFF, 16'hFFFF].
No Scaling: [12'b0, xtlh_xadm_ph_cdts, xtlh_xadm_pd_cdts]; When the number of advertised posted credits (both header and data) are infinite, then the default would be [12'b0, 8'hFF, 12'hFFF].
                }
            }
            field RSVDP_TX_P_FC_CREDIT_STATUS @'h1c {
                bits 4;
                access ro;
                hard_reset 'h0;
                doc {
                    Reserved for future use.
                }
            }
            doc {
                Transmit Posted FC Credit StatusTransmit Posted FC Credit Status
            }
        }
        register TX_NP_FC_CREDIT_STATUS_OFF @'h34 {
            bytes 4;
            field TX_NP_DATA_FC_CREDIT @'h0 {
                bits 16;
                access ro;
                volatile 1
                hard_reset 'h0;
                doc {
                    Transmit Non-Posted Data FC Credits. The non-posted Data credits advertised by the receiver at the other end of the link, updated with each UpdateFC DLLP.
Default value depends on the number of advertised credits for header and data
Scaled Flow Control: [4'b0, xtlh_xadm_nph_cdts, xtlh_xadm_npd_cdts]; When the number of advertised non-posted credits (both header and data) are infinite, then the default would be [4'b0, 12'hFFF, 16'hFFFF].
No Scaling: [12'b0, xtlh_xadm_nph_cdts, xtlh_xadm_npd_cdts]; When the number of advertised non-posted credits (both header and data) are infinite, then the default would be [12'b0, 8'hFF, 12'hFFF].
                }
            }
            field TX_NP_HEADER_FC_CREDIT @'h10 {
                bits 12;
                access ro;
                volatile 1
                hard_reset 'h0;
                doc {
                    Transmit Non-Posted Header FC Credits. The non-posted Header credits advertised by the receiver at the other end of the link, updated with each UpdateFC DLLP.
Default value depends on the number of advertised credits for header and data
Scaled Flow Control: [4'b0, xtlh_xadm_nph_cdts, xtlh_xadm_npd_cdts]; When the number of advertised non-posted credits (both header and data) are infinite, then the default would be [4'b0, 12'hFFF, 16'hFFFF].
No Scaling: [12'b0, xtlh_xadm_nph_cdts, xtlh_xadm_npd_cdts]; When the number of advertised non-posted credits (both header and data) are infinite, then the default would be [12'b0, 8'hFF, 12'hFFF].
                }
            }
            field RSVDP_TX_NP_FC_CREDIT_STATUS @'h1c {
                bits 4;
                access ro;
                hard_reset 'h0;
                doc {
                    Reserved for future use.
                }
            }
            doc {
                Transmit Non-Posted FC Credit StatusTransmit Non-Posted FC Credit Status
            }
        }
        register TX_CPL_FC_CREDIT_STATUS_OFF @'h38 {
            bytes 4;
            field TX_CPL_DATA_FC_CREDIT @'h0 {
                bits 16;
                access ro;
                volatile 1
                hard_reset 'h0;
                doc {
                    Transmit Completion Data FC Credits. The Completion Data credits advertised by the receiver at the other end of the link, updated with each UpdateFC DLLP.
Default value depends on the number of advertised credits for header and data
Scaled Flow Control: [4'b0, xtlh_xadm_cplh_cdts, xtlh_xadm_cpld_cdts]; When the number of advertised completion credits (both header and data) are infinite, then the default would be [4'b0, 12'hFFF, 16'hFFFF].
No Scaling: [12'b0, xtlh_xadm_cplh_cdts, xtlh_xadm_cpld_cdts]; When the number of advertised completion credits (both header and data) are infinite, then the default would be [12'b0, 8'hFF, 12'hFFF].
                }
            }
            field TX_CPL_HEADER_FC_CREDIT @'h10 {
                bits 12;
                access ro;
                volatile 1
                hard_reset 'h0;
                doc {
                    Transmit Completion Header FC Credits. The Completion Header credits advertised by the receiver at the other end of the link, updated with each UpdateFC DLLP.
Default value depends on the number of advertised credits for header and data
Scaled Flow Control: [4'b0, xtlh_xadm_cplh_cdts, xtlh_xadm_cpld_cdts]; When the number of advertised completion credits (both header and data) are infinite, then the default would be [4'b0, 12'hFFF, 16'hFFFF].
No Scaling: [12'b0, xtlh_xadm_cplh_cdts, xtlh_xadm_cpld_cdts]; When the number of advertised completion credits (both header and data) are infinite, then the default would be [12'b0, 8'hFF, 12'hFFF].
                }
            }
            field RSVDP_TX_CPL_FC_CREDIT_STATUS @'h1c {
                bits 4;
                access ro;
                hard_reset 'h0;
                doc {
                    Reserved for future use.
                }
            }
            doc {
                Transmit Completion FC Credit StatusTransmit Completion FC Credit Status
            }
        }
        register QUEUE_STATUS_OFF @'h3c {
            bytes 4;
            field RX_TLP_FC_CREDIT_NON_RETURN @'h0 {
                access ro;
                volatile 1
                hard_reset 'h0;
                doc {
                    Received TLP FC Credits Not Returned. Indicates that the controller has received a TLP but has not yet sent an UpdateFC DLLP indicating that the credits for that TLP have been restored by the receiver at the other end of the link.
                }
            }
            field TX_RETRY_BUFFER_NE @'h1 {
                access ro;
                volatile 1
                hard_reset 'h0;
                doc {
                    Transmit Retry Buffer Not Empty. Indicates that there is data in the transmit retry buffer.
                }
            }
            field RX_QUEUE_NON_EMPTY @'h2 {
                access ro;
                volatile 1
                hard_reset 'h0;
                doc {
                    Receive Credit Queue Not Empty. Indicates there is data in one or more of the receive buffers.
                }
            }
            field RX_QUEUE_OVERFLOW @'h3 {
                access w1c;
                volatile 1
                hard_reset 'h0;
                doc {
                    Receive Credit Queue Overflow. Indicates insufficient buffer space available to write to the P/NP/CPL credit queue.
                }
            }
            field RSVDP_4 @'h4 {
                bits 9;
                access ro;
                hard_reset 'h0;
                soft_reset 'h0;
                doc {
                    Reserved for future use.
                }
            }
            field RX_SERIALIZATION_Q_NON_EMPTY @'hd {
                access ro;
                volatile 1
                hard_reset 'h0;
                doc {
                    Receive Serialization Queue Not Empty. Indicates there is data in the serialization queue.
                }
            }
            field RX_SERIALIZATION_Q_WRITE_ERR @'he {
                access w1c;
                volatile 1
                hard_reset 'h0;
                doc {
                    Receive Serialization Queue Write Error. Indicates insufficient buffer space available to write to the serialization queue.
                }
            }
            field RX_SERIALIZATION_Q_READ_ERR @'hf {
                access w1c;
                volatile 1
                hard_reset 'h0;
                doc {
                    Receive Serialization Read Error. Indicates the serialization queue has attempted to read an incorrectly formatted TLP.
                }
            }
            field TIMER_MOD_FLOW_CONTROL @'h10 {
                bits 13;
                access rw;
                volatile 1
                hard_reset 'h0;
                doc {
                    FC Latency Timer Override Value. When you set the "FC Latency Timer Override Enable" in this register, the value in this field will override the FC latency timer value that the controller calculates according to the PCIe specification. For more details, see "Flow Control".

Note: This register field is sticky.
                }
            }
            field RSVDP_29 @'h1d {
                bits 2;
                access ro;
                hard_reset 'h0;
                soft_reset 'h0;
                doc {
                    Reserved for future use.
                }
            }
            field TIMER_MOD_FLOW_CONTROL_EN @'h1f {
                access rw;
                volatile 1
                hard_reset 'h0;
                doc {
                    FC Latency Timer Override Enable. When this bit is set, the value from the "FC Latency Timer Override Value" field in this register will override the FC latency timer value that the controller calculates according to the PCIe specification.

Note: This register field is sticky.
                }
            }
            doc {
                Queue StatusQueue Status
            }
        }
        register VC_TX_ARBI_1_OFF @'h40 {
            bytes 4;
            field WRR_WEIGHT_VC_0 @'h0 {
                bits 8;
                access ro;
                hard_reset 'h0;
                doc {
                    WRR Weight for VC0.

Note: The access attributes of this field are as follows:
 - Wire: R 
 - Dbi: R 
                }
            }
            field WRR_WEIGHT_VC_1 @'h8 {
                bits 8;
                access ro;
                hard_reset 'h0;
                doc {
                    WRR Weight for VC1.

Note: The access attributes of this field are as follows:
 - Wire: R 
 - Dbi: R 
                }
            }
            field WRR_WEIGHT_VC_2 @'h10 {
                bits 8;
                access ro;
                hard_reset 'h0;
                doc {
                    WRR Weight for VC2.

Note: The access attributes of this field are as follows:
 - Wire: R 
 - Dbi: R 
                }
            }
            field WRR_WEIGHT_VC_3 @'h18 {
                bits 8;
                access ro;
                hard_reset 'h0;
                doc {
                    WRR Weight for VC3.

Note: The access attributes of this field are as follows:
 - Wire: R 
 - Dbi: R 
                }
            }
            doc {
                VC Transmit Arbitration Register 1VC Transmit Arbitration Register 1
            }
        }
        register VC_TX_ARBI_2_OFF @'h44 {
            bytes 4;
            field WRR_WEIGHT_VC_4 @'h0 {
                bits 8;
                access ro;
                hard_reset 'h0;
                doc {
                    WRR Weight for VC4.

Note: The access attributes of this field are as follows:
 - Wire: R 
 - Dbi: R 
                }
            }
            field WRR_WEIGHT_VC_5 @'h8 {
                bits 8;
                access ro;
                hard_reset 'h0;
                doc {
                    WRR Weight for VC5.

Note: The access attributes of this field are as follows:
 - Wire: R 
 - Dbi: R 
                }
            }
            field WRR_WEIGHT_VC_6 @'h10 {
                bits 8;
                access ro;
                hard_reset 'h0;
                doc {
                    WRR Weight for VC6.

Note: The access attributes of this field are as follows:
 - Wire: R 
 - Dbi: R 
                }
            }
            field WRR_WEIGHT_VC_7 @'h18 {
                bits 8;
                access ro;
                hard_reset 'h0;
                doc {
                    WRR Weight for VC7.

Note: The access attributes of this field are as follows:
 - Wire: R 
 - Dbi: R 
                }
            }
            doc {
                VC Transmit Arbitration Register 2VC Transmit Arbitration Register 2
            }
        }
        register VC0_P_RX_Q_CTRL_OFF @'h48 {
            bytes 4;
            field VC0_P_DATA_CREDIT @'h0 {
                bits 12;
                access rw;
                hard_reset 'h0;
                doc {
                    VC0 Posted Data Credits. The number of initial posted data credits for VC0, used only in the segmented-buffer configuration.

Note: The access attributes of this field are as follows:
 - Wire: R (sticky) 
 - Dbi: R (sticky) 
Note: This register field is sticky.
                }
            }
            field VC0_P_HEADER_CREDIT @'hc {
                bits 8;
                access rw;
                hard_reset 'h0;
                doc {
                    VC0 Posted Header Credits. The number of initial posted header credits for VC0, used only in the segmented-buffer configuration.

Note: The access attributes of this field are as follows:
 - Wire: R (sticky) 
 - Dbi: R (sticky) 
Note: This register field is sticky.
                }
            }
            field RESERVED4 @'h14 {
                access rw;
                hard_reset 'h0;
                doc {
                    Reserved.

Note: This register field is sticky.
                }
            }
            field VC0_P_TLP_Q_MODE @'h15 {
                bits 3;
                access rw;
                hard_reset 'h0;
                doc {
                    Reserved.

Note: This register field is sticky.
                }
            }
            field VC0_P_HDR_SCALE @'h18 {
                bits 2;
                access rw;
                hard_reset 'h0;
                doc {
                    VC0 Scale Posted Header Credites.


Note: This register field is sticky.
                }
            }
            field VC0_P_DATA_SCALE @'h1a {
                bits 2;
                access rw;
                hard_reset 'h0;
                doc {
                    VC0 Scale Posted Data Credites.


Note: This register field is sticky.
                }
            }
            field RESERVED5 @'h1c {
                bits 2;
                access rw;
                hard_reset 'h0;
                doc {
                    Reserved.

Note: This register field is sticky.
                }
            }
            field TLP_TYPE_ORDERING_VC0 @'h1e {
                access rw;
                hard_reset 'h0;
                doc {
                    TLP Type Ordering for VC0. Determines the TLP type ordering rule for VC0 receive queues, used only in the segmented-buffer configuration:
 - 1: PCIe ordering rules (recommended)
 - 0: Strict ordering: posted, completion, then non-posted
Note: This register field is sticky.
                }
            }
            field VC_ORDERING_RX_Q @'h1f {
                access rw;
                hard_reset 'h0;
                doc {
                    VC Ordering for Receive Queues. Determines the VC ordering rule for the receive queues, used only in the segmented-buffer configuration:
 - 1: Strict ordering, higher numbered VCs have higher priority
 - 0: Round robin
Note: This register field is sticky.
                }
            }
            doc {
                Segmented-Buffer VC0 Posted Receive Queue Control.Segmented-Buffer VC0 Posted Receive Queue Control.
            }
        }
        register VC0_NP_RX_Q_CTRL_OFF @'h4c {
            bytes 4;
            field VC0_NP_DATA_CREDIT @'h0 {
                bits 12;
                access rw;
                hard_reset 'h0;
                doc {
                    VC0 Non-Posted Data Credits. The number of initial non-posted data credits for VC0, used only in the segmented-buffer configuration.

Note: The access attributes of this field are as follows:
 - Wire: R (sticky) 
 - Dbi: R (sticky) 
Note: This register field is sticky.
                }
            }
            field VC0_NP_HEADER_CREDIT @'hc {
                bits 8;
                access rw;
                hard_reset 'h0;
                doc {
                    VC0 Non-Posted Header Credits. The number of initial non-posted header credits for VC0, used only in the segmented-buffer configuration.

Note: The access attributes of this field are as follows:
 - Wire: R (sticky) 
 - Dbi: R (sticky) 
Note: This register field is sticky.
                }
            }
            field RESERVED6 @'h14 {
                access rw;
                hard_reset 'h0;
                doc {
                    Reserved.

Note: This register field is sticky.
                }
            }
            field VC0_NP_TLP_Q_MODE @'h15 {
                bits 3;
                access rw;
                hard_reset 'h0;
                doc {
                    Reserved.

Note: This register field is sticky.
                }
            }
            field VC0_NP_HDR_SCALE @'h18 {
                bits 2;
                access rw;
                hard_reset 'h0;
                doc {
                    VC0 Scale Non-Posted Header Credites.


Note: This register field is sticky.
                }
            }
            field VC0_NP_DATA_SCALE @'h1a {
                bits 2;
                access rw;
                hard_reset 'h0;
                doc {
                    VC0 Scale Non-Posted Data Credites.


Note: This register field is sticky.
                }
            }
            field RESERVED7 @'h1c {
                bits 4;
                access rw;
                hard_reset 'h0;
                doc {
                    Reserved.

Note: This register field is sticky.
                }
            }
            doc {
                Segmented-Buffer VC0 Non-Posted Receive Queue Control.Segmented-Buffer VC0 Non-Posted Receive Queue Control.
            }
        }
        register VC0_CPL_RX_Q_CTRL_OFF @'h50 {
            bytes 4;
            field VC0_CPL_DATA_CREDIT @'h0 {
                bits 12;
                access rw;
                hard_reset 'h0;
                doc {
                    VC0 Completion Data Credits. The number of initial Completion data credits for VC0, used only in the segmented-buffer configuration.

Note: The access attributes of this field are as follows:
 - Wire: R (sticky) 
 - Dbi: R (sticky) 
Note: This register field is sticky.
                }
            }
            field VC0_CPL_HEADER_CREDIT @'hc {
                bits 8;
                access rw;
                hard_reset 'h0;
                doc {
                    VC0 Completion Header Credits. The number of initial Completion header credits for VC0, used only in the segmented-buffer configuration.

Note: The access attributes of this field are as follows:
 - Wire: R (sticky) 
 - Dbi: R (sticky) 
Note: This register field is sticky.
                }
            }
            field RESERVED8 @'h14 {
                access rw;
                hard_reset 'h0;
                doc {
                    Reserved.

Note: This register field is sticky.
                }
            }
            field VC0_CPL_TLP_Q_MODE @'h15 {
                bits 3;
                access rw;
                hard_reset 'h0;
                doc {
                    Reserved.

Note: This register field is sticky.
                }
            }
            field VC0_CPL_HDR_SCALE @'h18 {
                bits 2;
                access rw;
                hard_reset 'h0;
                doc {
                    VC0 Scale CPL Header Credites.


Note: This register field is sticky.
                }
            }
            field VC0_CPL_DATA_SCALE @'h1a {
                bits 2;
                access rw;
                hard_reset 'h0;
                doc {
                    VC0 Scale CPL Data Credites.


Note: This register field is sticky.
                }
            }
            field RESERVED9 @'h1c {
                bits 4;
                access rw;
                hard_reset 'h0;
                doc {
                    Reserved.

Note: This register field is sticky.
                }
            }
            doc {
                Segmented-Buffer VC0 Completion Receive Queue Control.Segmented-Buffer VC0 Completion Receive Queue Control.
            }
        }
        register GEN2_CTRL_OFF @'h10c {
            bytes 4;
            field FAST_TRAINING_SEQ @'h0 {
                bits 8;
                access rw;
                hard_reset 'h0;
                doc {
                    Sets the Number of Fast Training Sequences (N_FTS) that the controller advertises as its N_FTS during Gen2 or Gen3 link training. This value is used to inform the link partner about the PHY's ability to recover synchronization after a low power state. The number should be provided by the PHY vendor. Do not set N_FTS to zero; doing so can cause the LTSSM to go into the recovery state when exiting from L0s.
This field is reserved (fixed to '0') for M-PCIe.

Note: The access attributes of this field are as follows:
 - Wire: R/W (sticky) 
 - Dbi: R/W (sticky) 
Note: This register field is sticky.
                }
            }
            field NUM_OF_LANES @'h8 {
                bits 5;
                access rw;
                hard_reset 'h0;
                doc {
                    Predetermined Number of Lanes. Defines the number of lanes which are connected and not bad. Used to limit the effective link width to ignore 'broken" or "unused" lanes that detect a receiver. Indicates the number of lanes to check for exit from Electrical Idle in Polling.Active and L2.Idle. It is possible that the LTSSM might detect a receiver on a bad or broken lane during the Detect Substate. However, it is also possible that such a lane might also fail to exit Electrical Idle and therefore prevent a valid link from being configured. This value is referred to as the "Predetermined Number of Lanes" in section 4.2.6.2.1 of the PCI Express Base 3.0 Specification, revision 1.0. Encoding is as follows:
 - 0x01: 1 lane
 - 0x02: 2 lanes
 - 0x03: 3 lanes
 - ..
When you have unused lanes in your system, then you must change the value in this register to reflect the number of lanes. You must also change the value in the "Link Mode Enable" field of PORT_LINK_CTRL_OFF. The value in this register is normally the same as the encoded value in PORT_LINK_CTRL_OFF. If you find that one of your used lanes is bad then you must reduce the value in this register. For more information, see "How to Tie Off Unused Lanes." For information on upsizing and downsizing the link width, see "Link Establishment."
This field is reserved (fixed to '0') for M-PCIe.

Note: The access attributes of this field are as follows:
 - Wire: R/W (sticky) 
 - Dbi: R/W (sticky) 
Note: This register field is sticky.
                }
            }
            field PRE_DET_LANE @'hd {
                bits 3;
                access rw;
                hard_reset 'h0;
                enum { LANE0 = 0, LANE1 = 1, LANE15 = 2, LANE3 = 3, LANE7 = 4 };
                doc {
                    Predetermined Lane for Auto Flip. This field defines which physical lane is connected to logical Lane0 by the flip operation performed in Detect.
This field is used to restrict the receiver detect procedure to a particular lane when the default detect and polling procedure performed on all lanes cannot be successful. A notable example of when it is useful to program this field to a value different from the default, is when a lane is asymmetrically broken, that is, it is detected in Detect LTSSM state but it cannot exit Electrical Idle in Polling LTSSM state.

Note: This field is reserved (fixed to '0') for M-PCIe.

Note: The access attributes of this field are as follows:
 - Wire: R/W (sticky) 
 - Dbi: R/W (sticky) 
Note: This register field is sticky.
                }
            }
            field AUTO_LANE_FLIP_CTRL_EN @'h10 {
                access rw;
                hard_reset 'h0;
                doc {
                    Enable Auto flipping of the lanes. You must set the CX_AUTO_LANE_FLIP_CTRL_EN configuration parameter to include the hardware for this feature in the controller. For more details, see the 'Lane Reversal' appendix in the Databook. This field is reserved (fixed to '0') for M-PCIe.

Note: The access attributes of this field are as follows:
 - Wire: R/W (sticky) 
 - Dbi: R/W (sticky) 
Note: This register field is sticky.
                }
            }
            field DIRECT_SPEED_CHANGE @'h11 {
                access rw;
                volatile 1
                hard_reset 'h0;
                doc {
                    Directed Speed Change. Writing "1" to this field instructs the LTSSM to initiate a speed change to Gen2 or Gen3 after the link is initialized at Gen1 speed.
When the speed change occurs, the controller will clear the contents of this field; and a read to this field by your software will return a "0".
To manually initiate the speed change:
 - Write to LINK_CONTROL2_LINK_STATUS2_REG . PCIE_CAP_TARGET_LINK_SPEED in the local device
 - Deassert this field
 - Assert this field
If you set the default of this field using the DEFAULT_GEN2_SPEED_CHANGE configuration parameter to "1", then the speed change is initiated automatically after link up, and the controller clears the contents of this field. If you want to prevent this automatic speed change, then write a lower speed value to the Target Link Speed field of the Link Control 2 register (LINK_CONTROL2_LINK_STATUS2_OFF . PCIE_CAP_TARGET_LINK_SPEED) through the DBI before link up.
This field is reserved (fixed to '0') for M-PCIe.

Note: The access attributes of this field are as follows:
 - Wire: R/W 
 - Dbi: R/W 
                }
            }
            field CONFIG_PHY_TX_CHANGE @'h12 {
                access rw;
                hard_reset 'h0;
                doc {
                    Config PHY Tx Swing. Controls the PHY transmitter voltage swing level. The controller drives the mac_phy_txswing output from this register bit field.
 - 0: Full Swing
 - 1: Low Swing
This field is reserved (fixed to '0') for M-PCIe.

Note: The access attributes of this field are as follows:
 - Wire: R/W (sticky) 
 - Dbi: R/W (sticky) 
Note: This register field is sticky.
                }
            }
            field CONFIG_TX_COMP_RX @'h13 {
                access rw;
                hard_reset 'h0;
                doc {
                    Config Tx Compliance Receive Bit. When set to 1, signals LTSSM to transmit TS ordered sets with the compliance receive bit assert (equal to "1").
This field is reserved (fixed to '0') for M-PCIe.

Note: The access attributes of this field are as follows:
 - Wire: R/W (sticky) 
 - Dbi: R/W (sticky) 
Note: This register field is sticky.
                }
            }
            field SEL_DEEMPHASIS @'h14 {
                access rw;
                hard_reset 'h0;
                doc {
                    Used to set the de-emphasis level for upstream ports. This bit selects the level of de-emphasis the link operates at.
 - 0: -6 dB
 - 1: -3.5 dB
This field is reserved (fixed to '0') for M-PCIe.

Note: The access attributes of this field are as follows:
 - Wire: R/W (sticky) 
 - Dbi: R/W (sticky) 
Note: This register field is sticky.
                }
            }
            field GEN1_EI_INFERENCE @'h15 {
                access rw;
                hard_reset 'h0;
                doc {
                    Electrical Idle Inference Mode at Gen1 Rate. Programmable mode to determine inferred electrical idle (EI) in Recovery.Speed or Loopback.Active (as slave) state at Gen1 speed by looking for a "1" value on RxElecIdle instead of looking for a "0" on RxValid. If the PHY fails to deassert the RxValid signal in Recovery.Speed or Loopback.Active (because of corrupted EIOS for example), then EI cannot be inferred successfully in the controller by just detecting the condition RxValid=0.
 - 0: Use RxElecIdle signal to infer Electrical Idle
 - 1: Use RxValid signal to infer Electrical Idle
Note: This register field is sticky.
                }
            }
            field RSVDP_23 @'h17 {
                bits 9;
                access ro;
                hard_reset 'h0;
                soft_reset 'h0;
                doc {
                    Reserved for future use.
                }
            }
            doc {
                This register is used to control various functions of the controller related to link training, lane reversal, and equalization.This register is used to control various functions of the controller related to link training, lane reversal, and equalization.
            }
        }
        register PHY_STATUS_OFF @'h110 {
            bytes 4;
            field PHY_STATUS @'h0 {
                bits 32;
                access ro;
                volatile 1
                hard_reset 'h0;
                doc {
                    PHY Status. Data received directly from the phy_cfg_status bus.
These is a GPIO register reflecting the values on the static phy_cfg_status input signals. The usage is left completely to the user and does not in any way influence controller functionality. You can use it for any static sideband status signalling requirements that you have for your PHY.
This field is reserved (fixed to '0') for M-PCIe.

Note: This register field is sticky.
                }
            }
            doc {
                PHY Status Register. Memory mapped register from phy_cfg_status GPIO input pins.PHY Status Register. Memory mapped register from phy_cfg_status GPIO input pins.
            }
        }
        register PHY_CONTROL_OFF @'h114 {
            bytes 4;
            field PHY_CONTROL @'h0 {
                bits 32;
                access rw;
                hard_reset 'h0;
                doc {
                    PHY Control. Data sent directly to the cfg_phy_control bus.
These is a GPIO register driving the values on the static cfg_phy_control output signals. The usage is left completely to the user and does not in any way influence controller functionality. You can use it for any static sideband control signalling requirements that you have for your PHY.
This field is reserved (fixed to '0') for M-PCIe.

Note: This register field is sticky.
                }
            }
            doc {
                PHY Control Register. Memory mapped register to cfg_phy_control GPIO output pins.PHY Control Register. Memory mapped register to cfg_phy_control GPIO output pins.
            }
        }
        register TRGT_MAP_CTRL_OFF @'h11c {
            bytes 4;
            field TARGET_MAP_PF @'h0 {
                bits 6;
                access rw;
                volatile 1
                hard_reset 'h0;
                doc {
                    Target Values for each BAR on the PF Function selected by the index number. This register does not respect the Byte Enable setting. any write will affect all register bits.
                }
            }
            field TARGET_MAP_ROM @'h6 {
                access rw;
                volatile 1
                hard_reset 'h0;
                doc {
                    Target Value for the ROM page of the PF Function selected by the index number. This register does not respect the Byte Enable setting. any write will affect all register bits.
                }
            }
            field TARGET_MAP_RESERVED_13_15 @'hd {
                bits 3;
                access ro;
                hard_reset 'h0;
                doc {
                    Reserved.

Note: The access attributes of this field are as follows:
 - Wire: RSVDP 
 - Dbi: R (sticky) 
                }
            }
            field TARGET_MAP_INDEX @'h10 {
                bits 5;
                access rw;
                volatile 1
                hard_reset 'h0;
                doc {
                    The number of the PF Function on which the Target Values are set. This register does not respect the Byte Enable setting. any write will affect all register bits.
                }
            }
            field TARGET_MAP_RESERVED_21_31 @'h15 {
                bits 11;
                access ro;
                hard_reset 'h0;
                doc {
                    Reserved.

Note: The access attributes of this field are as follows:
 - Wire: RSVDP 
 - Dbi: R (sticky) 
                }
            }
            doc {
                Programmable Target Map Control Register.Programmable Target Map Control Register.
            }
        }
        register CLOCK_GATING_CTRL_OFF @'h18c {
            bytes 4;
            field RADM_CLK_GATING_EN @'h0 {
                access rw;
                hard_reset 'h0;
                doc {
                    RADM Clock Gating Enable. 

This register, if set, enables the RADM to autonomously enable and disable its clock. The DWC_pcie_clk_rst.v module provides the gated clock, radm_clk_g, to the RADM and is enabled when the controllers clock enable signal, en_radm_clk_g, is asserted. The RADM clock is a gated version of the core clock, core_clk. The controller de-asserts en_radm_clk_g when there is no Rx traffic, Rx queues and pre/post-queue pipelines are empty, RADM completion LUT is empty, and there are no FLR actions pending.
 - 0: Disable
 - 1: Enable (default)
Note: This register field is sticky.
                }
            }
            field AXI_CLK_GATING_EN @'h1 {
                access rw;
                hard_reset 'h0;
                doc {
                    AXI Clock Gating Enable. 

This register enables the AXI Bridge to autonomously enable and disable the AXI Master clock, the AXI Slave clock and the AXI DBI slave clock. The DWC_pcie_clk_rst.v module provides the gated clock, mstr_axi_aclk_gated, to the AXI Bridge and is enabled when the controllers clock enable signal, mstr_aclk_active, is asserted. For the AXI Slave this module provides the gated clock, slv_axi_aclk_gated, to the AXI Bridge and is enabled when the controllers clock enable signal, slv_aclk_active, is asserted. If the AXI DBI Slave is enabled (DBI_4SLAVE_POPULATED=1) the module provides the gated clock, dbi_axi_aclk_gated, to the AXI Bridge and is enabled when the controllers clock enable signal, dbi_aclk_active, is asserted. The controller de-asserts the clock enable signals when the respective AXI Master/Slave interfaces are idle.
 - 0: Disable
 - 1: Enable (default)
Note: This register field is sticky.
                }
            }
            field RSVDP_2 @'h2 {
                bits 30;
                access ro;
                hard_reset 'h0;
                soft_reset 'h0;
                doc {
                    Reserved for future use.
                }
            }
            doc {
                This register enables you to disable dynamic clock gating. By default dynamic clock gating is on, allowing the controller to autonomously enable and disable its clocks. The clock gating is performed in the clock and reset module, DWC_pcie_clk_rst.v, and is initiated by the controllers clock enable signals. The following modules support dynamic clock gating:
 - AXI Bridge
 - RADMThis register enables you to disable dynamic clock gating. By default dynamic clock gating is on, allowing the controller to autonomously enable and disable its clocks. The clock gating is performed in the clock and reset module, DWC_pcie_clk_rst.v, and is initiated by the controllers clock enable signals. The following modules support dynamic clock gating:
 - AXI Bridge
 - RADM
            }
        }
        register GEN3_RELATED_OFF @'h190 {
            bytes 4;
            field GEN3_ZRXDC_NONCOMPL @'h0 {
                access rw;
                hard_reset 'h0;
                doc {
                    Gen3 Receiver Impedance ZRX-DC Not Compliant. Receivers that operate at 8.0 GT/s with an impedance other than the range defined by the ZRX-DC parameter for 2.5 GT/s (40-60 Ohms) must meet additional behavior requirements in the following LTSSM states: Polling, Rx_L0s, L1, L2, and Disabled.
 - 0: The receiver complies with the ZRX-DC parameter for 2.5 GT/s when operating at 8 GT/s or higher.
 - 1: The receiver does not comply with the ZRX-DC parameter for 2.5 GT/s when operating at 8 GT/s or higher.
Note: When CX_GEN4_SPEED/CX_GEN5_SPEED, this register is shared for Gen3 and Gen4/Gen5 data rates.

Note: This register field is sticky.
                }
            }
            field RSVDP_1 @'h1 {
                bits 7;
                access ro;
                hard_reset 'h0;
                soft_reset 'h0;
                doc {
                    Reserved for future use.
                }
            }
            field DISABLE_SCRAMBLER_GEN_3 @'h8 {
                access rw;
                hard_reset 'h0;
                doc {
                    Disable Scrambler for Gen3 and Gen4 Data Rate. The Gen3 and Gen4 scrambler/descrambler within the controller needs to be disabled when the scrambling function is implemented outside of the controller (for example within the PHY).

Note: When CX_GEN4_SPEED/CX_GEN5_SPEED, this register is shared for Gen3 and Gen4/Gen5 data rate.

Note: This register field is sticky.
                }
            }
            field EQ_PHASE_2_3 @'h9 {
                access rw;
                hard_reset 'h0;
                doc {
                    Equalization Phase 2 and Phase 3 Disable. This applies to downstream ports only.

Note: When CX_GEN4_SPEED/CX_GEN5_SPEED, this register is shadow register for Gen3 and Gen4/Gen5 data rate. If RATE_SHADOW_SEL==00b, this register is for Gen3 data rate. If RATE_SHADOW_SEL==01b, this register is for Gen4 data rate. If RATE_SHADOW_SEL==10b, this register is for Gen5 data rate.

Note: The access attributes of this field are as follows:
 - Wire: see description 
 - Dbi: see description 
Note: This register field is sticky.
                }
            }
            field EQ_EIEOS_CNT @'ha {
                access rw;
                hard_reset 'h0;
                doc {
                    Equalization EIEOS Count Reset Disable. Disable requesting reset of EIEOS count during equalization.

Note: When CX_GEN4_SPEED/CX_GEN5_SPEED, this register is shared for Gen3 and Gen4/Gen5 data rate.

Note: This register field is sticky.
                }
            }
            field EQ_REDO @'hb {
                access rw;
                hard_reset 'h0;
                doc {
                    Equalization Redo Disable. Disable autonomous mechanism for requesting to redo the equalization process.

Note: When CX_GEN4_SPEED/CX_GEN5_SPEED, this register is shared for Gen3 and Gen4/Gen5 data rate.

Note: This register field is sticky.
                }
            }
            field RXEQ_PH01_EN @'hc {
                access rw;
                hard_reset 'h0;
                doc {
                    Rx Equalization Phase 0/Phase 1 Hold Enable. When this bit is set the upstream port holds phase 0 (the downstream port holds phase 1) for 10ms. Holding phase 0 or phase 1 can be used to allow sufficient time for Rx Equalization to be performed by the PHY. This bit is used during Virtex-7 Gen3 equalization. The programmable bits [RXEQ_PH01_EN, EQ_PHASE_2_3] can be used to obtain the following variations of the equalization procedure:
 - 00: Tx equalization only in phase 2/3
 - 01: No Tx equalization, no Rx equalization
 - 10: Tx equalization in phase 2/3, Rx equalization in phase 0/1
 - 11: No Tx equalization, Rx equalization in phase 0/1
Note: When CX_GEN4_SPEED/CX_GEN5_SPEED, this register is shadow register for Gen3 and Gen4/Gen5 data rate. If RATE_SHADOW_SEL==00b, this register is for Gen3 data rate. If RATE_SHADOW_SEL==01b, this register is for Gen4 data rate. If RATE_SHADOW_SEL==10b, this register is for Gen5 data rate.

Note: The access attributes of this field are as follows:
 - Wire: see description 
 - Dbi: see description 
Note: This register field is sticky.
                }
            }
            field RXEQ_RGRDLESS_RXTS @'hd {
                access rw;
                hard_reset 'h0;
                doc {
                    When set to '1', the controller as Gen3 EQ master asserts RxEqEval to instruct the PHY to do Rx adaptation and evaluation after a 500ns timeout from a new preset request.
 - 0: mac_phy_rxeqeval asserts after 1us and 2 TS1 received from remote partner.
 - 1: mac_phy_rxeqeval asserts after 500ns regardless of TS's received or not.
Note: When CX_GEN4_SPEED/CX_GEN5_SPEED, this register is shadow register for Gen3 and Gen4/Gen5 data rate. If RATE_SHADOW_SEL==00b, this register is for Gen3 data rate. If RATE_SHADOW_SEL==01b, this register is for Gen4 data rate. If RATE_SHADOW_SEL==10b, this register is for Gen5 data rate.

Note: The access attributes of this field are as follows:
 - Wire: see description 
 - Dbi: see description 
Note: This register field is sticky.
                }
            }
            field RSVDP_14 @'he {
                bits 2;
                access ro;
                hard_reset 'h0;
                soft_reset 'h0;
                doc {
                    Reserved for future use.
                }
            }
            field GEN3_EQUALIZATION_DISABLE @'h10 {
                access rw;
                hard_reset 'h0;
                doc {
                    Equalization Disable. Disable equalization feature. This bit cannot be changed once the LTSSM starts link training.

Note: When CX_GEN4_SPEED/CX_GEN5_SPEED, this register is shared for Gen3 and Gen4/Gen5 data rate.

Note: This register field is sticky.
                }
            }
            field GEN3_DLLP_XMT_DELAY_DISABLE @'h11 {
                access rw;
                hard_reset 'h0;
                doc {
                    DLLP Transmission Delay Disable. Disable delay transmission of DLLPs before equalization.

Note: When CX_GEN4_SPEED/CX_GEN5_SPEED, this register is shared for Gen3 and Gen4/Gen5 data rate.

Note: This register field is sticky.
                }
            }
            field GEN3_DC_BALANCE_DISABLE @'h12 {
                access rw;
                hard_reset 'h0;
                doc {
                    DC Balance Disable. Disable DC Balance feature.

Note: When CX_GEN4_SPEED/CX_GEN5_SPEED, this register is shared for Gen3 and Gen4/Gen5 data rate.

Note: This register field is sticky.
                }
            }
            field RSVDP_19 @'h13 {
                bits 2;
                access ro;
                hard_reset 'h0;
                soft_reset 'h0;
                doc {
                    Reserved for future use.
                }
            }
            field AUTO_EQ_DISABLE @'h15 {
                access rw;
                volatile 1
                hard_reset 'h0;
                doc {
                    Autonomous Equalization Disable. When the controller is in L0 state at Gen3 data rate and equalization was completed successfully in Autonomous EQ Mechanism, setting this bit in DSP will not direct the controller to Recovery state to perform Gen4 equalization. Link stays in Gen3 rate and DSP sends DLLPs to USP. If the bit is 0, DSP will block DLLPs and direct the link to perform Gen4 EQ in Autonomous Mechanism.

Note: When CX_GEN4_SPEED/CX_GEN5_SPEED, this register is shadow register for Gen3 and Gen4/Gen5 data rate. If RATE_SHADOW_SEL==00b, this register is RSVD. If RATE_SHADOW_SEL==01b, this register is for Gen4 data rate. If RATE_SHADOW_SEL==10b, this register is for Gen5 data rate.

Note: The access attributes of this field are as follows:
 - Wire: see description 
 - Dbi: see description 
Note: This register field is sticky.
                }
            }
            field USP_SEND_8GT_EQ_TS2_DISABLE @'h16 {
                access rw;
                volatile 1
                hard_reset 'h0;
                doc {
                    Upstream Port Send 8GT/s or 16GT/s EQ TS2 Disable. The base spec defines that USP can optionally send 8GT or 16GT EQ TS2 and it means USP can set DSP TxPreset value in Gen4 or Gen5 Data Rate. If this register set to 0, USP sends 8GT or 16GT EQ TS2. If this register set to 1, USP does not send 8GT or 16GT EQ TS2. This applies to upstream ports only. No Function for downstream ports.

Note: When CX_GEN4_SPEED/CX_GEN5_SPEED, this register is shadow register for Gen3 and Gen4/Gen5 data rate. If RATE_SHADOW_SEL==00b, this register is RSVD. If RATE_SHADOW_SEL==01b, this register is for Gen4 data rate. If RATE_SHADOW_SEL==10b, this register is for Gen5 data rate. 
Value after reset in Gen4/Gen5 is 0x1.

Note: The access attributes of this field are as follows:
 - Wire: see description 
 - Dbi: see description 
Note: This register field is sticky.
                }
            }
            field GEN3_EQ_INVREQ_EVAL_DIFF_DISABLE @'h17 {
                access rw;
                hard_reset 'h0;
                doc {
                    Eq InvalidRequest and RxEqEval Different Time Assertion Disable. Disable the assertion of Eq InvalidRequest and RxEqEval at different time.

Note: When CX_GEN4_SPEED/CX_GEN5_SPEED, this register is shared for Gen3 and Gen4/Gen5 data rate.

Note: This register field is sticky.
                }
            }
            field RATE_SHADOW_SEL @'h18 {
                bits 2;
                access rw;
                hard_reset 'h0;
                doc {
                    Rate Shadow Select. This register value decide the Data Rate of shadow register.
 - 00b: Gen3 Data Rate is selected for shadow register.
 - 01b: Gen4 Data Rate is selected for shadow register.
 - 10b: Gen5 Data Rate is selected for shadow register.
 - 11b: Reserved.
The following shadow registers are controlled by this register.
 - GEN3_RELATED_OFF[9] EQ_PHASE_2_3
 - GEN3_RELATED_OFF[12] RXEQ_PH01_EN
 - GEN3_RELATED_OFF[19] RE_EQ_REQUEST_ENABLE
 - GEN3_RELATED_OFF[21] AUTO_EQ_DISABLE
 - GEN3_RELATED_OFF[22] USP_SEND_8GT_EQ_TS2_DISABLE
 - GEN3_EQ_LOCAL_FS_LF_OFF[5:0] GEN3_EQ_LOCAL_LF
 - GEN3_EQ_LOCAL_FS_LF_OFF[11:6] GEN3_EQ_LOCAL_FS
 - GEN3_EQ_PSET_COEFF_MAP_0[5:0] GEN3_EQ_PRE_CURSOR_PSET
 - GEN3_EQ_PSET_COEFF_MAP_0[11:6] GEN3_EQ_CURSOR_PSET
 - GEN3_EQ_PSET_COEFF_MAP_0[17:12] GEN3_EQ_POSET_CURSOR_PSET
 - GEN3_EQ_CONTROL_OFF[3:0] GEN3_EQ_FB_MODE
 - GEN3_EQ_CONTROL_OFF[4] GEN3_EQ_PHASE23_EXIT_MODE
 - GEN3_EQ_CONTROL_OFF[5] GEN3_EQ_EVAL_2MS_DISABLE
 - GEN3_EQ_CONTROL_OFF[23:8] GEN3_EQ_PSET_REQ_VEC
 - GEN3_EQ_CONTROL_OFF[24] GEN3_EQ_FOM_INC_INITIAL_EVAL
 - GEN3_EQ_CONTROL_OFF[25] GEN3_EQ_PSET_REQ_AS_COEF
 - GEN3_EQ_FB_MODE_DIR_CHANGE_OFF[4:0] GEN3_EQ_FMDC_T_MIN_PHASE23
 - GEN3_EQ_FB_MODE_DIR_CHANGE_OFF[9:5] GEN3_EQ_FMDC_N_EVALS
 - GEN3_EQ_FB_MODE_DIR_CHANGE_OFF[13:10] GEN3_EQ_FMDC_MAX_PRE_CUSROR_DELTA
 - GEN3_EQ_FB_MODE_DIR_CHANGE_OFF[17:14] GEN3_EQ_FMDC_MAX_POST_CUSROR_DELTA
Note: This register field is sticky.
                }
            }
            field RSVDP_26 @'h1a {
                bits 6;
                access ro;
                hard_reset 'h0;
                soft_reset 'h0;
                doc {
                    Reserved for future use.
                }
            }
            doc {
                Gen3 Control Register. There is no Gen3-specific N_FTS field. The N_FTS field in the "Link Width and Speed Change Control Register" is used for both Gen2 and Gen3 speed modes. There is no Gen3-specific "Directed Speed Change" field. The "Directed Speed Change" field in the "Link Width and Speed Change Control Register" is used to change to Gen2 or Gen3 speed. A speed change to Gen3 occurs if (1) the "Directed Speed Change" field is set to "1" and (2) the "Target Link Speed" field in the Link Control 2 Register is set to Gen3. Gen3 support is advertised by both sides of the link during link training.
M-PCIe doesn't have Conventional PCIe Gen3 feature. The registers of this section do not exist.Gen3 Control Register. There is no Gen3-specific N_FTS field. The N_FTS field in the "Link Width and Speed Change Control Register" is used for both Gen2 and Gen3 speed modes. There is no Gen3-specific "Directed Speed Change" field. The "Directed Speed Change" field in the "Link Width and Speed Change Control Register" is used to change to Gen2 or Gen3 speed. A speed change to Gen3 occurs if (1) the "Directed Speed Change" field is set to "1" and (2) the "Target Link Speed" field in the Link Control 2 Register is set to Gen3. Gen3 support is advertised by both sides of the link during link training.
M-PCIe doesn't have Conventional PCIe Gen3 feature. The registers of this section do not exist.
            }
        }
        register GEN3_EQ_CONTROL_OFF @'h1a8 {
            bytes 4;
            field GEN3_EQ_FB_MODE @'h0 {
                bits 4;
                access rw;
                volatile 1
                hard_reset 'h0;
                doc {
                    Feedback Mode.
 - 0000b: Direction Change
 - 0001b: Figure Of Merit
 - 0010b: Reserved
 - .....: Reserved
 - 1111b: Reserved
Note: When CX_GEN4_SPEED/CX_GEN5_SPEED, this register is a shadow register for Gen3 and Gen4/Gen5 data rate. If RATE_SHADOW_SEL==00b, this register is for Gen3 data rate. If RATE_SHADOW_SEL==01b, this register is for Gen4 data rate. If RATE_SHADOW_SEL==10b, this register is for Gen5 data rate.

Note: This register field is sticky.
                }
            }
            field GEN3_EQ_PHASE23_EXIT_MODE @'h4 {
                access rw;
                volatile 1
                hard_reset 'h0;
                doc {
                    Behavior After 24 ms Timeout (when optimal settings are not found). 
 For a USP: Determine next LTSSM state from Phase2 after 24ms Timeout
 - 0: Recovery.Speed
 - 1: Recovery.Equalization.Phase3
When optimal settings are not found then:
 - Equalization Phase 2 Successful status bit is not set in the "Link Status Register 2" when GEN3_EQ_PHASE23_EXIT_MODE = 0
 - Equalization Phase 2 Successful status bit is set in the "Link Status Register 2" when GEN3_EQ_PHASE23_EXIT_MODE = 1
 - Equalization Phase 2 Complete status bit is set in the "Link Status Register 2"
For a DSP: Determine next LTSSM state from Phase3 after 24ms Timeout
 - 0: Recovery.Speed
 - 1: Recovery.Equalization.RcvrLock
When optimal settings are not found then:
 - Equalization Phase 3 Successful status bit is not set in the "Link Status Register 2" when GEN3_EQ_PHASE23_EXIT_MODE = 0
 - Equalization Phase 3 Successful status bit is set in the "Link Status Register 2" when GEN3_EQ_PHASE23_EXIT_MODE = 1
 - Equalization Phase 3 Complete status bit is set in the "Link Status Register 2"
Note: GEN3_EQ_PHASE23_EXIT_MODE = 1 affects Direction Change feed back mode. EQ requests for Figure Of Merit mode complete before 24 ms timeout. Please see GEN3_EQ_PSET_REQ_VEC Register for more.
Note: When CX_GEN4_SPEED/CX_GEN5_SPEED, this register is shadow register for Gen3 and Gen4/Gen5 data rate. If RATE_SHADOW_SEL==00b, this register is for Gen3 data rate. If RATE_SHADOW_SEL==01b, this register is for Gen4 data rate. If RATE_SHADOW_SEL==10b, this register is for Gen5 data rate.

Note: This register field is sticky.
                }
            }
            field GEN3_EQ_EVAL_2MS_DISABLE @'h5 {
                access rw;
                volatile 1
                hard_reset 'h0;
                doc {
                    Phase2_3 2 ms Timeout Disable. Determine behavior in Phase2 for USP (Phase3 if DSP) when the PHY does not respond within 2ms to the assertion of RxEqEval:
 - 0: abort the current evaluation, stop any attempt to modify the remote transmitter settings, Phase2 is terminated by the 24ms timeout
 - 1: ignore the 2ms timeout and continue as normal. This is used to support PHYs that require more than 2ms to respond to the assertion of RxEqEval.
Note: When CX_GEN4_SPEED/CX_GEN5_SPEED, this register is shadow register for Gen3 and Gen4/Gen5 data rate. If RATE_SHADOW_SEL==00b, this register is for Gen3 data rate. If RATE_SHADOW_SEL==01b, this register is for Gen4 data rate. If RATE_SHADOW_SEL==10b, this register is for Gen5 data rate.

Note: This register field is sticky.
                }
            }
            field GEN3_LOWER_RATE_EQ_REDO_ENABLE @'h6 {
                access rw;
                volatile 1
                hard_reset 'h0;
                doc {
                    Support EQ redo and lower rate change:
 - 0: not support
 - 1: support
Note: Gen3 and Gen4 share the same register bit and have the same feature.

Note: This register field is sticky.
                }
            }
            field RSVDP_7 @'h7 {
                access ro;
                hard_reset 'h0;
                soft_reset 'h0;
                doc {
                    Reserved for future use.
                }
            }
            field GEN3_EQ_PSET_REQ_VEC @'h8 {
                bits 16;
                access rw;
                volatile 1
                hard_reset 'h0;
                doc {
                    Preset Request Vector. Requesting of Presets during the initial part of the EQ Master Phase. Encoding scheme is as follows:

 Bit [15:0] =0x0: No preset is requested and evaluated in EQ Master Phase.

 Bit [i] =1: "Preset=i" is requested and evaluated in EQ Master Phase.
 - 0000000000000000: No preset be requested and evaluated in EQ Master Phase
 - 000000xxxxxxxxx1: Preset 0 is requested and evaluated in EQ Master Phase
 - 000000xxxxxxxx1x: Preset 1 is requested and evaluated in EQ Master Phase
 - 000000xxxxxxx1xx: Preset 2 is requested and evaluated in EQ Master Phase
 - 000000xxxxxx1xxx: Preset 3 is requested and evaluated in EQ Master Phase
 - 000000xxxxx1xxxx: Preset 4 is requested and evaluated in EQ Master Phase
 - 000000xxxx1xxxxx: Preset 5 is requested and evaluated in EQ Master Phase
 - 000000xxx1xxxxxx: Preset 6 is requested and evaluated in EQ Master Phase
 - 000000xx1xxxxxxx: Preset 7 is requested and evaluated in EQ Master Phase
 - 000000x1xxxxxxxx: Preset 8 is requested and evaluated in EQ Master Phase
 - 00000x1xxxxxxxxx: Preset 9 is requested and evaluated in EQ Master Phase
 - 000001xxxxxxxxxx: Preset 10 is requested and evaluated in EQ Master Phase
 - All other encodings: Reserved
Note: You must contact your PHY vendor to ensure 24 ms timeout does not occur in presets requests in EQ master phase, i.e., you must set a proper value to the GEN3_EQ_PSET_REQ_VEC register so that the EQ tunning for Figure of Merit in the EQ master phase completes before 24 ms timeout.
Note: When CX_GEN4_SPEED/CX_GEN5_SPEED, this register is shadow register for Gen3 and Gen4/Gen5 data rate. If RATE_SHADOW_SEL==00b, this register is for Gen3 data rate. If RATE_SHADOW_SEL==01b, this register is for Gen4 data rate. If RATE_SHADOW_SEL==10b, this register is for Gen5 data rate.

Note: This register field is sticky.
                }
            }
            field GEN3_EQ_FOM_INC_INITIAL_EVAL @'h18 {
                access rw;
                volatile 1
                hard_reset 'h0;
                doc {
                    Include Initial FOM. Include or not the FOM feedback from the initial preset evaluation performed in the EQ Master, when finding the highest FOM among all preset evaluations.
 - 0: Do not include
 - 1: Include
Note: When CX_GEN4_SPEED/CX_GEN5_SPEED, this register is shadow register for Gen3 and Gen4/Gen5 data rate. If RATE_SHADOW_SEL==00b, this register is for Gen3 data rate. If RATE_SHADOW_SEL==01b, this register is for Gen4 data rate. If RATE_SHADOW_SEL==10b, this register is for Gen5 data rate.

Note: This register field is sticky.
                }
            }
            field GEN3_EQ_PSET_REQ_AS_COEF @'h19 {
                access rw;
                volatile 1
                hard_reset 'h0;
                doc {
                    GEN3_EQ_PSET_REQ_AS_COEF is an internally reserved field. Do not use.

Note: This register field is sticky.
                }
            }
            field GEN3_REQ_SEND_CONSEC_EIEOS_FOR_PSET_MAP @'h1a {
                access rw;
                volatile 1
                hard_reset 'h0;
                doc {
                    Request controller to send back-to-back EIEOS in Recovery.RcvrLock state until presets to coefficients mapping is complete.
 - 0: Do not request
 - 1: request
Note: Gen3 and Gen4 share the same register bit and have the same feature.

Note: This register field is sticky.
                }
            }
            field RSVDP_27 @'h1b {
                bits 5;
                access ro;
                hard_reset 'h0;
                soft_reset 'h0;
                doc {
                    Reserved for future use.
                }
            }
            doc {
                Gen3 EQ Control Register. This register controls equalization for Phase2 in an upstream port (USP), or Phase3 in a downstream port (DSP).
M-PCIe doesn't have Conventional PCIe Gen3 feature. The registers of this section do not exist.Gen3 EQ Control Register. This register controls equalization for Phase2 in an upstream port (USP), or Phase3 in a downstream port (DSP).
M-PCIe doesn't have Conventional PCIe Gen3 feature. The registers of this section do not exist.
            }
        }
        register GEN3_EQ_FB_MODE_DIR_CHANGE_OFF @'h1ac {
            bytes 4;
            field GEN3_EQ_FMDC_T_MIN_PHASE23 @'h0 {
                bits 5;
                access rw;
                hard_reset 'h0;
                doc {
                    Minimum Time (in ms) To Remain in EQ Master Phase. The LTSSM stays in EQ Master phase for at least this amount of time, before starting to check for convergence of the coefficients.
Allowed values 0,1,...,24.

Note: When CX_GEN4_SPEED/CX_GEN5_SPEED, this register is shadow register for Gen3 and Gen4/Gen5 data rate. If RATE_SHADOW_SEL==00b, this register is for Gen3 data rate. If RATE_SHADOW_SEL==01b, this register is for Gen4 data rate. If RATE_SHADOW_SEL==10b, this register is for Gen5 data rate.

Note: This register field is sticky.
                }
            }
            field GEN3_EQ_FMDC_N_EVALS @'h5 {
                bits 5;
                access rw;
                hard_reset 'h0;
                doc {
                    Convergence Window Depth. Number of consecutive evaluations considered in Phase 2/3 when determining if optimal coefficients have been found.
Allowed range: 0,1,2,..16 up to a maximum of CX_GEN3_EQ_COEFQ_DEPTH.

When set to 0, EQ Master is performed without sending any requests to the remote partner in Phase 2 for USP and Phase 3 for DSP. Therefore, the remote partner will not change its transmitter coefficients and will move to the next state.

Note: When CX_GEN4_SPEED/CX_GEN5_SPEED, this register is shadow register for Gen3 and Gen4/Gen5 data rate. If RATE_SHADOW_SEL==00b, this register is for Gen3 data rate. If RATE_SHADOW_SEL==01b, this register is for Gen4 data rate. If RATE_SHADOW_SEL==10b, this register is for Gen5 data rate.

Note: This register field is sticky.
                }
            }
            field GEN3_EQ_FMDC_MAX_PRE_CUSROR_DELTA @'ha {
                bits 4;
                access rw;
                hard_reset 'h0;
                doc {
                    Convergence Window Aperture for C-1. Pre-cursor coefficients maximum delta within the convergence window depth.
Allowed range: 0,1,2,..15.

Note: When CX_GEN4_SPEED/CX_GEN5_SPEED, this register is shadow register for Gen3 and Gen4/Gen5 data rate. If RATE_SHADOW_SEL==00b, this register is for Gen3 data rate. If RATE_SHADOW_SEL==01b, this register is for Gen4 data rate. If RATE_SHADOW_SEL==10b, this register is for Gen5 data rate.

Note: This register field is sticky.
                }
            }
            field GEN3_EQ_FMDC_MAX_POST_CUSROR_DELTA @'he {
                bits 4;
                access rw;
                hard_reset 'h0;
                doc {
                    Convergence Window Aperture for C+1. Post-cursor coefficients maximum delta within the convergence window depth. Allowed range: 0,1,2,..15.

Note: When CX_GEN4_SPEED/CX_GEN5_SPEED, this register is shadow register for Gen3 and Gen4/Gen5 data rate. If RATE_SHADOW_SEL==00b, this register is for Gen3 data rate. If RATE_SHADOW_SEL==01b, this register is for Gen4 data rate. If RATE_SHADOW_SEL==10b, this register is for Gen5 data rate.

Note: This register field is sticky.
                }
            }
            field RSVDP_18 @'h12 {
                bits 14;
                access ro;
                hard_reset 'h0;
                soft_reset 'h0;
                doc {
                    Reserved for future use.
                }
            }
            doc {
                Gen3 EQ Direction Change Feedback Mode Control Register. Equalization controls to be used in Phase2 (USP) or Phase 3 (DSP), when you set the Feedback Mode in "Gen3 EQ Control Register" to "Direction Change." These fields allow control over the initial starting point for the search of optimal coefficient settings, and allow control over the criteria used to determine when the optimal settings have been achieved. The values are applied to all the lanes.Gen3 EQ Direction Change Feedback Mode Control Register. Equalization controls to be used in Phase2 (USP) or Phase 3 (DSP), when you set the Feedback Mode in "Gen3 EQ Control Register" to "Direction Change." These fields allow control over the initial starting point for the search of optimal coefficient settings, and allow control over the criteria used to determine when the optimal settings have been achieved. The values are applied to all the lanes.
            }
        }
        register ORDER_RULE_CTRL_OFF @'h1b4 {
            bytes 4;
            field NP_PASS_P @'h0 {
                bits 8;
                access rw;
                hard_reset 'h0;
                doc {
                    Non-Posted Passing Posted Ordering Rule Control.

 Determines if NP can pass halted P queue.
 - 0 : NP can not pass P (recommended).
 - 1 : NP can pass P
                }
            }
            field CPL_PASS_P @'h8 {
                bits 8;
                access rw;
                hard_reset 'h0;
                doc {
                    Completion Passing Posted Ordering Rule Control.

 Determines if CPL can pass halted P queue.
 - 0: CPL can not pass P (recommended)
 - 1: CPL can pass P
                }
            }
            field RSVDP_16 @'h10 {
                bits 16;
                access ro;
                hard_reset 'h0;
                soft_reset 'h0;
                doc {
                    Reserved for future use.
                }
            }
            doc {
                Order Rule Control Register.Order Rule Control Register.
            }
        }
        register PIPE_LOOPBACK_CONTROL_OFF @'h1b8 {
            bytes 4;
            field LPBK_RXVALID @'h0 {
                bits 16;
                access rw;
                hard_reset 'h0;
                doc {
                    LPBK_RXVALID is an internally reserved field. Do not use.

Note: This register field is sticky.
                }
            }
            field RXSTATUS_LANE @'h10 {
                bits 6;
                access rw;
                hard_reset 'h0;
                doc {
                    RXSTATUS_LANE is an internally reserved field. Do not use.

Note: This register field is sticky.
                }
            }
            field RSVDP_22 @'h16 {
                bits 2;
                access ro;
                hard_reset 'h0;
                soft_reset 'h0;
                doc {
                    Reserved for future use.
                }
            }
            field RXSTATUS_VALUE @'h18 {
                bits 3;
                access wo;
                volatile 1
                hard_reset 'h0;
                doc {
                    RXSTATUS_VALUE is an internally reserved field. Do not use.
                }
            }
            field RSVDP_27 @'h1b {
                bits 4;
                access ro;
                hard_reset 'h0;
                soft_reset 'h0;
                doc {
                    Reserved for future use.
                }
            }
            field PIPE_LOOPBACK @'h1f {
                access rw;
                hard_reset 'h0;
                doc {
                    PIPE Loopback Enable. Indicates RMMI Loopback if M-PCIe.

Note: This register field is sticky.
                }
            }
            doc {
                PIPE Loopback Control Register.PIPE Loopback Control Register.
            }
        }
        register MISC_CONTROL_1_OFF @'h1bc {
            bytes 4;
            field DBI_RO_WR_EN @'h0 {
                access rw;
                volatile 1
                hard_reset 'h0;
                doc {
                    Write to RO Registers Using DBI. When you set this field to "1", then some RO and HwInit bits are writable from the local application through the DBI.
For more details, see "Writing to Read-Only Registers."

Note: This register field is sticky.
                }
            }
            field DEFAULT_TARGET @'h1 {
                access rw;
                hard_reset 'h0;
                doc {
                    Default target a received IO or MEM request with UR/CA/CRS is sent to by the controller.
 - 0: The controller drops all incoming I/O or MEM requests (after corresponding error reporting). A completion with UR status will be generated for non-posted requests.
 - 1: The controller forwards all incoming I/O or MEM requests with UR/CA/CRS status to your application
For more details, see "ECRC Handling" and "Request TLP Routing Rules" in
"Receive Routing" section of the "Controller Operations" chapter of the Databook.

Default value is DEFAULT_TARGET configuration parameter.

Note: This register field is sticky.
                }
            }
            field UR_CA_MASK_4_TRGT1 @'h2 {
                access rw;
                hard_reset 'h0;
                doc {
                    This field only applies to request TLPs (with UR filtering status) that you have chosen to forward to the application (when you set DEFAULT_TARGET in this register).
 - When you set this field to '1', the core suppresses error logging, Error Message generation, and CPL generation (for non-posted requests).
 - For more details, refer to the "Advanced Error Handling For Received TLPs" chapter of the Databook. You should set this if you have set the Default Target port logic register to '1'.
Default is CX_MASK_UR_CA_4_TRGT1  configuration parameter.

Note: This register field is sticky.
                }
            }
            field SIMPLIFIED_REPLAY_TIMER @'h3 {
                access rw;
                hard_reset 'h0;
                doc {
                    Enables Simplified Replay Timer (Gen4). For more details, see "Transmit Replay" in the Controller Operations chapter of the Databook.
Simplified Replay Timer Values are:
 - A value from 24,000 to 31,000 Symbol Times when Extended Synch is 0b.
 - A value from 80,000 to 100,000 Symbol Times when Extended Synch is 1b.
Must not be changed while link is in use.

Note: This register field is sticky.
                }
            }
            field ARI_DEVICE_NUMBER @'h5 {
                access rw;
                hard_reset 'h0;
                doc {
                    When ARI is enabled, this field enables use of the device ID.


Note: This register field is sticky.
                }
            }
            field CPLQ_MNG_EN @'h6 {
                access rw;
                hard_reset 'h0;
                doc {
                    This field enables the Completion Queue Management feature.
Default value is 1.

Note: This register field is sticky.
                }
            }
            field RSVDP_7 @'h7 {
                bits 25;
                access ro;
                hard_reset 'h0;
                soft_reset 'h0;
                doc {
                    Reserved for future use.
                }
            }
            doc {
                DBI Read-Only Write Enable Register.DBI Read-Only Write Enable Register.
            }
        }
        register MULTI_LANE_CONTROL_OFF @'h1c0 {
            bytes 4;
            field TARGET_LINK_WIDTH @'h0 {
                bits 6;
                access rw;
                hard_reset 'h0;
                doc {
                    Target Link Width.

Values correspond to:
 - 6'b000000: Core does not start upconfigure or autonomous width downsizing in the Configuration state.
 - 6'b000001: x1
 - 6'b000010: x2
 - 6'b000100: x4
 - 6'b001000: x8
 - 6'b010000: x16
 - 6'b100000: x32
This field is reserved (fixed to '0') for M-PCIe.
                }
            }
            field DIRECT_LINK_WIDTH_CHANGE @'h6 {
                access rw;
                volatile 1
                hard_reset 'h0;
                doc {
                    Directed Link Width Change.

The controller always moves to Configuration state through Recovery state when this bit is set to '1'.
 - If the upconfigure_capable variable is '1' and the PCIE_CAP_HW_AUTO_WIDTH_DISABLE bit in LINK_CONTROL_LINK_STATUS_REG is '0', the controller starts upconfigure or autonomous width downsizing (to the TARGET_LINK_WIDTH value) in the Configuration state.
 - If TARGET_LINK_WIDTH value is 0x0, the controller does not start upconfigure or autonomous width downsizing in the Configuration state.
The controller self-clears this field when the controller accepts this request.

This field is reserved (fixed to '0') for M-PCIe.
                }
            }
            field UPCONFIGURE_SUPPORT @'h7 {
                access rw;
                hard_reset 'h0;
                doc {
                    Upconfigure Support.

The controller sends this value as the Link Upconfigure Capability in TS2 Ordered Sets in Configuration.Complete state.

This field is reserved (fixed to '0') for M-PCIe.

Note: This register field is sticky.
                }
            }
            field RSVDP_8 @'h8 {
                bits 24;
                access ro;
                hard_reset 'h0;
                soft_reset 'h0;
                doc {
                    Reserved for future use.
                }
            }
            doc {
                UpConfigure Multi-lane Control Register.

Used when upsizing or downsizing the link width through Configuration state without bringing the link down.
For more details, see the "Link Establishment" section in the "Controller
Operations" chapter of the Databook.UpConfigure Multi-lane Control Register.

Used when upsizing or downsizing the link width through Configuration state without bringing the link down.
For more details, see the "Link Establishment" section in the "Controller
Operations" chapter of the Databook.
            }
        }
        register PHY_INTEROP_CTRL_OFF @'h1c4 {
            bytes 4;
            field RXSTANDBY_CONTROL @'h0 {
                bits 7;
                access rw;
                hard_reset 'h0;
                doc {
                    Rxstandby Control. Bits 0..5 determine if the controller asserts the RxStandby signal (mac_phy_rxstandby) in the indicated condition. Bit 6 enables the controller to perform the RxStandby/RxStandbyStatus handshake.

 This field is reserved for internal use.

You should not write to this field and change the default unless specifically instructed by Synopsys support.
 - [0]: Rx EIOS and subsequent T TX-IDLE-MIN
 - [1]: Rate Change
 - [2]: Inactive lane for upconfigure/downconfigure
 - [3]: PowerDown=P1orP2
 - [4]: RxL0s.Idle
 - [5]: EI Infer in L0
 - [6]: Execute RxStandby/RxStandbyStatus Handshake
This field is reserved (fixed to '0') for M-PCIe.

Note: This register field is sticky.
                }
            }
            field RSVDP_7 @'h7 {
                access ro;
                hard_reset 'h0;
                soft_reset 'h0;
                doc {
                    Reserved for future use.
                }
            }
            field L1_NOWAIT_P1 @'h9 {
                access ro;
                hard_reset 'h0;
                doc {
                    L1 entry control bit.

 This field is reserved for internal use.

You should not write to this field and change the default unless specifically instructed by Synopsys support.
 - 1: Core does not wait for PHY to acknowledge transition to P1 before entering L1.
 - 0: Core waits for the PHY to acknowledge transition to P1 before entering L1.
Note: The access attributes of this field are as follows:
 - Wire: R/W (sticky) 
 - Dbi: R/W (sticky) 
Note: This register field is sticky.
                }
            }
            field L1_CLK_SEL @'ha {
                access rw;
                hard_reset 'h0;
                doc {
                    L1 Clock control bit.

 This field is reserved for internal use.

You should not write to this field and change the default unless specifically instructed by Synopsys support.
 - 1: Controller does not request aux_clk switch and core_clk gating in L1.
 - 0: Controller requests aux_clk switch and core_clk gating in L1.
Note: This register field is sticky.
                }
            }
            field P2NOBEACON_ENABLE @'hb {
                access rw;
                hard_reset 'h0;
                doc {
                    P2.NoBeacon Enable bit.
 - 1: Controller drives P2.NoBeacon encoding for PHY power down state, when core goes to L2.
 - 0: Controller drives P2 encoding for PHY power down state, when core goes to L2.
Note: This register field is sticky.
                }
            }
            field RSVDP_12 @'hc {
                bits 20;
                access ro;
                hard_reset 'h0;
                soft_reset 'h0;
                doc {
                    Reserved for future use.
                }
            }
            doc {
                PHY Interoperability Control Register.
PHY Interoperability Control Register.

            }
        }
        register TRGT_CPL_LUT_DELETE_ENTRY_OFF @'h1c8 {
            bytes 4;
            field LOOK_UP_ID @'h0 {
                bits 31;
                access rw;
                hard_reset 'h0;
                doc {
                    This number selects one entry to delete of the TRGT_CPL_LUT.
                }
            }
            field DELETE_EN @'h1f {
                access wo;
                volatile 1
                hard_reset 'h0;
                doc {
                    This is a one-shot bit. A '1' write to this bit triggers the deletion of the target completion LUT entry that is specified in the LOOK_UP_ID field.
This is a self-clearing register field. Reading from this register field always returns a '0'.
                }
            }
            doc {
                TRGT_CPL_LUT Delete Entry Control register. 

Using this register you can delete one entry in the target completion LUT. You should only use this register when you know that your application will never send the completion because of an FLR or any other reason.

Note:: The target completion LUT (and associated target completion timeout event) is watching for completions (from your application on XALI0/1/2 or AXI master read channel) corresponding to previously received non-posted requests from the PCIe wire.TRGT_CPL_LUT Delete Entry Control register. 

Using this register you can delete one entry in the target completion LUT. You should only use this register when you know that your application will never send the completion because of an FLR or any other reason.

Note:: The target completion LUT (and associated target completion timeout event) is watching for completions (from your application on XALI0/1/2 or AXI master read channel) corresponding to previously received non-posted requests from the PCIe wire.
            }
        }
        register LINK_FLUSH_CONTROL_OFF @'h1cc {
            bytes 4;
            field AUTO_FLUSH_EN @'h0 {
                access rw;
                hard_reset 'h0;
                doc {
                    Enables automatic flushing of pending requests before sending the reset request to the application logic to reset the PCIe controller and the AXI Bridge.
The flushing process is initiated if any of the following events occur:
 - Hot reset request. A downstream port (DSP) can "hot reset" an upstream port (USP) by sending two consecutive TS1 ordered sets with the hot reset bit asserted.
 - Warm (Soft) reset request. Generated when exiting from D3 to D0 and cfg_pm_no_soft_rst=0.
 - Link down reset request. A high to low transition on smlh_req_rst_not indicates the link has gone down and the controller is requesting a reset.
If you disable automatic flushing, your application is responsible for resetting the PCIe controller and the AXI Bridge. For more details see "Warm and Hot Resets" section in the Architecture chapter of the Databook.

Note: This register field is sticky.
                }
            }
            field RSVDP_1 @'h1 {
                bits 23;
                access ro;
                hard_reset 'h0;
                soft_reset 'h0;
                doc {
                    Reserved for future use.
                }
            }
            field RSVD_I_8 @'h18 {
                bits 8;
                access rw;
                hard_reset 'h0;
                doc {
                    This is an internally reserved field. Do not use.

Note: This register field is sticky.
                }
            }
            doc {
                Link Reset Request Flush Control Register.Link Reset Request Flush Control Register.
            }
        }
        register AMBA_ERROR_RESPONSE_DEFAULT_OFF @'h1d0 {
            bytes 4;
            field AMBA_ERROR_RESPONSE_GLOBAL @'h0 {
                access rw;
                hard_reset 'h0;
                doc {
                    Global Slave Error Response Mapping. Determines the AXI slave response for all error scenarios on non-posted requests. For more details see "Error Handling" in the AXI chapter of the Databook.

AHB:
 - 0: OKAY (with FFFF data for non-posted requests) and ignore the setting in bit [2] of this register.
 - 1: ERROR for normal link (data) accesses and look at bit [2] for other scenarios.
AXI:
 - 0: OKAY (with FFFF data for non-posted requests)
 - 1: SLVERR/DECERR (the AXI_ERROR_RESPONSE_MAP field determines the PCIe-to-AXI Slave error response mapping)
The error response mapping is not applicable to Non-existent Vendor ID register reads.

Note: This register field is sticky.
                }
            }
            field RSVDP_1 @'h1 {
                access ro;
                hard_reset 'h0;
                soft_reset 'h0;
                doc {
                    Reserved for future use.
                }
            }
            field AMBA_ERROR_RESPONSE_VENDORID @'h2 {
                access rw;
                hard_reset 'h0;
                doc {
                    Vendor ID Non-existent Slave Error Response Mapping. Determines the AXI slave response for errors on reads to non-existent Vendor ID register. For more details see "Error Handling" in the AXI chapter of the Databook.
AHB:
 - 0: OKAY (with FFFF data). The controller ignores the setting in the bit when bit 0 of this register is '0'.
 - 1: ERROR
AXI:
 - 0: OKAY (with FFFF data).
 - 1: SLVERR/DECERR (the AXI_ERROR_RESPONSE_MAP field determines the PCIe-to-AXI Slave error response mapping)
Note: This register field is sticky.
                }
            }
            field AMBA_ERROR_RESPONSE_CRS @'h3 {
                bits 2;
                access rw;
                volatile 1
                hard_reset 'h0;
                doc {
                    CRS Slave Error Response Mapping. Determines the AXI slave response for CRS completions. For more details see "Error Handling" in the AXI chapter of the Databook.
AHB:
 - always returns OKAY
AXI:
 - 00: OKAY
 - 01: OKAY with all FFFF_FFFF data for all CRS completions
 - 10: OKAY with FFFF_0001 data for CRS completions to vendor ID read requests, OKAY with FFFF_FFFF data for all other CRS completions
 - 11: SLVERR/DECERR (the AXI_ERROR_RESPONSE_MAP field determines the PCIe-to-AXI Slave error response mapping)
Note: This register field is sticky.
                }
            }
            field RSVDP_5 @'h5 {
                bits 5;
                access ro;
                hard_reset 'h0;
                soft_reset 'h0;
                doc {
                    Reserved for future use.
                }
            }
            field AMBA_ERROR_RESPONSE_MAP @'ha {
                bits 6;
                access rw;
                hard_reset 'h0;
                doc {
                    AXI Slave Response Error Map. Allows you to selectively map the errors received from the PCIe completion (for non-posted requests) to the AXI slave responses, slv_rresp or slv_bresp. The recommended setting is SLVERR. CRS is always mapped to OKAY.
 - [0]
 -- 0: UR (unsupported request) -> DECERR
 -- 1: UR (unsupported request) -> SLVERR
 - [1]
 -- 0: CRS (configuration retry status) -> DECERR
 -- 1: CRS (configuration retry status) -> SLVERR
 - [2]
 -- 0: CA (completer abort) -> DECERR
 -- 1: CA (completer abort) -> SLVERR
 - [3]: Reserved
 - [4]: Reserved
 - [5]:
 -- 0: Completion Timeout -> DECERR
 -- 1: Completion Timeout -> SLVERR
The AXI bridge internally drops (processes internally but not passed to your application) a completion that has been marked by the Rx filter as UC or MLF, and does not pass its status directly down to the slave interface. It waits for a timeout and then signals "Completion Timeout" to the slave interface.
The controller sets the AXI slave read databus to 0xFFFF for all error responses.

Note: This register field is sticky.
                }
            }
            field RSVDP_16 @'h10 {
                bits 16;
                access ro;
                hard_reset 'h0;
                soft_reset 'h0;
                doc {
                    Reserved for future use.
                }
            }
            doc {
                AXI Bridge Slave Error Response Register.AXI Bridge Slave Error Response Register.
            }
        }
        register AMBA_LINK_TIMEOUT_OFF @'h1d4 {
            bytes 4;
            field LINK_TIMEOUT_PERIOD_DEFAULT @'h0 {
                bits 8;
                access rw;
                hard_reset 'h0;
                doc {
                    Timeout Value (ms). The timer will timeout and then flush the bridge TX request queues after this amount of time. The timer counts when there are pending outbound AXI slave interface requests and the PCIe TX link is not transmitting any of these requests.
The timer is clocked by core_clk. For an M-PCIe configuration:
 - Time unit of this field is 4 ms.
 - Margin of error for RateA clock is < 1%.
 - Margin of error for RateB clock is between 16% and 17%.
Note: This register field is sticky.
                }
            }
            field LINK_TIMEOUT_ENABLE_DEFAULT @'h8 {
                access rw;
                hard_reset 'h0;
                doc {
                    Disable Flush. You can disable the flush feature by setting this field to "1".

Note: This register field is sticky.
                }
            }
            field RSVDP_9 @'h9 {
                bits 23;
                access ro;
                hard_reset 'h0;
                soft_reset 'h0;
                doc {
                    Reserved for future use.
                }
            }
            doc {
                Link Down AXI Bridge Slave Timeout Register. If your application AXI master issues outbound requests to the AXI bridge slave interface before the PCIe link is operational, the controller starts a "flush" timer. The timeout value of the timer is set by this register. If the timer times out before the PCIe link is operational, the bridge TX request queues are flushed. For more details, see the "AXI Bridge Initialization, Clocking and Reset" section in the AXI chapter of the Databook.Link Down AXI Bridge Slave Timeout Register. If your application AXI master issues outbound requests to the AXI bridge slave interface before the PCIe link is operational, the controller starts a "flush" timer. The timeout value of the timer is set by this register. If the timer times out before the PCIe link is operational, the bridge TX request queues are flushed. For more details, see the "AXI Bridge Initialization, Clocking and Reset" section in the AXI chapter of the Databook.
            }
        }
        register AMBA_ORDERING_CTRL_OFF @'h1d8 {
            bytes 4;
            field RSVDP_0 @'h0 {
                access ro;
                hard_reset 'h0;
                soft_reset 'h0;
                doc {
                    Reserved for future use.
                }
            }
            field AX_SNP_EN @'h1 {
                access rw;
                hard_reset 'h0;
                doc {
                    AXI Serialize Non-Posted Requests Enable. This field enables the AXI Bridge to serialize same ID Non-Posted Read/Write Requests on the wire. Serialization implies one outstanding same ID NP Read or Write on the wire and used to avoid AXI RAR and WAW hazards at the remote link partner. For more details, see the "Optional Serialization of AXI Slave Non-posted Requests" section in the AXI chapter of the Databook.
                }
            }
            field RSVDP_2 @'h2 {
                access ro;
                hard_reset 'h0;
                soft_reset 'h0;
                doc {
                    Reserved for future use.
                }
            }
            field AX_MSTR_ORDR_P_EVENT_SEL @'h3 {
                bits 2;
                access rw;
                hard_reset 'h0;
                doc {
                    AXI Master Posted Ordering Event Selector.

 This field selects how the master interface determines when a P write is completed when enforcing the PCIe ordering rule, "NP must not pass P" at the AXI Master Interface.
The AXI protocol does not support ordering between channels. Therefore, NP reads can pass P on your AXI bus fabric. This can result in an ordering violation when the read overtakes a P that is going to the same address. Therefore, the bridge master does not issue any NP requests until all outstanding P writes reach their destination. It does this by waiting for the all of the write responses on the B channel. This can affect the performance of the master read channel.
For scenarios where the interconnect serializes the AXI master "AW", "W" and "AR" channels,you can increase the performance by reducing the need to wait until the complete Posted transaction has effectively reached the application slave.
 - 00: B'last event: wait for the all of the write responses on the B channel thereby ensuring that the complete Posted transaction has effectively reached the application slave (default).
 - 01: AW'last event: wait until the complete Posted transaction has left the AXI address channel at the bridge master.
 - 10: W'last event: wait until the complete Posted transaction has left the AXI data channel at the bridge master.
 - 11: Reserved
Note 2: This setting will not affect:
 - MSI interrupt catcher and P data ordering. This is always driven by the B'last event.
 - DMA read engine TLP ordering. This is always driven by the B'last event.
 - NP write transactions which are always serialized with P write transactions.
                }
            }
            field RSVDP_5 @'h5 {
                bits 2;
                access ro;
                hard_reset 'h0;
                soft_reset 'h0;
                doc {
                    Reserved for future use.
                }
            }
            field AX_MSTR_ZEROLREAD_FW @'h7 {
                access rw;
                hard_reset 'h0;
                doc {
                    AXI Master Zero Length Read Forward to the application. 

The DW PCIe controller AXI bridge is able to terminate in order with the Posted transactions the zero length read, implementing the PCIe express flush semantics of the Posted transactions.
 - 0x0: The zero length Read is terminated at the DW PCIe AXI bridge master
 - 0x1: The zero length Read is forward to the application.
                }
            }
            field RSVDP_8 @'h8 {
                bits 24;
                access ro;
                hard_reset 'h0;
                soft_reset 'h0;
                doc {
                    Reserved for future use.
                }
            }
            doc {
                AMBA Ordering Control.AMBA Ordering Control.
            }
        }
        register COHERENCY_CONTROL_1_OFF @'h1e0 {
            bytes 4;
            field CFG_MEMTYPE_VALUE @'h0 {
                access rw;
                hard_reset 'h0;
                doc {
                    Sets the memory type for the lower and upper parts of the address space:
 - 0: lower = Peripheral; upper = Memory
 - 1: lower = Memory type; upper = Peripheral
Note: This register field is sticky.
                }
            }
            field RSVDP_1 @'h1 {
                access ro;
                hard_reset 'h0;
                soft_reset 'h0;
                doc {
                    Reserved for future use.
                }
            }
            field CFG_MEMTYPE_BOUNDARY_LOW_ADDR @'h2 {
                bits 30;
                access rw;
                hard_reset 'h0;
                doc {
                    Boundary Lower Address For Memory Type. Bits [31:0] of dword-aligned address of the boundary for Memory type. The two lower address LSBs are "00". Addresses up to but not including this value are in the lower address space region; addresses equal or greater than this value are in the upper address space region.

Note: This register field is sticky.
                }
            }
            doc {
                ACE Cache Coherency Control Register 1ACE Cache Coherency Control Register 1
            }
        }
        register COHERENCY_CONTROL_2_OFF @'h1e4 {
            bytes 4;
            field CFG_MEMTYPE_BOUNDARY_HIGH_ADDR @'h0 {
                bits 32;
                access rw;
                hard_reset 'h0;
                doc {
                    Boundary Upper Address For Memory Type. Bits [63:32] of the 64-bit dword-aligned address of the boundary for Memory type.

Note: This register field is sticky.
                }
            }
            doc {
                ACE Cache Coherency Control Register 2ACE Cache Coherency Control Register 2
            }
        }
        register COHERENCY_CONTROL_3_OFF @'h1e8 {
            bytes 4;
            field CFG_MSTR_ARCACHE_MODE @'h3 {
                bits 4;
                access rw;
                hard_reset 'h0;
                doc {
                    Master Read CACHE Signal Behavior.
Defines how the individual bits in mstr_arcache are controlled:
 - 0: set automatically by the AXI master
 - 1: set by the value of the corresponding bit of the CFG_MSTR_ARCACHE_VALUE field
Note: This register field is sticky.
                }
            }
            field CFG_MSTR_AWCACHE_MODE @'hb {
                bits 4;
                access rw;
                hard_reset 'h0;
                doc {
                    Master Write CACHE Signal Behavior.
Defines how the individual bits in mstr_awcache are controlled:
 - 0: set automatically by the AXI master
 - 1: set by the value of the corresponding bit of the CFG_MSTR_AWCACHE_VALUE field
Note: for message requests the value of mstr_awcache is always "0000" regardless of the value of this bit

Note: This register field is sticky.
                }
            }
            field CFG_MSTR_ARCACHE_VALUE @'h13 {
                bits 4;
                access rw;
                hard_reset 'h0;
                doc {
                    Master Read CACHE Signal Value.
Value of the individual bits in mstr_arcache when CFG_MSTR_ARCACHE_MODE is '1'.

Note: This register field is sticky.
                }
            }
            field CFG_MSTR_AWCACHE_VALUE @'h1b {
                bits 4;
                access rw;
                hard_reset 'h0;
                doc {
                    Master Write CACHE Signal Value.
Value of the individual bits in mstr_awcache when CFG_MSTR_AWCACHE_MODE is '1'.

Note: not applicable to message requests; for message requests the value of mstr_awcache is always "0000"

Note: This register field is sticky.
                }
            }
            doc {
                ACE Cache Coherency Control Register 3ACE Cache Coherency Control Register 3
            }
        }
        register AXI_MSTR_MSG_ADDR_LOW_OFF @'h1f0 {
            bytes 4;
            field CFG_AXIMSTR_MSG_ADDR_LOW_RESERVED @'h0 {
                bits 12;
                access ro;
                hard_reset 'h0;
                doc {
                    Reserved for future use.

Note: This register field is sticky.
                }
            }
            field CFG_AXIMSTR_MSG_ADDR_LOW @'hc {
                bits 20;
                access rw;
                hard_reset 'h0;
                doc {
                    Lower 20 bits of the programmable AXI address for Messages.

Note: This register field is sticky.
                }
            }
            doc {
                Lower 20 bits of the programmable AXI address where Messages coming from wire are mapped to. Bits [11:0] of the register are tied to zero for the address to be 4k-aligned. In previous releases, the third and fourth DWORDs of a message (Msg/MsgD) TLP header were delivered though the AXI master address bus (mstr_awaddr). These DWORDS are now supplied through the mstr_awmisc_info_hdr_34dw[63:0] output; and the value on mstr_awaddr is driven to the value you have programmed into the AXI_MSTR_MSG_ADDR_LOW_OFF and AXI_MSTR_MSG_ADDR_HIGH_OFF registers.Lower 20 bits of the programmable AXI address where Messages coming from wire are mapped to. Bits [11:0] of the register are tied to zero for the address to be 4k-aligned. In previous releases, the third and fourth DWORDs of a message (Msg/MsgD) TLP header were delivered though the AXI master address bus (mstr_awaddr). These DWORDS are now supplied through the mstr_awmisc_info_hdr_34dw[63:0] output; and the value on mstr_awaddr is driven to the value you have programmed into the AXI_MSTR_MSG_ADDR_LOW_OFF and AXI_MSTR_MSG_ADDR_HIGH_OFF registers.
            }
        }
        register AXI_MSTR_MSG_ADDR_HIGH_OFF @'h1f4 {
            bytes 4;
            field CFG_AXIMSTR_MSG_ADDR_HIGH @'h0 {
                bits 32;
                access rw;
                hard_reset 'h0;
                doc {
                    Upper 32 bits of the programmable AXI address for Messages.

Note: This register field is sticky.
                }
            }
            doc {
                Upper 32 bits of the programmable AXI address where Messages coming from wire are mapped to.Upper 32 bits of the programmable AXI address where Messages coming from wire are mapped to.
            }
        }
        register PCIE_VERSION_NUMBER_OFF @'h1f8 {
            bytes 4;
            field VERSION_NUMBER @'h0 {
                bits 32;
                access ro;
                hard_reset 'h0;
                doc {
                    Version Number.
                }
            }
            doc {
                PCIe Controller IIP Release Version Number. The version number is given in
hex format. You should convert each pair of hex characters to ASCII to interpret.

Using 4.70a (GA) as an example:
 - VERSION_NUMBER = 0x3437302a which translates to 470* 
 - VERSION_TYPE = 0x67612a2a which translates to ga**
Using 4.70a-ea01 as an example:
 - VERSION_NUMBER = 0x3437302a which translates to 470* 
 - VERSION_TYPE = 0x65613031 which translates to ea01
GA is a general release available on www.designware.com

EA is an early release available on a per-customer basis.PCIe Controller IIP Release Version Number. The version number is given in
hex format. You should convert each pair of hex characters to ASCII to interpret.

Using 4.70a (GA) as an example:
 - VERSION_NUMBER = 0x3437302a which translates to 470* 
 - VERSION_TYPE = 0x67612a2a which translates to ga**
Using 4.70a-ea01 as an example:
 - VERSION_NUMBER = 0x3437302a which translates to 470* 
 - VERSION_TYPE = 0x65613031 which translates to ea01
GA is a general release available on www.designware.com

EA is an early release available on a per-customer basis.
            }
        }
        register PCIE_VERSION_TYPE_OFF @'h1fc {
            bytes 4;
            field VERSION_TYPE @'h0 {
                bits 32;
                access ro;
                hard_reset 'h0;
                doc {
                    Version Type.
                }
            }
            doc {
                PCIe Controller IIP Release Version Type. The type is given in
hex format. You should convert each pair of hex characters to ASCII to interpret.

Using 4.70a (GA) as an example:
 - VERSION_NUMBER = 0x3437302a which translates to 470* 
 - VERSION_TYPE = 0x67612a2a which translates to ga**
Using 4.70a-ea01 as an example:
 - VERSION_NUMBER = 0x3437302a which translates to 470* 
 - VERSION_TYPE = 0x65613031 which translates to ea01
GA is a general release available on www.designware.com

EA is an early release available on a per-customer basis.PCIe Controller IIP Release Version Type. The type is given in
hex format. You should convert each pair of hex characters to ASCII to interpret.

Using 4.70a (GA) as an example:
 - VERSION_NUMBER = 0x3437302a which translates to 470* 
 - VERSION_TYPE = 0x67612a2a which translates to ga**
Using 4.70a-ea01 as an example:
 - VERSION_NUMBER = 0x3437302a which translates to 470* 
 - VERSION_TYPE = 0x65613031 which translates to ea01
GA is a general release available on www.designware.com

EA is an early release available on a per-customer basis.
            }
        }
        register MSIX_ADDRESS_MATCH_LOW_OFF @'h240 {
            bytes 4;
            field MSIX_ADDRESS_MATCH_EN @'h0 {
                access rw;
                hard_reset 'h0;
                doc {
                    MSI-X Match Enable. Enable the MSI-X Address Match feature when the AXI bridge is present.

Note: This register field is sticky.
                }
            }
            field MSIX_ADDRESS_MATCH_RESERVED_1 @'h1 {
                access ro;
                hard_reset 'h0;
                doc {
                    Reserved.

Note: This register field is sticky.
                }
            }
            field MSIX_ADDRESS_MATCH_LOW @'h2 {
                bits 30;
                access rw;
                hard_reset 'h0;
                doc {
                    MSI-X Address Match Low Address.

Note: This register field is sticky.
                }
            }
            doc {
                MSI-X Address Match Low Register. When you enable the MSI-X Table RAM feature (MSIX_TABLE_EN=1), the controller implements the logic and RAM required to generate MSI-X requests. For more details, see the Interrupts section in the "Controller Operations" chapter of the Databook. This register is only used in AXI configurations. When your local AXI application writes (MWr) to the address defined in this register (and MSIX_ADDRESS_MATCH_HIGH_OFF), the controller will load the MSIX_DOORBELL_OFF register with the contents of the MWr and subsequently create and send MSI-X TLPsMSI-X Address Match Low Register. When you enable the MSI-X Table RAM feature (MSIX_TABLE_EN=1), the controller implements the logic and RAM required to generate MSI-X requests. For more details, see the Interrupts section in the "Controller Operations" chapter of the Databook. This register is only used in AXI configurations. When your local AXI application writes (MWr) to the address defined in this register (and MSIX_ADDRESS_MATCH_HIGH_OFF), the controller will load the MSIX_DOORBELL_OFF register with the contents of the MWr and subsequently create and send MSI-X TLPs
            }
        }
        register MSIX_ADDRESS_MATCH_HIGH_OFF @'h244 {
            bytes 4;
            field MSIX_ADDRESS_MATCH_HIGH @'h0 {
                bits 32;
                access rw;
                hard_reset 'h0;
                doc {
                    MSI-X Address Match High Address.

Note: This register field is sticky.
                }
            }
            doc {
                MSI-X Address Match High Register. When you enable the MSI-X Table RAM feature (MSIX_TABLE_EN=1), the controller implements the logic and RAM required to generate MSI-X requests. For more details, see the Interrupts section in the "Controller Operations" chapter of the Databook. This register is only used in AXI configurations. When your local AXI application writes (MWr) to the address defined in this register (and MSIX_ADDRESS_MATCH_LOW_OFF), the controller will load the MSIX_DOORBELL_OFF register with the contents of the MWr and subsequently create and send MSI-X TLPsMSI-X Address Match High Register. When you enable the MSI-X Table RAM feature (MSIX_TABLE_EN=1), the controller implements the logic and RAM required to generate MSI-X requests. For more details, see the Interrupts section in the "Controller Operations" chapter of the Databook. This register is only used in AXI configurations. When your local AXI application writes (MWr) to the address defined in this register (and MSIX_ADDRESS_MATCH_LOW_OFF), the controller will load the MSIX_DOORBELL_OFF register with the contents of the MWr and subsequently create and send MSI-X TLPs
            }
        }
        register MSIX_DOORBELL_OFF @'h248 {
            bytes 4;
            field MSIX_DOORBELL_VECTOR @'h0 {
                bits 11;
                access wo;
                hard_reset 'h0;
                doc {
                    MSI-X Doorbell Vector. This register determines which vector to generate the MSI-X transaction for.
                }
            }
            field MSIX_DOORBELL_RESERVED_11 @'hb {
                access wo;
                hard_reset 'h0;
                doc {
                    Reserved.
                }
            }
            field MSIX_DOORBELL_TC @'hc {
                bits 3;
                access wo;
                hard_reset 'h0;
                doc {
                    MSIX Doorbell Traffic Class. This register determines which traffic class to generate the MSI-X transaction with.
                }
            }
            field MSIX_DOORBELL_VF_ACTIVE @'hf {
                access wo;
                hard_reset 'h0;
                doc {
                    MSIX Doorbell Virtual Function Active. This register determines whether a Virtual Function is used to generate the MSI-X transaction.
                }
            }
            field MSIX_DOORBELL_VF @'h10 {
                bits 8;
                access wo;
                hard_reset 'h0;
                doc {
                    MSIX Doorbell Virtual Function. This register determines the Virtual Function for the MSI-X transaction.
                }
            }
            field MSIX_DOORBELL_PF @'h18 {
                bits 5;
                access wo;
                hard_reset 'h0;
                doc {
                    MSIX Doorbell Physical Function. This register determines the Physical Function for the MSI-X transaction.
                }
            }
            field MSIX_DOORBELL_RESERVED_29_31 @'h1d {
                bits 3;
                access wo;
                hard_reset 'h0;
                doc {
                    Reserved.
                }
            }
            doc {
                MSI-X Doorbell Register. When you enable the MSI-X Table RAM feature (MSIX_TABLE_EN=1), the controller implements the logic and RAM required to generate MSI-X requests. For more details, see the Interrupts section in the "Controller Operations" chapter of the Databook.
 - For AXI configurations: when your local application writes (MWr) to the address defined in MSIX_ADDRESS_MATCH_LOW_OFF, the controller will load this register with the contents of the MWr and subsequently create and send MSI-X TLPs.
 - For AHB configurations: the MSI-X Table RAM feature is not supported.
 - For non-AMBA configurations: when your local application writes to this register, the controller will create and send MSI-X TLPs.MSI-X Doorbell Register. When you enable the MSI-X Table RAM feature (MSIX_TABLE_EN=1), the controller implements the logic and RAM required to generate MSI-X requests. For more details, see the Interrupts section in the "Controller Operations" chapter of the Databook.
 - For AXI configurations: when your local application writes (MWr) to the address defined in MSIX_ADDRESS_MATCH_LOW_OFF, the controller will load this register with the contents of the MWr and subsequently create and send MSI-X TLPs.
 - For AHB configurations: the MSI-X Table RAM feature is not supported.
 - For non-AMBA configurations: when your local application writes to this register, the controller will create and send MSI-X TLPs.
            }
        }
        register MSIX_RAM_CTRL_OFF @'h24c {
            bytes 4;
            field MSIX_RAM_CTRL_TABLE_DS @'h0 {
                access rw;
                hard_reset 'h0;
                doc {
                    MSIX Table RAM Deep Sleep. Set this bit to drive the cfg_msix_table_ds output to signal your external logic to place the MSIX Table RAM in Deep Sleep low-power mode.

Note: This register field is sticky.
                }
            }
            field MSIX_RAM_CTRL_TABLE_SD @'h1 {
                access rw;
                hard_reset 'h0;
                doc {
                    MSIX Table RAM Shut Down. Set this bit to drive the cfg_msix_table_sd output to signal your external logic to place the MSIX Table RAM in Shut Down low-power mode.

Note: This register field is sticky.
                }
            }
            field MSIX_RAM_CTRL_RESERVED_2_7 @'h2 {
                bits 6;
                access ro;
                hard_reset 'h0;
                doc {
                    Reserved.

Note: This register field is sticky.
                }
            }
            field MSIX_RAM_CTRL_PBA_DS @'h8 {
                access rw;
                hard_reset 'h0;
                doc {
                    MSIX PBA RAM Deep Sleep. Set this bit to drive the cfg_msix_pba_ds output to signal your external logic to place the MSIX PBA RAM in Deep Sleep low-power mode.

Note: This register field is sticky.
                }
            }
            field MSIX_RAM_CTRL_PBA_SD @'h9 {
                access rw;
                hard_reset 'h0;
                doc {
                    MSIX PBA RAM Shut Down. Set this bit to drive the cfg_msix_pba_sd output to signal your external logic to place the MSIX PBA RAM in Shut Down low-power mode.

Note: This register field is sticky.
                }
            }
            field MSIX_RAM_CTRL_RESERVED_10_15 @'ha {
                bits 6;
                access ro;
                hard_reset 'h0;
                doc {
                    Reserved.

Note: This register field is sticky.
                }
            }
            field MSIX_RAM_CTRL_BYPASS @'h10 {
                access rw;
                hard_reset 'h0;
                doc {
                    MSIX RAM Control Bypass. The bypass field, when set, disables the internal generation of low power signals for both RAMs.
It is up to the application to ensure the RAMs are in the proper power state before trying to access them. Moreover, the application needs to observe all timing requirements of the RAM low power signals before trying to use the MSIX functionality.

Note: This register field is sticky.
                }
            }
            field MSIX_RAM_CTRL_RESERVED_17_23 @'h11 {
                bits 7;
                access ro;
                hard_reset 'h0;
                doc {
                    Reserved.

Note: This register field is sticky.
                }
            }
            field MSIX_RAM_CTRL_DBG_TABLE @'h18 {
                access rw;
                hard_reset 'h0;
                doc {
                    MSIX Table RAM Debug Mode. Use this bit to activate the debug mode and allow direct read/write access to the Table. Use can also use the dbg_table input to activate debug mode. Debug mode turns off the PF/VF/Offset-based addressing into the RAM and maps the entire table linearly from the base address of the BAR (indicated by the BIR) in function 0.

Note: This register field is sticky.
                }
            }
            field MSIX_RAM_CTRL_DBG_PBA @'h19 {
                access rw;
                hard_reset 'h0;
                doc {
                    MSIX PBA RAM Debug Mode. Use this bit to activate the debug mode and allow direct read/write access to the PBA. Use can also use the dbg_pba input to activate debug mode. Debug mode turns off the PF/VF/Offset-based addressing into the RAM and maps the entire table linearly from the base address of the BAR (indicated by the BIR) in function 0.

Note: This register field is sticky.
                }
            }
            field MSIX_RAM_CTRL_RESERVED_26_31 @'h1a {
                bits 6;
                access ro;
                hard_reset 'h0;
                doc {
                    Reserved.

Note: This register field is sticky.
                }
            }
            doc {
                MSI-X RAM power mode and debug control register. When you enable the MSI-X Table RAM feature (MSIX_TABLE_EN=1), the controller implements the logic and RAM required to generate MSI-X requests. For more details, see the Interrupts section in the "Controller Operations" chapter of the Databook.MSI-X RAM power mode and debug control register. When you enable the MSI-X Table RAM feature (MSIX_TABLE_EN=1), the controller implements the logic and RAM required to generate MSI-X requests. For more details, see the Interrupts section in the "Controller Operations" chapter of the Databook.
            }
        }
        register AUX_CLK_FREQ_OFF @'h440 {
            bytes 4;
            field AUX_CLK_FREQ @'h0 {
                bits 10;
                access rw;
                hard_reset 'h0;
                doc {
                    The aux_clk frequency in MHz. This value is used to provide a 1 us reference for counting time during low-power states with aux_clk when the PHY has removed the pipe_clk.
Frequencies lower than 1 MHz are possible but with a loss of accuracy in the time counted.
If the actual frequency (f) of aux_clk does not exactly match the programmed frequency (f_prog), then there is an error in the time counted by the controller that can be expressed in percentage as: err% = (f_prog/f-1)*100. For example if f=2.5 MHz and f_prog=3 MHz, then err% =(3/2.5-1)*100 =20%, meaning that the time counted by the controller on aux_clk will be 20% greater than the time in us programmed in the corresponding time register (for example T_POWER_ON).

Note: This register field is sticky.
                }
            }
            field RSVDP_10 @'ha {
                bits 22;
                access ro;
                hard_reset 'h0;
                soft_reset 'h0;
                doc {
                    Reserved for future use.
                }
            }
            doc {
                Auxiliary Clock Frequency Control Register.Auxiliary Clock Frequency Control Register.
            }
        }
        register GEN4_LANE_MARGINING_1_OFF @'h480 {
            bytes 4;
            field MARGINING_NUM_TIMING_STEPS @'h0 {
                bits 6;
                access rw;
                hard_reset 'h0;
                doc {
                    M(NumTimingSteps) for Lane Margining at the Receiver.
This parameter is defined in 9 Electrical Sub-Block of PCI Express Base Specification 4.0.
For a description of this standard PCIe parameter, see the PCI Express Base Specification 4.0.

Note: This register field is sticky.
                }
            }
            field RSVDP_6 @'h6 {
                bits 2;
                access ro;
                hard_reset 'h0;
                soft_reset 'h0;
                doc {
                    Reserved for future use.
                }
            }
            field MARGINING_MAX_TIMING_OFFSET @'h8 {
                bits 6;
                access rw;
                hard_reset 'h0;
                doc {
                    M(MaxTimingOffset) for Lane Margining at the Receiver.
This parameter is defined in 9 Electrical Sub-Block of PCI Express Base Specification 4.0.
For a description of this standard PCIe parameter, see the PCI Express Base Specification 4.0.

Note: This register field is sticky.
                }
            }
            field RSVDP_14 @'he {
                bits 2;
                access ro;
                hard_reset 'h0;
                soft_reset 'h0;
                doc {
                    Reserved for future use.
                }
            }
            field MARGINING_NUM_VOLTAGE_STEPS @'h10 {
                bits 7;
                access rw;
                hard_reset 'h0;
                doc {
                    M(NumVoltageSteps) for Lane Margining at the Receiver.
This parameter is defined in 9 Electrical Sub-Block of PCI Express Base Specification 4.0.
For a description of this standard PCIe parameter, see the PCI Express Base Specification 4.0.

Note: This register field is sticky.
                }
            }
            field RSVDP_23 @'h17 {
                access ro;
                hard_reset 'h0;
                soft_reset 'h0;
                doc {
                    Reserved for future use.
                }
            }
            field MARGINING_MAX_VOLTAGE_OFFSET @'h18 {
                bits 6;
                access rw;
                hard_reset 'h0;
                doc {
                    M(MaxVoltageOffset) for Lane Margining at the Receiver.
This parameter is defined in 9 Electrical Sub-Block of PCI Express Base Specification 4.0.
For a description of this standard PCIe parameter, see the PCI Express Base Specification 4.0.

Note: This register field is sticky.
                }
            }
            field RSVDP_30 @'h1e {
                bits 2;
                access ro;
                hard_reset 'h0;
                soft_reset 'h0;
                doc {
                    Reserved for future use.
                }
            }
            doc {
                Gen4 Lane Margining 1 Register.Gen4 Lane Margining 1 Register.
            }
        }
        register GEN4_LANE_MARGINING_2_OFF @'h484 {
            bytes 4;
            field MARGINING_SAMPLE_RATE_VOLTAGE @'h0 {
                bits 6;
                access rw;
                hard_reset 'h0;
                doc {
                    M(SamplingRateVoltage) for Lane Margining at the Receiver.
This parameter is defined in 9 Electrical Sub-Block of PCI Express Base Specification 4.0.
For a description of this standard PCIe parameter, see the PCI Express Base Specification 4.0.
Note: This value is not used when MARGINING_IND_ERROR_SAMPLER is 0b. The M(SamplingRateVoltage) is fixed to 63 internally.

Note: This register field is sticky.
                }
            }
            field RSVDP_6 @'h6 {
                bits 2;
                access ro;
                hard_reset 'h0;
                soft_reset 'h0;
                doc {
                    Reserved for future use.
                }
            }
            field MARGINING_SAMPLE_RATE_TIMING @'h8 {
                bits 6;
                access rw;
                hard_reset 'h0;
                doc {
                    M(SamplingRateTiming) for Lane Margining at the Receiver.
This parameter is defined in 9 Electrical Sub-Block of PCI Express Base Specification 4.0.
For a description of this standard PCIe parameter , see the PCI Express Base Specification 4.0.
Note: This value is not used when MARGINING_IND_ERROR_SAMPLER is 0b. The M(SamplingRateTiming) is fixed to 63 internally.

Note: This register field is sticky.
                }
            }
            field RSVDP_14 @'he {
                bits 2;
                access ro;
                hard_reset 'h0;
                soft_reset 'h0;
                doc {
                    Reserved for future use.
                }
            }
            field MARGINING_MAXLANES @'h10 {
                bits 5;
                access rw;
                hard_reset 'h0;
                doc {
                    M(MaxLanes) for Lane Margining at the Receiver.
This parameter is defined in 9 Electrical Sub-Block of PCI Express Base Specification 4.0.
For a description of this standard PCIe parameter, see the PCI Express Base Specification 4.0.

Note: This register field is sticky.
                }
            }
            field RSVDP_21 @'h15 {
                bits 3;
                access ro;
                hard_reset 'h0;
                soft_reset 'h0;
                doc {
                    Reserved for future use.
                }
            }
            field MARGINING_VOLTAGE_SUPPORTED @'h18 {
                access rw;
                hard_reset 'h0;
                doc {
                    M(VoltageSupported) for Lane Margining at the Receiver.
This parameter is defined in 9 Electrical Sub-Block of PCI Express Base Specification 4.0.
For a description of this standard PCIe parameter, see the PCI Express Base Specification 4.0.

Note: This register field is sticky.
                }
            }
            field MARGINING_IND_UP_DOWN_VOLTAGE @'h19 {
                access rw;
                hard_reset 'h0;
                doc {
                    M(IndUpDownVoltage) for Lane Margining at the Receiver.
This parameter is defined in 9 Electrical Sub-Block of PCI Express Base Specification 4.0.
For a description of this standard PCIe parameter, see the PCI Express Base Specification 4.0.

Note: This register field is sticky.
                }
            }
            field MARGINING_IND_LEFT_RIGHT_TIMING @'h1a {
                access rw;
                hard_reset 'h0;
                doc {
                    M(IndLeftRightTiming) for Lane Margining at the Receiver.
This parameter is defined in 9 Electrical Sub-Block of PCI Express Base Specification 4.0.
For a description of this standard PCIe parameter, see the PCI Express Base Specification 4.0.

Note: This register field is sticky.
                }
            }
            field MARGINING_SAMPLE_REPORTING_METHOD @'h1b {
                access rw;
                hard_reset 'h0;
                doc {
                    M(SampleReportingMethod) for Lane Margining at the Receiver.
This parameter is defined in 9 Electrical Sub-Block of PCI Express Base Specification 4.0.
For a description of this standard PCIe parameter, see the PCI Express Base Specification 4.0.

Note: This register field is sticky.
                }
            }
            field MARGINING_IND_ERROR_SAMPLER @'h1c {
                access rw;
                hard_reset 'h0;
                doc {
                    M(IndErrorSampler) for Lane Margining at the Receiver.
This parameter is defined in 9 Electrical Sub-Block of PCI Express Base Specification 4.0.
For a description of this standard PCIe parameter, see the PCI Express Base Specification 4.0.

Note: This register field is sticky.
                }
            }
            field RSVDP_29 @'h1d {
                bits 2;
                access ro;
                hard_reset 'h0;
                soft_reset 'h0;
                doc {
                    Reserved for future use.
                }
            }
            doc {
                Gen4 Lane Margining 2 Register.Gen4 Lane Margining 2 Register.
            }
        }
        register PIPE_RELATED_OFF @'h490 {
            bytes 4;
            field RX_MESSAGE_BUS_WRITE_BUFFER_DEPTH @'h0 {
                bits 4;
                access rw;
                hard_reset 'h0;
                doc {
                    Rx Message Bus Write Buffer Depth.
This parameter is defined in PIPE Specification.
For a description of this standard PIPE parameter, see the PIPE Specification.

Note: This register field is sticky.
                }
            }
            field TX_MESSAGE_BUS_MIN_WRITE_BUFFER_DEPTH @'h4 {
                bits 4;
                access ro;
                hard_reset 'h0;
                doc {
                    Tx Message Bus Write Buffer Depth.
This parameter is defined in PIPE Specification 4.4.
For a description of this standard PIPE parameter, see the PIPE Specification.

Note: This register field is sticky.
                }
            }
            field PIPE_GARBAGE_DATA_MODE @'h8 {
                access rw;
                hard_reset 'h0;
                doc {
                    PIPE Garbage Data Mode.
 - 0: PIPE Spec compliant mode: The MAC discards any symbols received after the electrical idle ordered-set until RxValid is deasserted.
 - 1: Special PHY Support mode: The MAC discards any symbols received after the electrical idle ordered-set until when any of the following three conditions are true:
 -- RxValid is deasserted
 -- a valid RxStartBlock is received at 128b/130b encoding
 -- a valid COM symbol is received at 8b/10b encoding


Note: This register field is sticky.
                }
            }
            field RSVDP_9 @'h9 {
                bits 23;
                access ro;
                hard_reset 'h0;
                soft_reset 'h0;
                doc {
                    Reserved for future use.
                }
            }
            doc {
                PIPE Related Register.
This register controls the pipe's capabitity, control, and status parameters.PIPE Related Register.
This register controls the pipe's capabitity, control, and status parameters.
            }
        }
        register RX_SERIALIZATION_Q_CTRL_OFF @'h500 {
            bytes 4;
            field ALMOST_FULL_THRESHOLD @'h0 {
                bits 16;
                access ro;
                volatile 1
                hard_reset 'h0;
                doc {
                    Current almost full threshold.
                }
            }
            field ALMOST_FULL_THRESHOLD_ADJ_VAL @'h10 {
                bits 12;
                access rw;
                hard_reset 'h0;
                doc {
                    Almost full threshold adjustment value.
                }
            }
            field RSVDP_28 @'h1c {
                bits 2;
                access ro;
                hard_reset 'h0;
                soft_reset 'h0;
                doc {
                    Reserved for future use.
                }
            }
            field ALMOST_FULL_THRESHOLD_ADJ_SIGN @'h1e {
                access rw;
                hard_reset 'h0;
                doc {
                    Almost full threshold adjustment sign.
                }
            }
            field RX_SERIALIZATION_OVFLW_PRVNTN_EN @'h1f {
                access rw;
                hard_reset 'h0;
                doc {
                    Enable Receive Serialization Queue Overflow Prevention.
                }
            }
            doc {
                Receive Serialization Queue Control Register.Receive Serialization Queue Control Register.
            }
        }
        doc {
            Port Logic
        }
    }
    doc {
        DWC PCIE-EP Memory Map
    }
}

