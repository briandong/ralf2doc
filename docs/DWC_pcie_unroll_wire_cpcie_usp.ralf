system unroll_wire_pcie_controller_block {
    bytes 4;
    block PF0_ATU_CAP @'h0 {
        bytes 4;
        register IATU_REGION_CTRL_1_OFF_OUTBOUND_0 @'h0 {
            bytes 4;
            field TYPE @'h0 {
                bits 5;
                access rw;
                hard_reset 'h0;
                doc {
                    When the address of an outbound TLP is matched to this region, then the TYPE field of the TLP is changed to the value in this register.

Note: This register field is sticky.
                }
            }
            field TC @'h5 {
                bits 3;
                access rw;
                hard_reset 'h0;
                doc {
                    When the address of an outbound TLP is matched to this region, then the TC field of the TLP is changed to the value in this register.

Note: This register field is sticky.
                }
            }
            field TD @'h8 {
                access rw;
                hard_reset 'h0;
                doc {
                    This is a reserved field. Do not use.

Note: This register field is sticky.
                }
            }
            field ATTR @'h9 {
                bits 2;
                access rw;
                hard_reset 'h0;
                doc {
                    When the address of an outbound TLP is matched to this region, then the ATTR field of the TLP is changed to the value in this register.

Note: This register field is sticky.
                }
            }
            field INCREASE_REGION_SIZE @'hd {
                access rw;
                hard_reset 'h0;
                doc {
                    Increase the maximum ATU Region size. When set, the maximum ATU Region size is determined by CX_ATU_MAX_REGION_SIZE. When clear, the maximum ATU Region size is 4 GB (default).

Note: This register field is sticky.
                }
            }
            field CTRL_1_FUNC_NUM @'h14 {
                bits 3;
                access rw;
                hard_reset 'h0;
                doc {
                    Function Number.
 - When the address of an outbound TLP is matched to this region and the FUNC_BYPASS field in the "iATU Control 2 Register" is '0', then the function number used in generating the function part of the requester ID (RID) field of the TLP is taken from this 5-bit register. The value in this register must be 0x0 unless multifunction operation in the controller is enabled (CX_NFUNC > 1).
 - When you are using the AXI Bridge, then this field is swapped before AXI decomposition occurs so that the correct "Max_Read_Request_Size" and "Max_Payload_Size" values are used.

Note: This register field is sticky.
                }
            }
            doc {
                iATU Region Control 1 Register.iATU Region Control 1 Register.
            }
        }
        register IATU_REGION_CTRL_2_OFF_OUTBOUND_0 @'h4 {
            bytes 4;
            field MSG_CODE @'h0 {
                bits 8;
                access rw;
                hard_reset 'h0;
                doc {
                    MSG TLPs (Message Code). When the address of an outbound TLP is matched to this region, and the translated TLP TYPE field is Msg or MsgD; then the message field of the TLP is changed to the value in this register.

Memory TLPs: (ST;Steering Tag). When the ST field of an outbound TLP is matched to this region, and the translated TLP TYPE field targets memory space; then the ST field of the TLP is changed to the value in this register. Only Valid when the CX_TPH_ENABLE configuration parameter is 1.

Note: This register field is sticky.
                }
            }
            field TAG @'h8 {
                bits 8;
                access rw;
                hard_reset 'h0;
                doc {
                    TAG.

The substituted TAG field (byte 6) in the outgoing TLP header when TAG_SUBSTITUTE_EN is set.

Note: This register field is sticky.
                }
            }
            field TAG_SUBSTITUTE_EN @'h10 {
                access rw;
                hard_reset 'h0;
                doc {
                    TAG Substitute Enable.

When enabled and region address is matched, the iATU substitutes the TAG field of the outbound TLP header with the contents of the TAG field in this register. The expected usage scenario is translation from AXI MWr to Vendor Defined Msg/MsgD.

Note (CX_TPH_ENABLE=1): TAG substitution for MWr will not occur because this field (byte 6) in the TLP header is the ST field. ST substitution can still take place using the MSG_CODE field in IATU_REGION_CTRL_2_OFF_OUTBOUND_i.

Note: This register field is sticky.
                }
            }
            field MSB2BITS_TAG @'h11 {
                bits 2;
                access rw;
                hard_reset 'h0;
                doc {
                    TAG.

Two most significant bits of the substituted TAG field in the outgoing TLP header when TAG_SUBSTITUTE_EN is set. 

Note: This register field is sticky.
                }
            }
            field FUNC_BYPASS @'h13 {
                access rw;
                hard_reset 'h0;
                doc {
                    Function Number Translation Bypass. In this mode, the function number of the translated TLP is taken from your application transmit interface and not from the CTRL_1_FUNC_NUM field of the "iATU Control 1 Register" or the VF_NUMBER field of the "iATU Control 3 Register."

Note: This register field is sticky.
                }
            }
            field SNP @'h14 {
                access rw;
                hard_reset 'h0;
                doc {
                    Serialize Non-Posted Requests. In this mode, when the AXI Bridge is populated, same AXI ID Non-Posted Read/Write Requests are transmitted on the wire if there are no other same ID Non-Posted Requests outstanding.

Note: This register field is sticky.
                }
            }
            field TLP_HEADER_FIELDS_BYPASS @'h15 {
                access rw;
                hard_reset 'h0;
                doc {
                    TLP Header Fields Translation Bypass.  In this mode header fields of the translated TLP is taken from your application transmit interface or, if AMBA is configured,  from the AMBA sideband bus (slv_awmisc_info) and not from the corresponding fields of the IATU_REGION_CTRL_1_OFF_OUTBOUND_i  or IATU_REGION_CTRL_2_OFF_OUTBOUND_i registers. The header fields are
 -	TC
 -	PH
 -	TH
 -	ST
 -	AT
 -	Attr (IDO, RO and NS).
Note: This register field is sticky. 

Note: This register field is sticky.
                }
            }
            field INHIBIT_PAYLOAD @'h16 {
                access rw;
                hard_reset 'h0;
                doc {
                    Inhibit TLP Payload Data for TLP's in Matched Region; assign iATU region to be TLP without data.
When enabled and region address is matched, the iATU marks all TLPs as having no payload data by forcing the TLP header Fmt[1] bit =0, regardless of the application inputs such as slv_wstrb.
 - 1: Fmt[1] =0 so that only TLP type without data is sent. For example, a Msg instead of MsgD will be sent.
 - 0: Fmt[1] =0/1 so that TLPs with or without data can be sent. 
Note: This register field is sticky.
                }
            }
            field HEADER_SUBSTITUTE_EN @'h17 {
                access rw;
                hard_reset 'h0;
                doc {
                    Header Substitute Enable.

When enabled and region address is matched, the iATU fully substitutes bytes 8-11 (for 3 DWORD header) or bytes 12-15 (for 4 DWORD header) of the outbound TLP header with the contents of the LWR_TARGET_RW field in IATU_LWR_TARGET_ADDR_OFF_OUTBOUND_i.
 - 1: LWR_TARGET_RW in the iATU_LWR_TARGET_ADDR_OFF_OUTBOUND_i register is used to fill bytes 8-to-11 (for 3 DWORD header) or bytes 12-to-15 (for 4 DWORD header) of the translated TLP header.
 - 0: LWR_TARGET_RW in the iATU_LWR_TARGET_ADDR_OFF_OUTBOUND_i register forms the new address of the translated region.
Note: This register field is sticky.
                }
            }
            field CFG_SHIFT_MODE @'h1c {
                access rw;
                hard_reset 'h0;
                doc {
                    CFG Shift Mode.

The iATU uses bits [27:12] of the untranslated address (on the XALI0/1/2 interface or AXI slave interface address) to form the BDF number of the outgoing CFG TLP.

This supports the Enhanced Configuration Address Mapping (ECAM) mechanism (Section 7.2.2 of the PCI Express Base 3.1 Specification, revision 1.0) by allowing all outgoing I/O and MEM TLPs (that have been translated to CFG) to be mapped from memory space into any 256 MB region of the PCIe configuration space.

Note: This register field is sticky.
                }
            }
            field INVERT_MODE @'h1d {
                access rw;
                hard_reset 'h0;
                doc {
                    Invert Mode. When set the address matching region is inverted. Therefore, an address match occurs when the untranslated address is in the region outside the defined range (Base Address to Limit Address).

Note: This register field is sticky.
                }
            }
            field REGION_EN @'h1f {
                access rw;
                hard_reset 'h0;
                doc {
                    Region Enable. This bit must be set to '1' for address translation to take place.

Note: This register field is sticky.
                }
            }
            doc {
                iATU Region Control 2 Register.iATU Region Control 2 Register.
            }
        }
        register IATU_LWR_BASE_ADDR_OFF_OUTBOUND_0 @'h8 {
            bytes 4;
            field LWR_BASE_HW @'h0 {
                bits 12;
                access ro;
                hard_reset 'h0;
                doc {
                    Forms bits [n-1:0] of the start address of the address region to be translated. The start address must be aligned to a CX_ATU_MIN_REGION_SIZE kB boundary, so these bits are always 0.
A write to this location is ignored by the PCIe controller.

n is log2(CX_ATU_MIN_REGION_SIZE)
                }
            }
            field LWR_BASE_RW @'hc {
                bits 20;
                access rw;
                hard_reset 'h0;
                doc {
                    Forms bits [31:n] of the start address of the address region to be translated. 
n is log2(CX_ATU_MIN_REGION_SIZE)

Note: This register field is sticky.
                }
            }
            doc {
                iATU Lower Base Address Register. The CX_ATU_MIN_REGION_SIZE configuration parameter (Value Range: 4 kB, 8 kB, 16 kB, 32 kB, 64 kB defaults to 64 kB) specifies the minimum size of an address translation region. For example, if set to 64 kB; the lower 16 bits of the Base, Limit and Target registers are zero and all address regions are aligned on 64 kB boundaries. More precisely, the lower log2(CX_ATU_MIN_REGION_SIZE) bits are zero.iATU Lower Base Address Register. The CX_ATU_MIN_REGION_SIZE configuration parameter (Value Range: 4 kB, 8 kB, 16 kB, 32 kB, 64 kB defaults to 64 kB) specifies the minimum size of an address translation region. For example, if set to 64 kB; the lower 16 bits of the Base, Limit and Target registers are zero and all address regions are aligned on 64 kB boundaries. More precisely, the lower log2(CX_ATU_MIN_REGION_SIZE) bits are zero.
            }
        }
        register IATU_UPPER_BASE_ADDR_OFF_OUTBOUND_0 @'hc {
            bytes 4;
            field UPPER_BASE_RW @'h0 {
                bits 32;
                access rw;
                hard_reset 'h0;
                doc {
                    Forms bits [63:32] of the start (and end) address of the address region to be translated. In systems with a 32-bit address space, this register is not used and therefore writing to this register has no effect.

Note: This register field is sticky.
                }
            }
            doc {
                iATU Upper Base Address Register.iATU Upper Base Address Register.
            }
        }
        register IATU_LIMIT_ADDR_OFF_OUTBOUND_0 @'h10 {
            bytes 4;
            field LIMIT_ADDR_HW @'h0 {
                bits 12;
                access ro;
                hard_reset 'h0;
                doc {
                    Forms lower bits of the end address of the address region to be translated. The end address must be aligned to a CX_ATU_MIN_REGION_SIZE kB boundary, so these bits are always all ones.
A write to this location is ignored by the PCIe controller.
                }
            }
            field LIMIT_ADDR_RW @'hc {
                bits 20;
                access rw;
                hard_reset 'h0;
                doc {
                    Forms upper bits of the end address of the address region to be translated.

Note: This register field is sticky.
                }
            }
            doc {
                iATU Limit Address Register.iATU Limit Address Register.
            }
        }
        register IATU_LWR_TARGET_ADDR_OFF_OUTBOUND_0 @'h14 {
            bytes 4;
            field LWR_TARGET_RW_OUTBOUND @'h0 {
                bits 32;
                access rw;
                hard_reset 'h0;
                doc {
                    When HEADER_SUBSTITUTE_EN in IATU_REGION_CTRL_2_OFF_OUTBOUND_ is '0' (normal operation):
 - LWR_TARGET_RW[31:n] forms MSB's of the Lower Target part of the new address of the translated region;
 - LWR_TARGET_RW[n-1:0] are not used. (The start address must be aligned to a CX_ATU_MIN_REGION_SIZE kB boundary, so the lower bits of the start address of the new address of the translated region (bits n-1:0) are always '0').
 - n is log2(CX_ATU_MIN_REGION_SIZE).
When HEADER_SUBSTITUTE_EN in IATU_REGION_CTRL_2_OFF_OUTBOUND_i is '1':
 - LWR_TARGET_RW[31:0] forms bytes 8-11 (for 3 dword header) or bytes 12-15 (for 4 dword header) of the outbound TLP header. Usage scenarios include the transmission of Vendor Defined Messages where the controller determines the content of bytes 12 to 15 of the TLP header.
Note: This register field is sticky.
                }
            }
            doc {
                iATU Lower Target Address Register.iATU Lower Target Address Register.
            }
        }
        register IATU_UPPER_TARGET_ADDR_OFF_OUTBOUND_0 @'h18 {
            bytes 4;
            field UPPER_TARGET_RW @'h0 {
                bits 32;
                access rw;
                hard_reset 'h0;
                doc {
                    Forms bits [63:32] of the start address (Upper Target part) of the new address of the translated region.

Note: This register field is sticky.
                }
            }
            doc {
                iATU Upper Target Address Register.iATU Upper Target Address Register.
            }
        }
        register IATU_UPPR_LIMIT_ADDR_OFF_OUTBOUND_0 @'h20 {
            bytes 4;
            field UPPR_LIMIT_ADDR_RW @'h0 {
                bits 4;
                access rw;
                hard_reset 'h0;
                doc {
                    Forms the LSB's of the Upper Limit part of the region "end address" to be translated. Only applies to 64-bit systems and when the INCREASE_REGION_SIZE field in IATU_REGION_CTRL_1_OFF_OUTBOUND_i is '1'

Note: This register field is sticky.
                }
            }
            field UPPR_LIMIT_ADDR_HW @'h4 {
                bits 28;
                access ro;
                hard_reset 'h0;
                doc {
                    Forms MSB's of the Upper Limit part of the region "end address" to be translated. Only applies to 64-bit systems and when the INCREASE_REGION_SIZE field in IATU_REGION_CTRL_1_OFF_OUTBOUND_i is '1'. These bits are always '0'.
                }
            }
            doc {
                iATU Upper Limit Address Register. The CX_MAX_ATU_REGION_SIZE configuration parameter (Value Range: 0->32, 8=1TB) specifies the maximum region size of an address translation region. This register is only used when the INCREASE_REGION_SIZE field in IATU_REGION_CTRL_1_OFF_OUTBOUND_i is '1'.iATU Upper Limit Address Register. The CX_MAX_ATU_REGION_SIZE configuration parameter (Value Range: 0->32, 8=1TB) specifies the maximum region size of an address translation region. This register is only used when the INCREASE_REGION_SIZE field in IATU_REGION_CTRL_1_OFF_OUTBOUND_i is '1'.
            }
        }
        register IATU_REGION_CTRL_1_OFF_INBOUND_0 @'h100 {
            bytes 4;
            field TYPE @'h0 {
                bits 5;
                access rw;
                hard_reset 'h0;
                doc {
                    When the TYPE field of an inbound TLP is matched to this value, then address translation proceeds (when all other enabled field-matches are successful).

Note: This register field is sticky.
                }
            }
            field TC @'h5 {
                bits 3;
                access rw;
                hard_reset 'h0;
                doc {
                    When the TC field of an inbound TLP is matched to this value, then address translation proceeds (when all other enabled field-matches are successful). This check is only performed if the "TC Match Enable" bit of the "iATU Control 2 Register" is set.

Note: This register field is sticky.
                }
            }
            field TD @'h8 {
                access rw;
                hard_reset 'h0;
                doc {
                    When the TD field of an inbound TLP is matched to this value, then address translation proceeds (when all other enabled field-matches are successful). This check is only performed if the "TD Match Enable" bit of the "iATU Control 2 Register" is set.

Note: This register field is sticky.
                }
            }
            field ATTR @'h9 {
                bits 2;
                access rw;
                hard_reset 'h0;
                doc {
                    When the ATTR field of an inbound TLP is matched to this value, then address translation proceeds (when all other enabled field-matches are successful). This check is only performed if the "ATTR Match Enable" bit of the "iATU Control 2 Register" is set.

Note: This register field is sticky.
                }
            }
            field INCREASE_REGION_SIZE @'hd {
                access rw;
                hard_reset 'h0;
                doc {
                    Increase the maximum ATU Region size. When set, the maximum ATU Region size is determined by CX_ATU_MAX_REGION_SIZE. When clear, the maximum ATU Region size is 4 GB (default).

Note: This register field is sticky.
                }
            }
            field CTRL_1_FUNC_NUM @'h14 {
                bits 3;
                access rw;
                hard_reset 'h0;
                doc {
                    Function Number.
 - MEM-I/O: When the Address and BAR matching logic in the controller indicate that a MEM-I/O transaction matches a BAR in the function corresponding to this value, then address translation proceeds. This check is only performed if the "Function Number Match Enable" bit of the "iATU Control 2 Register" is set.
 - CFG0/CFG1: When the destination function number as specified in the routing ID of the TLP header matches the function, then address translation proceeds. This check is only performed if the "Function Number Match Enable" bit of the "iATU Control 2 Register" is set.
Note: This register field is sticky.
                }
            }
            doc {
                iATU Region Control 1 Register.iATU Region Control 1 Register.
            }
        }
        register IATU_REGION_CTRL_2_OFF_INBOUND_0 @'h104 {
            bytes 4;
            field MSG_CODE @'h0 {
                bits 8;
                access rw;
                hard_reset 'h0;
                doc {
                    MSG TLPs: (Message Code). When the TYPE field of an inbound Msg/MsgD TLP is matched to this value, then address translation proceeds (when all other enabled field-matches are successful). This check is only performed if the "Message Code Match Enable" bit of the "iATU Control 2 Register" is set.

Memory TLPs: (ST;Steering Tag). When the ST field of an inbound TLP is matched to this value, then address translation proceeds. This check is only performed if the "ST Match Enable" bit of the "iATU Control2 Register" is set. The setting is independent of the setting of the TH field. Only Valid when the CX_TPH_ENABLE configuration parameter is 1.

Note: This register field is sticky.
                }
            }
            field BAR_NUM @'h8 {
                bits 3;
                access rw;
                hard_reset 'h0;
                doc {
                    BAR Number. When the BAR number of an inbound MEM or IO TLP " that is matched by the normal internal BAR address matching mechanism " is the same as this field, address translation proceeds (when all other enabled field-matches are successful). This check is only performed if the "Match Mode" bit of the "iATU Control 2 Register" is set.
 - 000b - BAR0
 - 001b - BAR1
 - 010b - BAR2
 - 011b - BAR3
 - 100b - BAR4
 - 101b - BAR5
 - 110b - ROM
 - 111b - reserved
 - IO translation would require either 00100b or 00101b in the inbound TLP TYPE; the BAR Number set in the range 000b - 101b and that BAR configured as an IO BAR.
Note: This register field is sticky.
                }
            }
            field MSG_TYPE_MATCH_MODE @'hd {
                access rw;
                hard_reset 'h0;
                doc {
                    Message Type Match Mode.

When enabled, and if single address location translate enable is set, then inbound TLPs of type MSG/MSGd which match the type field of the iatu_region_ctrl_1_OFF_inbound register (=>TYPE[4:3]=2'b10) will be translated.
Message type match mode overrides any value of MATCH_MODE field in this register. Usage scenarios for this are translation of VDM or ATS messages when AXI bridge is configured on client interface.

Note: This register field is sticky.
                }
            }
            field TC_MATCH_EN @'he {
                access rw;
                hard_reset 'h0;
                doc {
                    TC Match Enable. Ensures that a successful TC TLP field comparison match (see TC field of the "iATU Control 1 Register") occurs for address translation to proceed.

Note: This register field is sticky.
                }
            }
            field TD_MATCH_EN @'hf {
                access rw;
                hard_reset 'h0;
                doc {
                    TD Match Enable. Ensures that a successful TD TLP field comparison match (see TD field of the "iATU Control 1 Register") occurs for address translation to proceed.

Note: This register field is sticky.
                }
            }
            field ATTR_MATCH_EN @'h10 {
                access rw;
                hard_reset 'h0;
                doc {
                    ATTR Match Enable. Ensures that a successful ATTR TLP field comparison match (see ATTR field of the "iATU Control 1 Register") occurs for address translation to proceed.

Note: This register field is sticky.
                }
            }
            field FUNC_NUM_MATCH_EN @'h13 {
                access rw;
                hard_reset 'h0;
                doc {
                    Function Number Match Enable. Ensures that a successful Function Number TLP field comparison match (see Function Number field of the "iATU Control 1 Register") occurs (in MEM-I/O and CFG0/CFG1 transactions) for address translation to proceed.

Note: This register field is sticky.
                }
            }
            field MSG_CODE_MATCH_EN @'h15 {
                access rw;
                hard_reset 'h0;
                doc {
                    Message Code Match Enable (Msg TLPS). Ensures that a successful message Code TLP field comparison match (see Message Code field of the "iATU Control 2 Register") occurs (in MSG transactions) for address translation to proceed.

ST Match Enable (Mem TLPs). Ensures that a successful ST TLP field comparison match (see ST field of the "iATU Control 2 Register") occurs (in MEM transactions) for address translation to proceed. Only Valid when the CX_TPH_ENABLE configuration parameter is 1

Note: This register field is sticky.
                }
            }
            field SINGLE_ADDR_LOC_TRANS_EN @'h17 {
                access rw;
                hard_reset 'h0;
                doc {
                    Single Address Location Translate Enable.

When enabled, Rx TLPs can be translated to a single address location as determined by the target address register of the iATU region.
The main usage scenario is translation of Messages (such as Vendor Defined or ATS Messages) to MWr TLPs when the AXI bridge is enabled.

Note: This register field is sticky.
                }
            }
            field RESPONSE_CODE @'h18 {
                bits 2;
                access rw;
                hard_reset 'h0;
                doc {
                    Response Code. Defines the type of response to give for accesses matching this region. This overrides the normal RADM filter response. Note that this feature is not available for any region where Single Address Location Translate is enabled.
 - 00 - Normal RADM filter response is used.
 - 01 - Unsupported request (UR)
 - 10 - Completer abort (CA)
 - 11 - Not used / undefined / reserved.
Note: This register field is sticky.
                }
            }
            field FUZZY_TYPE_MATCH_CODE @'h1b {
                access rw;
                hard_reset 'h0;
                doc {
                    Fuzzy Type Match Mode. When enabled, the iATU relaxes the matching of the TLP TYPE field against the expected TYPE field so that
 - CfgRd0 and CfgRd1 TLPs are seen as identical. Similarly with CfgWr0 and CfgWr1.
 - MWr, MRd and MRdLk TLPs are seen as identical
 - The Routing field of Msg/MsgD TLPs is ignored
 - FetchAdd, Swap and CAS are seen as identical.
For example, CFG0 in the TYPE field in the "iATU Control 1 Register" matches against an inbound CfgRd0, CfgRd1, CfgWr0 or CfgWr1 TLP.

Note: This register field is sticky.
                }
            }
            field CFG_SHIFT_MODE @'h1c {
                access rw;
                hard_reset 'h0;
                doc {
                    CFG Shift Mode. This is useful for CFG transactions where the PCIe configuration mechanism maps bits [27:12] of the address to the bus/device and function number. This allows a CFG configuration space to be located in any 256MB window of your application memory space using a 28-bit effective address. Shifts bits [31:16] of the untranslated address to form bits [27:12] of the translated address.

Note: This register field is sticky.
                }
            }
            field INVERT_MODE @'h1d {
                access rw;
                hard_reset 'h0;
                doc {
                    Invert Mode. When set the address matching region is inverted. Therefore, an address match occurs when the untranslated address is in the region outside the defined range (Base Address to Limit Address).

Note: This register field is sticky.
                }
            }
            field MATCH_MODE @'h1e {
                access rw;
                hard_reset 'h0;
                doc {
                    Match Mode. Determines Inbound matching mode for TLPs. The mode depends on the type of TLP that is received as follows:

 For MEM-I/O TLPs, this field is interpreted as follows:
 - 0: Address Match Mode. The iATU operates using addresses as in the outbound direction. The Region Base and Limit Registers must be setup.
 - 1:BAR Match Mode. BAR matching is used. The "BAR Number" field is relevant. Not used for RC.
For CFG0 TLPs, this field is interpreted as follows:
 - 0: Routing ID Match Mode. The iATU interprets the Routing ID (Bytes 8 to 11 of TLP header) as an address. This corresponds to the upper 16 bits of the address in MEM-I/O transactions. The Routing ID of the TLP must be within the base and limit of the iATU region for matching to proceed.
 - 1: Accept Mode. The iATU accepts all CFG0 transactions as address matches. The routing ID in the CFG0 TLP is ignored. This is useful as all received CFG0 TLPs should be processed regardless of the Bus number.
For MSG/MSGD TLPs, this field is interpreted as follows:
 - 0: Address Match Mode. The iATU treats the third dword and fourth dword of the inbound MSG/MSGD TLP as an address and it is matched against the Region Base and Limit Registers.
 - 1: Vendor ID Match Mode. This mode is relevant for ID-routed Vendor Defined Messages. The iATU ignores the Routing ID (Bus, Device, Function) in bits [31:16] of the third dword of the TLP header, but matches against the Vendor ID in bits [15:0] of the third dword of the TLP header. Bits [15:0] of the Region Upper Base register should be programmed with the required Vendor ID. The lower Base and Limit Register should be programmed to translate TLPs based on vendor specific information in the fourth dword of the TLP header.
 -	If SINGLE_ADDRESS_LOCATION_TRANSLATE_EN = 1 AND MSG_TYPE_MATCH_MODE = 1, then Match Mode is ignored.
Note: This register field is sticky.
                }
            }
            field REGION_EN @'h1f {
                access rw;
                hard_reset 'h0;
                doc {
                    Region Enable. This bit must be set to '1' for address translation to take place.

Note: This register field is sticky.
                }
            }
            doc {
                iATU Region Control 2 Register.iATU Region Control 2 Register.
            }
        }
        register IATU_LWR_BASE_ADDR_OFF_INBOUND_0 @'h108 {
            bytes 4;
            field LWR_BASE_HW @'h0 {
                bits 12;
                access ro;
                hard_reset 'h0;
                doc {
                    Forms bits [n-1:0] of the start address of the address region to be translated. The start address must be aligned to a CX_ATU_MIN_REGION_SIZE kB boundary, so these bits are always 0.
A write to this location is ignored by the PCIe controller.

n is log2(CX_ATU_MIN_REGION_SIZE)
                }
            }
            field LWR_BASE_RW @'hc {
                bits 20;
                access rw;
                hard_reset 'h0;
                doc {
                    Forms bits [31:n] of the start address of the address region to be translated. 
n is log2(CX_ATU_MIN_REGION_SIZE)

Note: This register field is sticky.
                }
            }
            doc {
                iATU Lower Base Address Register. The CX_ATU_MIN_REGION_SIZE configuration parameter (Value Range: 4 kB, 8 kB, 16 kB, 32 kB, 64 kB defaults to 64 kB) specifies the minimum size of an address translation region. For example, if set to 64 kB; the lower 16 bits of the Base, Limit and Target registers are zero and all address regions are aligned on 64 kB boundaries. More precisely, the lower log2(CX_ATU_MIN_REGION_SIZE) bits are zero.iATU Lower Base Address Register. The CX_ATU_MIN_REGION_SIZE configuration parameter (Value Range: 4 kB, 8 kB, 16 kB, 32 kB, 64 kB defaults to 64 kB) specifies the minimum size of an address translation region. For example, if set to 64 kB; the lower 16 bits of the Base, Limit and Target registers are zero and all address regions are aligned on 64 kB boundaries. More precisely, the lower log2(CX_ATU_MIN_REGION_SIZE) bits are zero.
            }
        }
        register IATU_UPPER_BASE_ADDR_OFF_INBOUND_0 @'h10c {
            bytes 4;
            field UPPER_BASE_RW @'h0 {
                bits 32;
                access rw;
                hard_reset 'h0;
                doc {
                    Forms bits [63:32] of the start (and end) address of the address region to be translated.

Note: This register field is sticky.
                }
            }
            doc {
                iATU Upper Base Address Register.iATU Upper Base Address Register.
            }
        }
        register IATU_LIMIT_ADDR_OFF_INBOUND_0 @'h110 {
            bytes 4;
            field LIMIT_ADDR_HW @'h0 {
                bits 12;
                access ro;
                hard_reset 'h0;
                doc {
                    Forms lower bits of the end address of the address region to be translated. The end address must be aligned to a CX_ATU_MIN_REGION_SIZE kB boundary, so these bits are always all ones.
A write to this location is ignored by the PCIe controller.
                }
            }
            field LIMIT_ADDR_RW @'hc {
                bits 20;
                access rw;
                hard_reset 'h0;
                doc {
                    Forms upper bits of the end address of the address region to be translated.

Note: This register field is sticky.
                }
            }
            doc {
                iATU Limit Address Register.iATU Limit Address Register.
            }
        }
        register IATU_LWR_TARGET_ADDR_OFF_INBOUND_0 @'h114 {
            bytes 4;
            field LWR_TARGET_HW @'h0 {
                bits 12;
                access ro;
                hard_reset 'h0;
                doc {
                    Forms the LSB's of the Lower Target part of the new address of the translated region. The start address must be aligned to a CX_ATU_MIN_REGION_SIZE kB boundary (in address match mode); and to the Bar size boundary (in BAR match mode) so that these bits are always '0'. If the BAR is smaller than the iATU region size, then the iATU target address must align to the iATU region size; otherwise it must align to the BAR size.

A write to this location is ignored by the PCIe controller.
 - Field size depends on log2(CX_ATU_MIN_REGION_SIZE) in address match mode.
 - Field size depends on log2(BAR_MASK+1) in BAR match mode.
                }
            }
            field LWR_TARGET_RW @'hc {
                bits 20;
                access rw;
                hard_reset 'h0;
                doc {
                    Forms MSB's of the Lower Target part of the new address of the translated region. These bits are always '0'.
 - Field size depends on log2(CX_ATU_MIN_REGION_SIZE) in address match mode.
 - Field size depends on log2(BAR_MASK+1) in BAR match mode.
Note: This register field is sticky.
                }
            }
            doc {
                iATU Lower Target Address Register.iATU Lower Target Address Register.
            }
        }
        register IATU_UPPER_TARGET_ADDR_OFF_INBOUND_0 @'h118 {
            bytes 4;
            field UPPER_TARGET_RW @'h0 {
                bits 32;
                access rw;
                hard_reset 'h0;
                doc {
                    Forms bits [63:32] of the start address (Upper Target part) of the new address of the translated region. In systems with a 32-bit address space, this register is not used and therefore writing to this register has no effect.

Note: This register field is sticky.
                }
            }
            doc {
                iATU Upper Target Address Register.iATU Upper Target Address Register.
            }
        }
        register IATU_UPPR_LIMIT_ADDR_OFF_INBOUND_0 @'h120 {
            bytes 4;
            field UPPR_LIMIT_ADDR_RW @'h0 {
                bits 4;
                access rw;
                hard_reset 'h0;
                doc {
                    Forms the LSB's of the Upper Limit part of the region "end address" to be translated. Only applies to 64-bit systems and when the INCREASE_REGION_SIZE field in IATU_REGION_CTRL_1_OFF_INBOUND_i is '1'

Note: This register field is sticky.
                }
            }
            field UPPR_LIMIT_ADDR_HW @'h4 {
                bits 28;
                access ro;
                hard_reset 'h0;
                doc {
                    Forms MSB's of the Upper Limit part of the region "end address" to be translated. Only applies to 64-bit systems and when the INCREASE_REGION_SIZE field in IATU_REGION_CTRL_1_OFF_INBOUND_i is '1'. These bits are always '0'.
                }
            }
            doc {
                iATU Upper Limit Address Register. The CX_MAX_ATU_REGION_SIZE configuration parameter (Value Range: 0->32, 8=1TB) specifies the maximum region size of an address translation region. This register is only used when the INCREASE_REGION_SIZE field in IATU_REGION_CTRL_1_OFF_INBOUND_i is '1'.iATU Upper Limit Address Register. The CX_MAX_ATU_REGION_SIZE configuration parameter (Value Range: 0->32, 8=1TB) specifies the maximum region size of an address translation region. This register is only used when the INCREASE_REGION_SIZE field in IATU_REGION_CTRL_1_OFF_INBOUND_i is '1'.
            }
        }
        register IATU_REGION_CTRL_1_OFF_OUTBOUND_1 @'h200 {
            bytes 4;
            field TYPE @'h0 {
                bits 5;
                access rw;
                hard_reset 'h0;
                doc {
                    When the address of an outbound TLP is matched to this region, then the TYPE field of the TLP is changed to the value in this register.

Note: This register field is sticky.
                }
            }
            field TC @'h5 {
                bits 3;
                access rw;
                hard_reset 'h0;
                doc {
                    When the address of an outbound TLP is matched to this region, then the TC field of the TLP is changed to the value in this register.

Note: This register field is sticky.
                }
            }
            field TD @'h8 {
                access rw;
                hard_reset 'h0;
                doc {
                    This is a reserved field. Do not use.

Note: This register field is sticky.
                }
            }
            field ATTR @'h9 {
                bits 2;
                access rw;
                hard_reset 'h0;
                doc {
                    When the address of an outbound TLP is matched to this region, then the ATTR field of the TLP is changed to the value in this register.

Note: This register field is sticky.
                }
            }
            field INCREASE_REGION_SIZE @'hd {
                access rw;
                hard_reset 'h0;
                doc {
                    Increase the maximum ATU Region size. When set, the maximum ATU Region size is determined by CX_ATU_MAX_REGION_SIZE. When clear, the maximum ATU Region size is 4 GB (default).

Note: This register field is sticky.
                }
            }
            field CTRL_1_FUNC_NUM @'h14 {
                bits 3;
                access rw;
                hard_reset 'h0;
                doc {
                    Function Number.
 - When the address of an outbound TLP is matched to this region and the FUNC_BYPASS field in the "iATU Control 2 Register" is '0', then the function number used in generating the function part of the requester ID (RID) field of the TLP is taken from this 5-bit register. The value in this register must be 0x0 unless multifunction operation in the controller is enabled (CX_NFUNC > 1).
 - When you are using the AXI Bridge, then this field is swapped before AXI decomposition occurs so that the correct "Max_Read_Request_Size" and "Max_Payload_Size" values are used.

Note: This register field is sticky.
                }
            }
            doc {
                iATU Region Control 1 Register.iATU Region Control 1 Register.
            }
        }
        register IATU_REGION_CTRL_2_OFF_OUTBOUND_1 @'h204 {
            bytes 4;
            field MSG_CODE @'h0 {
                bits 8;
                access rw;
                hard_reset 'h0;
                doc {
                    MSG TLPs (Message Code). When the address of an outbound TLP is matched to this region, and the translated TLP TYPE field is Msg or MsgD; then the message field of the TLP is changed to the value in this register.

Memory TLPs: (ST;Steering Tag). When the ST field of an outbound TLP is matched to this region, and the translated TLP TYPE field targets memory space; then the ST field of the TLP is changed to the value in this register. Only Valid when the CX_TPH_ENABLE configuration parameter is 1.

Note: This register field is sticky.
                }
            }
            field TAG @'h8 {
                bits 8;
                access rw;
                hard_reset 'h0;
                doc {
                    TAG.

The substituted TAG field (byte 6) in the outgoing TLP header when TAG_SUBSTITUTE_EN is set.

Note: This register field is sticky.
                }
            }
            field TAG_SUBSTITUTE_EN @'h10 {
                access rw;
                hard_reset 'h0;
                doc {
                    TAG Substitute Enable.

When enabled and region address is matched, the iATU substitutes the TAG field of the outbound TLP header with the contents of the TAG field in this register. The expected usage scenario is translation from AXI MWr to Vendor Defined Msg/MsgD.

Note (CX_TPH_ENABLE=1): TAG substitution for MWr will not occur because this field (byte 6) in the TLP header is the ST field. ST substitution can still take place using the MSG_CODE field in IATU_REGION_CTRL_2_OFF_OUTBOUND_i.

Note: This register field is sticky.
                }
            }
            field MSB2BITS_TAG @'h11 {
                bits 2;
                access rw;
                hard_reset 'h0;
                doc {
                    TAG.

Two most significant bits of the substituted TAG field in the outgoing TLP header when TAG_SUBSTITUTE_EN is set. 

Note: This register field is sticky.
                }
            }
            field FUNC_BYPASS @'h13 {
                access rw;
                hard_reset 'h0;
                doc {
                    Function Number Translation Bypass. In this mode, the function number of the translated TLP is taken from your application transmit interface and not from the CTRL_1_FUNC_NUM field of the "iATU Control 1 Register" or the VF_NUMBER field of the "iATU Control 3 Register."

Note: This register field is sticky.
                }
            }
            field SNP @'h14 {
                access rw;
                hard_reset 'h0;
                doc {
                    Serialize Non-Posted Requests. In this mode, when the AXI Bridge is populated, same AXI ID Non-Posted Read/Write Requests are transmitted on the wire if there are no other same ID Non-Posted Requests outstanding.

Note: This register field is sticky.
                }
            }
            field TLP_HEADER_FIELDS_BYPASS @'h15 {
                access rw;
                hard_reset 'h0;
                doc {
                    TLP Header Fields Translation Bypass.  In this mode header fields of the translated TLP is taken from your application transmit interface or, if AMBA is configured,  from the AMBA sideband bus (slv_awmisc_info) and not from the corresponding fields of the IATU_REGION_CTRL_1_OFF_OUTBOUND_i  or IATU_REGION_CTRL_2_OFF_OUTBOUND_i registers. The header fields are
 -	TC
 -	PH
 -	TH
 -	ST
 -	AT
 -	Attr (IDO, RO and NS).
Note: This register field is sticky. 

Note: This register field is sticky.
                }
            }
            field INHIBIT_PAYLOAD @'h16 {
                access rw;
                hard_reset 'h0;
                doc {
                    Inhibit TLP Payload Data for TLP's in Matched Region; assign iATU region to be TLP without data.
When enabled and region address is matched, the iATU marks all TLPs as having no payload data by forcing the TLP header Fmt[1] bit =0, regardless of the application inputs such as slv_wstrb.
 - 1: Fmt[1] =0 so that only TLP type without data is sent. For example, a Msg instead of MsgD will be sent.
 - 0: Fmt[1] =0/1 so that TLPs with or without data can be sent. 
Note: This register field is sticky.
                }
            }
            field HEADER_SUBSTITUTE_EN @'h17 {
                access rw;
                hard_reset 'h0;
                doc {
                    Header Substitute Enable.

When enabled and region address is matched, the iATU fully substitutes bytes 8-11 (for 3 DWORD header) or bytes 12-15 (for 4 DWORD header) of the outbound TLP header with the contents of the LWR_TARGET_RW field in IATU_LWR_TARGET_ADDR_OFF_OUTBOUND_i.
 - 1: LWR_TARGET_RW in the iATU_LWR_TARGET_ADDR_OFF_OUTBOUND_i register is used to fill bytes 8-to-11 (for 3 DWORD header) or bytes 12-to-15 (for 4 DWORD header) of the translated TLP header.
 - 0: LWR_TARGET_RW in the iATU_LWR_TARGET_ADDR_OFF_OUTBOUND_i register forms the new address of the translated region.
Note: This register field is sticky.
                }
            }
            field CFG_SHIFT_MODE @'h1c {
                access rw;
                hard_reset 'h0;
                doc {
                    CFG Shift Mode.

The iATU uses bits [27:12] of the untranslated address (on the XALI0/1/2 interface or AXI slave interface address) to form the BDF number of the outgoing CFG TLP.

This supports the Enhanced Configuration Address Mapping (ECAM) mechanism (Section 7.2.2 of the PCI Express Base 3.1 Specification, revision 1.0) by allowing all outgoing I/O and MEM TLPs (that have been translated to CFG) to be mapped from memory space into any 256 MB region of the PCIe configuration space.

Note: This register field is sticky.
                }
            }
            field INVERT_MODE @'h1d {
                access rw;
                hard_reset 'h0;
                doc {
                    Invert Mode. When set the address matching region is inverted. Therefore, an address match occurs when the untranslated address is in the region outside the defined range (Base Address to Limit Address).

Note: This register field is sticky.
                }
            }
            field REGION_EN @'h1f {
                access rw;
                hard_reset 'h0;
                doc {
                    Region Enable. This bit must be set to '1' for address translation to take place.

Note: This register field is sticky.
                }
            }
            doc {
                iATU Region Control 2 Register.iATU Region Control 2 Register.
            }
        }
        register IATU_LWR_BASE_ADDR_OFF_OUTBOUND_1 @'h208 {
            bytes 4;
            field LWR_BASE_HW @'h0 {
                bits 12;
                access ro;
                hard_reset 'h0;
                doc {
                    Forms bits [n-1:0] of the start address of the address region to be translated. The start address must be aligned to a CX_ATU_MIN_REGION_SIZE kB boundary, so these bits are always 0.
A write to this location is ignored by the PCIe controller.

n is log2(CX_ATU_MIN_REGION_SIZE)
                }
            }
            field LWR_BASE_RW @'hc {
                bits 20;
                access rw;
                hard_reset 'h0;
                doc {
                    Forms bits [31:n] of the start address of the address region to be translated. 
n is log2(CX_ATU_MIN_REGION_SIZE)

Note: This register field is sticky.
                }
            }
            doc {
                iATU Lower Base Address Register. The CX_ATU_MIN_REGION_SIZE configuration parameter (Value Range: 4 kB, 8 kB, 16 kB, 32 kB, 64 kB defaults to 64 kB) specifies the minimum size of an address translation region. For example, if set to 64 kB; the lower 16 bits of the Base, Limit and Target registers are zero and all address regions are aligned on 64 kB boundaries. More precisely, the lower log2(CX_ATU_MIN_REGION_SIZE) bits are zero.iATU Lower Base Address Register. The CX_ATU_MIN_REGION_SIZE configuration parameter (Value Range: 4 kB, 8 kB, 16 kB, 32 kB, 64 kB defaults to 64 kB) specifies the minimum size of an address translation region. For example, if set to 64 kB; the lower 16 bits of the Base, Limit and Target registers are zero and all address regions are aligned on 64 kB boundaries. More precisely, the lower log2(CX_ATU_MIN_REGION_SIZE) bits are zero.
            }
        }
        register IATU_UPPER_BASE_ADDR_OFF_OUTBOUND_1 @'h20c {
            bytes 4;
            field UPPER_BASE_RW @'h0 {
                bits 32;
                access rw;
                hard_reset 'h0;
                doc {
                    Forms bits [63:32] of the start (and end) address of the address region to be translated. In systems with a 32-bit address space, this register is not used and therefore writing to this register has no effect.

Note: This register field is sticky.
                }
            }
            doc {
                iATU Upper Base Address Register.iATU Upper Base Address Register.
            }
        }
        register IATU_LIMIT_ADDR_OFF_OUTBOUND_1 @'h210 {
            bytes 4;
            field LIMIT_ADDR_HW @'h0 {
                bits 12;
                access ro;
                hard_reset 'h0;
                doc {
                    Forms lower bits of the end address of the address region to be translated. The end address must be aligned to a CX_ATU_MIN_REGION_SIZE kB boundary, so these bits are always all ones.
A write to this location is ignored by the PCIe controller.
                }
            }
            field LIMIT_ADDR_RW @'hc {
                bits 20;
                access rw;
                hard_reset 'h0;
                doc {
                    Forms upper bits of the end address of the address region to be translated.

Note: This register field is sticky.
                }
            }
            doc {
                iATU Limit Address Register.iATU Limit Address Register.
            }
        }
        register IATU_LWR_TARGET_ADDR_OFF_OUTBOUND_1 @'h214 {
            bytes 4;
            field LWR_TARGET_RW_OUTBOUND @'h0 {
                bits 32;
                access rw;
                hard_reset 'h0;
                doc {
                    When HEADER_SUBSTITUTE_EN in IATU_REGION_CTRL_2_OFF_OUTBOUND_ is '0' (normal operation):
 - LWR_TARGET_RW[31:n] forms MSB's of the Lower Target part of the new address of the translated region;
 - LWR_TARGET_RW[n-1:0] are not used. (The start address must be aligned to a CX_ATU_MIN_REGION_SIZE kB boundary, so the lower bits of the start address of the new address of the translated region (bits n-1:0) are always '0').
 - n is log2(CX_ATU_MIN_REGION_SIZE).
When HEADER_SUBSTITUTE_EN in IATU_REGION_CTRL_2_OFF_OUTBOUND_i is '1':
 - LWR_TARGET_RW[31:0] forms bytes 8-11 (for 3 dword header) or bytes 12-15 (for 4 dword header) of the outbound TLP header. Usage scenarios include the transmission of Vendor Defined Messages where the controller determines the content of bytes 12 to 15 of the TLP header.
Note: This register field is sticky.
                }
            }
            doc {
                iATU Lower Target Address Register.iATU Lower Target Address Register.
            }
        }
        register IATU_UPPER_TARGET_ADDR_OFF_OUTBOUND_1 @'h218 {
            bytes 4;
            field UPPER_TARGET_RW @'h0 {
                bits 32;
                access rw;
                hard_reset 'h0;
                doc {
                    Forms bits [63:32] of the start address (Upper Target part) of the new address of the translated region.

Note: This register field is sticky.
                }
            }
            doc {
                iATU Upper Target Address Register.iATU Upper Target Address Register.
            }
        }
        register IATU_UPPR_LIMIT_ADDR_OFF_OUTBOUND_1 @'h220 {
            bytes 4;
            field UPPR_LIMIT_ADDR_RW @'h0 {
                bits 4;
                access rw;
                hard_reset 'h0;
                doc {
                    Forms the LSB's of the Upper Limit part of the region "end address" to be translated. Only applies to 64-bit systems and when the INCREASE_REGION_SIZE field in IATU_REGION_CTRL_1_OFF_OUTBOUND_i is '1'

Note: This register field is sticky.
                }
            }
            field UPPR_LIMIT_ADDR_HW @'h4 {
                bits 28;
                access ro;
                hard_reset 'h0;
                doc {
                    Forms MSB's of the Upper Limit part of the region "end address" to be translated. Only applies to 64-bit systems and when the INCREASE_REGION_SIZE field in IATU_REGION_CTRL_1_OFF_OUTBOUND_i is '1'. These bits are always '0'.
                }
            }
            doc {
                iATU Upper Limit Address Register. The CX_MAX_ATU_REGION_SIZE configuration parameter (Value Range: 0->32, 8=1TB) specifies the maximum region size of an address translation region. This register is only used when the INCREASE_REGION_SIZE field in IATU_REGION_CTRL_1_OFF_OUTBOUND_i is '1'.iATU Upper Limit Address Register. The CX_MAX_ATU_REGION_SIZE configuration parameter (Value Range: 0->32, 8=1TB) specifies the maximum region size of an address translation region. This register is only used when the INCREASE_REGION_SIZE field in IATU_REGION_CTRL_1_OFF_OUTBOUND_i is '1'.
            }
        }
        register IATU_REGION_CTRL_1_OFF_INBOUND_1 @'h300 {
            bytes 4;
            field TYPE @'h0 {
                bits 5;
                access rw;
                hard_reset 'h0;
                doc {
                    When the TYPE field of an inbound TLP is matched to this value, then address translation proceeds (when all other enabled field-matches are successful).

Note: This register field is sticky.
                }
            }
            field TC @'h5 {
                bits 3;
                access rw;
                hard_reset 'h0;
                doc {
                    When the TC field of an inbound TLP is matched to this value, then address translation proceeds (when all other enabled field-matches are successful). This check is only performed if the "TC Match Enable" bit of the "iATU Control 2 Register" is set.

Note: This register field is sticky.
                }
            }
            field TD @'h8 {
                access rw;
                hard_reset 'h0;
                doc {
                    When the TD field of an inbound TLP is matched to this value, then address translation proceeds (when all other enabled field-matches are successful). This check is only performed if the "TD Match Enable" bit of the "iATU Control 2 Register" is set.

Note: This register field is sticky.
                }
            }
            field ATTR @'h9 {
                bits 2;
                access rw;
                hard_reset 'h0;
                doc {
                    When the ATTR field of an inbound TLP is matched to this value, then address translation proceeds (when all other enabled field-matches are successful). This check is only performed if the "ATTR Match Enable" bit of the "iATU Control 2 Register" is set.

Note: This register field is sticky.
                }
            }
            field INCREASE_REGION_SIZE @'hd {
                access rw;
                hard_reset 'h0;
                doc {
                    Increase the maximum ATU Region size. When set, the maximum ATU Region size is determined by CX_ATU_MAX_REGION_SIZE. When clear, the maximum ATU Region size is 4 GB (default).

Note: This register field is sticky.
                }
            }
            field CTRL_1_FUNC_NUM @'h14 {
                bits 3;
                access rw;
                hard_reset 'h0;
                doc {
                    Function Number.
 - MEM-I/O: When the Address and BAR matching logic in the controller indicate that a MEM-I/O transaction matches a BAR in the function corresponding to this value, then address translation proceeds. This check is only performed if the "Function Number Match Enable" bit of the "iATU Control 2 Register" is set.
 - CFG0/CFG1: When the destination function number as specified in the routing ID of the TLP header matches the function, then address translation proceeds. This check is only performed if the "Function Number Match Enable" bit of the "iATU Control 2 Register" is set.
Note: This register field is sticky.
                }
            }
            doc {
                iATU Region Control 1 Register.iATU Region Control 1 Register.
            }
        }
        register IATU_REGION_CTRL_2_OFF_INBOUND_1 @'h304 {
            bytes 4;
            field MSG_CODE @'h0 {
                bits 8;
                access rw;
                hard_reset 'h0;
                doc {
                    MSG TLPs: (Message Code). When the TYPE field of an inbound Msg/MsgD TLP is matched to this value, then address translation proceeds (when all other enabled field-matches are successful). This check is only performed if the "Message Code Match Enable" bit of the "iATU Control 2 Register" is set.

Memory TLPs: (ST;Steering Tag). When the ST field of an inbound TLP is matched to this value, then address translation proceeds. This check is only performed if the "ST Match Enable" bit of the "iATU Control2 Register" is set. The setting is independent of the setting of the TH field. Only Valid when the CX_TPH_ENABLE configuration parameter is 1.

Note: This register field is sticky.
                }
            }
            field BAR_NUM @'h8 {
                bits 3;
                access rw;
                hard_reset 'h0;
                doc {
                    BAR Number. When the BAR number of an inbound MEM or IO TLP " that is matched by the normal internal BAR address matching mechanism " is the same as this field, address translation proceeds (when all other enabled field-matches are successful). This check is only performed if the "Match Mode" bit of the "iATU Control 2 Register" is set.
 - 000b - BAR0
 - 001b - BAR1
 - 010b - BAR2
 - 011b - BAR3
 - 100b - BAR4
 - 101b - BAR5
 - 110b - ROM
 - 111b - reserved
 - IO translation would require either 00100b or 00101b in the inbound TLP TYPE; the BAR Number set in the range 000b - 101b and that BAR configured as an IO BAR.
Note: This register field is sticky.
                }
            }
            field MSG_TYPE_MATCH_MODE @'hd {
                access rw;
                hard_reset 'h0;
                doc {
                    Message Type Match Mode.

When enabled, and if single address location translate enable is set, then inbound TLPs of type MSG/MSGd which match the type field of the iatu_region_ctrl_1_OFF_inbound register (=>TYPE[4:3]=2'b10) will be translated.
Message type match mode overrides any value of MATCH_MODE field in this register. Usage scenarios for this are translation of VDM or ATS messages when AXI bridge is configured on client interface.

Note: This register field is sticky.
                }
            }
            field TC_MATCH_EN @'he {
                access rw;
                hard_reset 'h0;
                doc {
                    TC Match Enable. Ensures that a successful TC TLP field comparison match (see TC field of the "iATU Control 1 Register") occurs for address translation to proceed.

Note: This register field is sticky.
                }
            }
            field TD_MATCH_EN @'hf {
                access rw;
                hard_reset 'h0;
                doc {
                    TD Match Enable. Ensures that a successful TD TLP field comparison match (see TD field of the "iATU Control 1 Register") occurs for address translation to proceed.

Note: This register field is sticky.
                }
            }
            field ATTR_MATCH_EN @'h10 {
                access rw;
                hard_reset 'h0;
                doc {
                    ATTR Match Enable. Ensures that a successful ATTR TLP field comparison match (see ATTR field of the "iATU Control 1 Register") occurs for address translation to proceed.

Note: This register field is sticky.
                }
            }
            field FUNC_NUM_MATCH_EN @'h13 {
                access rw;
                hard_reset 'h0;
                doc {
                    Function Number Match Enable. Ensures that a successful Function Number TLP field comparison match (see Function Number field of the "iATU Control 1 Register") occurs (in MEM-I/O and CFG0/CFG1 transactions) for address translation to proceed.

Note: This register field is sticky.
                }
            }
            field MSG_CODE_MATCH_EN @'h15 {
                access rw;
                hard_reset 'h0;
                doc {
                    Message Code Match Enable (Msg TLPS). Ensures that a successful message Code TLP field comparison match (see Message Code field of the "iATU Control 2 Register") occurs (in MSG transactions) for address translation to proceed.

ST Match Enable (Mem TLPs). Ensures that a successful ST TLP field comparison match (see ST field of the "iATU Control 2 Register") occurs (in MEM transactions) for address translation to proceed. Only Valid when the CX_TPH_ENABLE configuration parameter is 1

Note: This register field is sticky.
                }
            }
            field SINGLE_ADDR_LOC_TRANS_EN @'h17 {
                access rw;
                hard_reset 'h0;
                doc {
                    Single Address Location Translate Enable.

When enabled, Rx TLPs can be translated to a single address location as determined by the target address register of the iATU region.
The main usage scenario is translation of Messages (such as Vendor Defined or ATS Messages) to MWr TLPs when the AXI bridge is enabled.

Note: This register field is sticky.
                }
            }
            field RESPONSE_CODE @'h18 {
                bits 2;
                access rw;
                hard_reset 'h0;
                doc {
                    Response Code. Defines the type of response to give for accesses matching this region. This overrides the normal RADM filter response. Note that this feature is not available for any region where Single Address Location Translate is enabled.
 - 00 - Normal RADM filter response is used.
 - 01 - Unsupported request (UR)
 - 10 - Completer abort (CA)
 - 11 - Not used / undefined / reserved.
Note: This register field is sticky.
                }
            }
            field FUZZY_TYPE_MATCH_CODE @'h1b {
                access rw;
                hard_reset 'h0;
                doc {
                    Fuzzy Type Match Mode. When enabled, the iATU relaxes the matching of the TLP TYPE field against the expected TYPE field so that
 - CfgRd0 and CfgRd1 TLPs are seen as identical. Similarly with CfgWr0 and CfgWr1.
 - MWr, MRd and MRdLk TLPs are seen as identical
 - The Routing field of Msg/MsgD TLPs is ignored
 - FetchAdd, Swap and CAS are seen as identical.
For example, CFG0 in the TYPE field in the "iATU Control 1 Register" matches against an inbound CfgRd0, CfgRd1, CfgWr0 or CfgWr1 TLP.

Note: This register field is sticky.
                }
            }
            field CFG_SHIFT_MODE @'h1c {
                access rw;
                hard_reset 'h0;
                doc {
                    CFG Shift Mode. This is useful for CFG transactions where the PCIe configuration mechanism maps bits [27:12] of the address to the bus/device and function number. This allows a CFG configuration space to be located in any 256MB window of your application memory space using a 28-bit effective address. Shifts bits [31:16] of the untranslated address to form bits [27:12] of the translated address.

Note: This register field is sticky.
                }
            }
            field INVERT_MODE @'h1d {
                access rw;
                hard_reset 'h0;
                doc {
                    Invert Mode. When set the address matching region is inverted. Therefore, an address match occurs when the untranslated address is in the region outside the defined range (Base Address to Limit Address).

Note: This register field is sticky.
                }
            }
            field MATCH_MODE @'h1e {
                access rw;
                hard_reset 'h0;
                doc {
                    Match Mode. Determines Inbound matching mode for TLPs. The mode depends on the type of TLP that is received as follows:

 For MEM-I/O TLPs, this field is interpreted as follows:
 - 0: Address Match Mode. The iATU operates using addresses as in the outbound direction. The Region Base and Limit Registers must be setup.
 - 1:BAR Match Mode. BAR matching is used. The "BAR Number" field is relevant. Not used for RC.
For CFG0 TLPs, this field is interpreted as follows:
 - 0: Routing ID Match Mode. The iATU interprets the Routing ID (Bytes 8 to 11 of TLP header) as an address. This corresponds to the upper 16 bits of the address in MEM-I/O transactions. The Routing ID of the TLP must be within the base and limit of the iATU region for matching to proceed.
 - 1: Accept Mode. The iATU accepts all CFG0 transactions as address matches. The routing ID in the CFG0 TLP is ignored. This is useful as all received CFG0 TLPs should be processed regardless of the Bus number.
For MSG/MSGD TLPs, this field is interpreted as follows:
 - 0: Address Match Mode. The iATU treats the third dword and fourth dword of the inbound MSG/MSGD TLP as an address and it is matched against the Region Base and Limit Registers.
 - 1: Vendor ID Match Mode. This mode is relevant for ID-routed Vendor Defined Messages. The iATU ignores the Routing ID (Bus, Device, Function) in bits [31:16] of the third dword of the TLP header, but matches against the Vendor ID in bits [15:0] of the third dword of the TLP header. Bits [15:0] of the Region Upper Base register should be programmed with the required Vendor ID. The lower Base and Limit Register should be programmed to translate TLPs based on vendor specific information in the fourth dword of the TLP header.
 -	If SINGLE_ADDRESS_LOCATION_TRANSLATE_EN = 1 AND MSG_TYPE_MATCH_MODE = 1, then Match Mode is ignored.
Note: This register field is sticky.
                }
            }
            field REGION_EN @'h1f {
                access rw;
                hard_reset 'h0;
                doc {
                    Region Enable. This bit must be set to '1' for address translation to take place.

Note: This register field is sticky.
                }
            }
            doc {
                iATU Region Control 2 Register.iATU Region Control 2 Register.
            }
        }
        register IATU_LWR_BASE_ADDR_OFF_INBOUND_1 @'h308 {
            bytes 4;
            field LWR_BASE_HW @'h0 {
                bits 12;
                access ro;
                hard_reset 'h0;
                doc {
                    Forms bits [n-1:0] of the start address of the address region to be translated. The start address must be aligned to a CX_ATU_MIN_REGION_SIZE kB boundary, so these bits are always 0.
A write to this location is ignored by the PCIe controller.

n is log2(CX_ATU_MIN_REGION_SIZE)
                }
            }
            field LWR_BASE_RW @'hc {
                bits 20;
                access rw;
                hard_reset 'h0;
                doc {
                    Forms bits [31:n] of the start address of the address region to be translated. 
n is log2(CX_ATU_MIN_REGION_SIZE)

Note: This register field is sticky.
                }
            }
            doc {
                iATU Lower Base Address Register. The CX_ATU_MIN_REGION_SIZE configuration parameter (Value Range: 4 kB, 8 kB, 16 kB, 32 kB, 64 kB defaults to 64 kB) specifies the minimum size of an address translation region. For example, if set to 64 kB; the lower 16 bits of the Base, Limit and Target registers are zero and all address regions are aligned on 64 kB boundaries. More precisely, the lower log2(CX_ATU_MIN_REGION_SIZE) bits are zero.iATU Lower Base Address Register. The CX_ATU_MIN_REGION_SIZE configuration parameter (Value Range: 4 kB, 8 kB, 16 kB, 32 kB, 64 kB defaults to 64 kB) specifies the minimum size of an address translation region. For example, if set to 64 kB; the lower 16 bits of the Base, Limit and Target registers are zero and all address regions are aligned on 64 kB boundaries. More precisely, the lower log2(CX_ATU_MIN_REGION_SIZE) bits are zero.
            }
        }
        register IATU_UPPER_BASE_ADDR_OFF_INBOUND_1 @'h30c {
            bytes 4;
            field UPPER_BASE_RW @'h0 {
                bits 32;
                access rw;
                hard_reset 'h0;
                doc {
                    Forms bits [63:32] of the start (and end) address of the address region to be translated.

Note: This register field is sticky.
                }
            }
            doc {
                iATU Upper Base Address Register.iATU Upper Base Address Register.
            }
        }
        register IATU_LIMIT_ADDR_OFF_INBOUND_1 @'h310 {
            bytes 4;
            field LIMIT_ADDR_HW @'h0 {
                bits 12;
                access ro;
                hard_reset 'h0;
                doc {
                    Forms lower bits of the end address of the address region to be translated. The end address must be aligned to a CX_ATU_MIN_REGION_SIZE kB boundary, so these bits are always all ones.
A write to this location is ignored by the PCIe controller.
                }
            }
            field LIMIT_ADDR_RW @'hc {
                bits 20;
                access rw;
                hard_reset 'h0;
                doc {
                    Forms upper bits of the end address of the address region to be translated.

Note: This register field is sticky.
                }
            }
            doc {
                iATU Limit Address Register.iATU Limit Address Register.
            }
        }
        register IATU_LWR_TARGET_ADDR_OFF_INBOUND_1 @'h314 {
            bytes 4;
            field LWR_TARGET_HW @'h0 {
                bits 12;
                access ro;
                hard_reset 'h0;
                doc {
                    Forms the LSB's of the Lower Target part of the new address of the translated region. The start address must be aligned to a CX_ATU_MIN_REGION_SIZE kB boundary (in address match mode); and to the Bar size boundary (in BAR match mode) so that these bits are always '0'. If the BAR is smaller than the iATU region size, then the iATU target address must align to the iATU region size; otherwise it must align to the BAR size.

A write to this location is ignored by the PCIe controller.
 - Field size depends on log2(CX_ATU_MIN_REGION_SIZE) in address match mode.
 - Field size depends on log2(BAR_MASK+1) in BAR match mode.
                }
            }
            field LWR_TARGET_RW @'hc {
                bits 20;
                access rw;
                hard_reset 'h0;
                doc {
                    Forms MSB's of the Lower Target part of the new address of the translated region. These bits are always '0'.
 - Field size depends on log2(CX_ATU_MIN_REGION_SIZE) in address match mode.
 - Field size depends on log2(BAR_MASK+1) in BAR match mode.
Note: This register field is sticky.
                }
            }
            doc {
                iATU Lower Target Address Register.iATU Lower Target Address Register.
            }
        }
        register IATU_UPPER_TARGET_ADDR_OFF_INBOUND_1 @'h318 {
            bytes 4;
            field UPPER_TARGET_RW @'h0 {
                bits 32;
                access rw;
                hard_reset 'h0;
                doc {
                    Forms bits [63:32] of the start address (Upper Target part) of the new address of the translated region. In systems with a 32-bit address space, this register is not used and therefore writing to this register has no effect.

Note: This register field is sticky.
                }
            }
            doc {
                iATU Upper Target Address Register.iATU Upper Target Address Register.
            }
        }
        register IATU_UPPR_LIMIT_ADDR_OFF_INBOUND_1 @'h320 {
            bytes 4;
            field UPPR_LIMIT_ADDR_RW @'h0 {
                bits 4;
                access rw;
                hard_reset 'h0;
                doc {
                    Forms the LSB's of the Upper Limit part of the region "end address" to be translated. Only applies to 64-bit systems and when the INCREASE_REGION_SIZE field in IATU_REGION_CTRL_1_OFF_INBOUND_i is '1'

Note: This register field is sticky.
                }
            }
            field UPPR_LIMIT_ADDR_HW @'h4 {
                bits 28;
                access ro;
                hard_reset 'h0;
                doc {
                    Forms MSB's of the Upper Limit part of the region "end address" to be translated. Only applies to 64-bit systems and when the INCREASE_REGION_SIZE field in IATU_REGION_CTRL_1_OFF_INBOUND_i is '1'. These bits are always '0'.
                }
            }
            doc {
                iATU Upper Limit Address Register. The CX_MAX_ATU_REGION_SIZE configuration parameter (Value Range: 0->32, 8=1TB) specifies the maximum region size of an address translation region. This register is only used when the INCREASE_REGION_SIZE field in IATU_REGION_CTRL_1_OFF_INBOUND_i is '1'.iATU Upper Limit Address Register. The CX_MAX_ATU_REGION_SIZE configuration parameter (Value Range: 0->32, 8=1TB) specifies the maximum region size of an address translation region. This register is only used when the INCREASE_REGION_SIZE field in IATU_REGION_CTRL_1_OFF_INBOUND_i is '1'.
            }
        }
        register IATU_REGION_CTRL_1_OFF_OUTBOUND_2 @'h400 {
            bytes 4;
            field TYPE @'h0 {
                bits 5;
                access rw;
                hard_reset 'h0;
                doc {
                    When the address of an outbound TLP is matched to this region, then the TYPE field of the TLP is changed to the value in this register.

Note: This register field is sticky.
                }
            }
            field TC @'h5 {
                bits 3;
                access rw;
                hard_reset 'h0;
                doc {
                    When the address of an outbound TLP is matched to this region, then the TC field of the TLP is changed to the value in this register.

Note: This register field is sticky.
                }
            }
            field TD @'h8 {
                access rw;
                hard_reset 'h0;
                doc {
                    This is a reserved field. Do not use.

Note: This register field is sticky.
                }
            }
            field ATTR @'h9 {
                bits 2;
                access rw;
                hard_reset 'h0;
                doc {
                    When the address of an outbound TLP is matched to this region, then the ATTR field of the TLP is changed to the value in this register.

Note: This register field is sticky.
                }
            }
            field INCREASE_REGION_SIZE @'hd {
                access rw;
                hard_reset 'h0;
                doc {
                    Increase the maximum ATU Region size. When set, the maximum ATU Region size is determined by CX_ATU_MAX_REGION_SIZE. When clear, the maximum ATU Region size is 4 GB (default).

Note: This register field is sticky.
                }
            }
            field CTRL_1_FUNC_NUM @'h14 {
                bits 3;
                access rw;
                hard_reset 'h0;
                doc {
                    Function Number.
 - When the address of an outbound TLP is matched to this region and the FUNC_BYPASS field in the "iATU Control 2 Register" is '0', then the function number used in generating the function part of the requester ID (RID) field of the TLP is taken from this 5-bit register. The value in this register must be 0x0 unless multifunction operation in the controller is enabled (CX_NFUNC > 1).
 - When you are using the AXI Bridge, then this field is swapped before AXI decomposition occurs so that the correct "Max_Read_Request_Size" and "Max_Payload_Size" values are used.

Note: This register field is sticky.
                }
            }
            doc {
                iATU Region Control 1 Register.iATU Region Control 1 Register.
            }
        }
        register IATU_REGION_CTRL_2_OFF_OUTBOUND_2 @'h404 {
            bytes 4;
            field MSG_CODE @'h0 {
                bits 8;
                access rw;
                hard_reset 'h0;
                doc {
                    MSG TLPs (Message Code). When the address of an outbound TLP is matched to this region, and the translated TLP TYPE field is Msg or MsgD; then the message field of the TLP is changed to the value in this register.

Memory TLPs: (ST;Steering Tag). When the ST field of an outbound TLP is matched to this region, and the translated TLP TYPE field targets memory space; then the ST field of the TLP is changed to the value in this register. Only Valid when the CX_TPH_ENABLE configuration parameter is 1.

Note: This register field is sticky.
                }
            }
            field TAG @'h8 {
                bits 8;
                access rw;
                hard_reset 'h0;
                doc {
                    TAG.

The substituted TAG field (byte 6) in the outgoing TLP header when TAG_SUBSTITUTE_EN is set.

Note: This register field is sticky.
                }
            }
            field TAG_SUBSTITUTE_EN @'h10 {
                access rw;
                hard_reset 'h0;
                doc {
                    TAG Substitute Enable.

When enabled and region address is matched, the iATU substitutes the TAG field of the outbound TLP header with the contents of the TAG field in this register. The expected usage scenario is translation from AXI MWr to Vendor Defined Msg/MsgD.

Note (CX_TPH_ENABLE=1): TAG substitution for MWr will not occur because this field (byte 6) in the TLP header is the ST field. ST substitution can still take place using the MSG_CODE field in IATU_REGION_CTRL_2_OFF_OUTBOUND_i.

Note: This register field is sticky.
                }
            }
            field MSB2BITS_TAG @'h11 {
                bits 2;
                access rw;
                hard_reset 'h0;
                doc {
                    TAG.

Two most significant bits of the substituted TAG field in the outgoing TLP header when TAG_SUBSTITUTE_EN is set. 

Note: This register field is sticky.
                }
            }
            field FUNC_BYPASS @'h13 {
                access rw;
                hard_reset 'h0;
                doc {
                    Function Number Translation Bypass. In this mode, the function number of the translated TLP is taken from your application transmit interface and not from the CTRL_1_FUNC_NUM field of the "iATU Control 1 Register" or the VF_NUMBER field of the "iATU Control 3 Register."

Note: This register field is sticky.
                }
            }
            field SNP @'h14 {
                access rw;
                hard_reset 'h0;
                doc {
                    Serialize Non-Posted Requests. In this mode, when the AXI Bridge is populated, same AXI ID Non-Posted Read/Write Requests are transmitted on the wire if there are no other same ID Non-Posted Requests outstanding.

Note: This register field is sticky.
                }
            }
            field TLP_HEADER_FIELDS_BYPASS @'h15 {
                access rw;
                hard_reset 'h0;
                doc {
                    TLP Header Fields Translation Bypass.  In this mode header fields of the translated TLP is taken from your application transmit interface or, if AMBA is configured,  from the AMBA sideband bus (slv_awmisc_info) and not from the corresponding fields of the IATU_REGION_CTRL_1_OFF_OUTBOUND_i  or IATU_REGION_CTRL_2_OFF_OUTBOUND_i registers. The header fields are
 -	TC
 -	PH
 -	TH
 -	ST
 -	AT
 -	Attr (IDO, RO and NS).
Note: This register field is sticky. 

Note: This register field is sticky.
                }
            }
            field INHIBIT_PAYLOAD @'h16 {
                access rw;
                hard_reset 'h0;
                doc {
                    Inhibit TLP Payload Data for TLP's in Matched Region; assign iATU region to be TLP without data.
When enabled and region address is matched, the iATU marks all TLPs as having no payload data by forcing the TLP header Fmt[1] bit =0, regardless of the application inputs such as slv_wstrb.
 - 1: Fmt[1] =0 so that only TLP type without data is sent. For example, a Msg instead of MsgD will be sent.
 - 0: Fmt[1] =0/1 so that TLPs with or without data can be sent. 
Note: This register field is sticky.
                }
            }
            field HEADER_SUBSTITUTE_EN @'h17 {
                access rw;
                hard_reset 'h0;
                doc {
                    Header Substitute Enable.

When enabled and region address is matched, the iATU fully substitutes bytes 8-11 (for 3 DWORD header) or bytes 12-15 (for 4 DWORD header) of the outbound TLP header with the contents of the LWR_TARGET_RW field in IATU_LWR_TARGET_ADDR_OFF_OUTBOUND_i.
 - 1: LWR_TARGET_RW in the iATU_LWR_TARGET_ADDR_OFF_OUTBOUND_i register is used to fill bytes 8-to-11 (for 3 DWORD header) or bytes 12-to-15 (for 4 DWORD header) of the translated TLP header.
 - 0: LWR_TARGET_RW in the iATU_LWR_TARGET_ADDR_OFF_OUTBOUND_i register forms the new address of the translated region.
Note: This register field is sticky.
                }
            }
            field CFG_SHIFT_MODE @'h1c {
                access rw;
                hard_reset 'h0;
                doc {
                    CFG Shift Mode.

The iATU uses bits [27:12] of the untranslated address (on the XALI0/1/2 interface or AXI slave interface address) to form the BDF number of the outgoing CFG TLP.

This supports the Enhanced Configuration Address Mapping (ECAM) mechanism (Section 7.2.2 of the PCI Express Base 3.1 Specification, revision 1.0) by allowing all outgoing I/O and MEM TLPs (that have been translated to CFG) to be mapped from memory space into any 256 MB region of the PCIe configuration space.

Note: This register field is sticky.
                }
            }
            field INVERT_MODE @'h1d {
                access rw;
                hard_reset 'h0;
                doc {
                    Invert Mode. When set the address matching region is inverted. Therefore, an address match occurs when the untranslated address is in the region outside the defined range (Base Address to Limit Address).

Note: This register field is sticky.
                }
            }
            field REGION_EN @'h1f {
                access rw;
                hard_reset 'h0;
                doc {
                    Region Enable. This bit must be set to '1' for address translation to take place.

Note: This register field is sticky.
                }
            }
            doc {
                iATU Region Control 2 Register.iATU Region Control 2 Register.
            }
        }
        register IATU_LWR_BASE_ADDR_OFF_OUTBOUND_2 @'h408 {
            bytes 4;
            field LWR_BASE_HW @'h0 {
                bits 12;
                access ro;
                hard_reset 'h0;
                doc {
                    Forms bits [n-1:0] of the start address of the address region to be translated. The start address must be aligned to a CX_ATU_MIN_REGION_SIZE kB boundary, so these bits are always 0.
A write to this location is ignored by the PCIe controller.

n is log2(CX_ATU_MIN_REGION_SIZE)
                }
            }
            field LWR_BASE_RW @'hc {
                bits 20;
                access rw;
                hard_reset 'h0;
                doc {
                    Forms bits [31:n] of the start address of the address region to be translated. 
n is log2(CX_ATU_MIN_REGION_SIZE)

Note: This register field is sticky.
                }
            }
            doc {
                iATU Lower Base Address Register. The CX_ATU_MIN_REGION_SIZE configuration parameter (Value Range: 4 kB, 8 kB, 16 kB, 32 kB, 64 kB defaults to 64 kB) specifies the minimum size of an address translation region. For example, if set to 64 kB; the lower 16 bits of the Base, Limit and Target registers are zero and all address regions are aligned on 64 kB boundaries. More precisely, the lower log2(CX_ATU_MIN_REGION_SIZE) bits are zero.iATU Lower Base Address Register. The CX_ATU_MIN_REGION_SIZE configuration parameter (Value Range: 4 kB, 8 kB, 16 kB, 32 kB, 64 kB defaults to 64 kB) specifies the minimum size of an address translation region. For example, if set to 64 kB; the lower 16 bits of the Base, Limit and Target registers are zero and all address regions are aligned on 64 kB boundaries. More precisely, the lower log2(CX_ATU_MIN_REGION_SIZE) bits are zero.
            }
        }
        register IATU_UPPER_BASE_ADDR_OFF_OUTBOUND_2 @'h40c {
            bytes 4;
            field UPPER_BASE_RW @'h0 {
                bits 32;
                access rw;
                hard_reset 'h0;
                doc {
                    Forms bits [63:32] of the start (and end) address of the address region to be translated. In systems with a 32-bit address space, this register is not used and therefore writing to this register has no effect.

Note: This register field is sticky.
                }
            }
            doc {
                iATU Upper Base Address Register.iATU Upper Base Address Register.
            }
        }
        register IATU_LIMIT_ADDR_OFF_OUTBOUND_2 @'h410 {
            bytes 4;
            field LIMIT_ADDR_HW @'h0 {
                bits 12;
                access ro;
                hard_reset 'h0;
                doc {
                    Forms lower bits of the end address of the address region to be translated. The end address must be aligned to a CX_ATU_MIN_REGION_SIZE kB boundary, so these bits are always all ones.
A write to this location is ignored by the PCIe controller.
                }
            }
            field LIMIT_ADDR_RW @'hc {
                bits 20;
                access rw;
                hard_reset 'h0;
                doc {
                    Forms upper bits of the end address of the address region to be translated.

Note: This register field is sticky.
                }
            }
            doc {
                iATU Limit Address Register.iATU Limit Address Register.
            }
        }
        register IATU_LWR_TARGET_ADDR_OFF_OUTBOUND_2 @'h414 {
            bytes 4;
            field LWR_TARGET_RW_OUTBOUND @'h0 {
                bits 32;
                access rw;
                hard_reset 'h0;
                doc {
                    When HEADER_SUBSTITUTE_EN in IATU_REGION_CTRL_2_OFF_OUTBOUND_ is '0' (normal operation):
 - LWR_TARGET_RW[31:n] forms MSB's of the Lower Target part of the new address of the translated region;
 - LWR_TARGET_RW[n-1:0] are not used. (The start address must be aligned to a CX_ATU_MIN_REGION_SIZE kB boundary, so the lower bits of the start address of the new address of the translated region (bits n-1:0) are always '0').
 - n is log2(CX_ATU_MIN_REGION_SIZE).
When HEADER_SUBSTITUTE_EN in IATU_REGION_CTRL_2_OFF_OUTBOUND_i is '1':
 - LWR_TARGET_RW[31:0] forms bytes 8-11 (for 3 dword header) or bytes 12-15 (for 4 dword header) of the outbound TLP header. Usage scenarios include the transmission of Vendor Defined Messages where the controller determines the content of bytes 12 to 15 of the TLP header.
Note: This register field is sticky.
                }
            }
            doc {
                iATU Lower Target Address Register.iATU Lower Target Address Register.
            }
        }
        register IATU_UPPER_TARGET_ADDR_OFF_OUTBOUND_2 @'h418 {
            bytes 4;
            field UPPER_TARGET_RW @'h0 {
                bits 32;
                access rw;
                hard_reset 'h0;
                doc {
                    Forms bits [63:32] of the start address (Upper Target part) of the new address of the translated region.

Note: This register field is sticky.
                }
            }
            doc {
                iATU Upper Target Address Register.iATU Upper Target Address Register.
            }
        }
        register IATU_UPPR_LIMIT_ADDR_OFF_OUTBOUND_2 @'h420 {
            bytes 4;
            field UPPR_LIMIT_ADDR_RW @'h0 {
                bits 4;
                access rw;
                hard_reset 'h0;
                doc {
                    Forms the LSB's of the Upper Limit part of the region "end address" to be translated. Only applies to 64-bit systems and when the INCREASE_REGION_SIZE field in IATU_REGION_CTRL_1_OFF_OUTBOUND_i is '1'

Note: This register field is sticky.
                }
            }
            field UPPR_LIMIT_ADDR_HW @'h4 {
                bits 28;
                access ro;
                hard_reset 'h0;
                doc {
                    Forms MSB's of the Upper Limit part of the region "end address" to be translated. Only applies to 64-bit systems and when the INCREASE_REGION_SIZE field in IATU_REGION_CTRL_1_OFF_OUTBOUND_i is '1'. These bits are always '0'.
                }
            }
            doc {
                iATU Upper Limit Address Register. The CX_MAX_ATU_REGION_SIZE configuration parameter (Value Range: 0->32, 8=1TB) specifies the maximum region size of an address translation region. This register is only used when the INCREASE_REGION_SIZE field in IATU_REGION_CTRL_1_OFF_OUTBOUND_i is '1'.iATU Upper Limit Address Register. The CX_MAX_ATU_REGION_SIZE configuration parameter (Value Range: 0->32, 8=1TB) specifies the maximum region size of an address translation region. This register is only used when the INCREASE_REGION_SIZE field in IATU_REGION_CTRL_1_OFF_OUTBOUND_i is '1'.
            }
        }
        register IATU_REGION_CTRL_1_OFF_INBOUND_2 @'h500 {
            bytes 4;
            field TYPE @'h0 {
                bits 5;
                access rw;
                hard_reset 'h0;
                doc {
                    When the TYPE field of an inbound TLP is matched to this value, then address translation proceeds (when all other enabled field-matches are successful).

Note: This register field is sticky.
                }
            }
            field TC @'h5 {
                bits 3;
                access rw;
                hard_reset 'h0;
                doc {
                    When the TC field of an inbound TLP is matched to this value, then address translation proceeds (when all other enabled field-matches are successful). This check is only performed if the "TC Match Enable" bit of the "iATU Control 2 Register" is set.

Note: This register field is sticky.
                }
            }
            field TD @'h8 {
                access rw;
                hard_reset 'h0;
                doc {
                    When the TD field of an inbound TLP is matched to this value, then address translation proceeds (when all other enabled field-matches are successful). This check is only performed if the "TD Match Enable" bit of the "iATU Control 2 Register" is set.

Note: This register field is sticky.
                }
            }
            field ATTR @'h9 {
                bits 2;
                access rw;
                hard_reset 'h0;
                doc {
                    When the ATTR field of an inbound TLP is matched to this value, then address translation proceeds (when all other enabled field-matches are successful). This check is only performed if the "ATTR Match Enable" bit of the "iATU Control 2 Register" is set.

Note: This register field is sticky.
                }
            }
            field INCREASE_REGION_SIZE @'hd {
                access rw;
                hard_reset 'h0;
                doc {
                    Increase the maximum ATU Region size. When set, the maximum ATU Region size is determined by CX_ATU_MAX_REGION_SIZE. When clear, the maximum ATU Region size is 4 GB (default).

Note: This register field is sticky.
                }
            }
            field CTRL_1_FUNC_NUM @'h14 {
                bits 3;
                access rw;
                hard_reset 'h0;
                doc {
                    Function Number.
 - MEM-I/O: When the Address and BAR matching logic in the controller indicate that a MEM-I/O transaction matches a BAR in the function corresponding to this value, then address translation proceeds. This check is only performed if the "Function Number Match Enable" bit of the "iATU Control 2 Register" is set.
 - CFG0/CFG1: When the destination function number as specified in the routing ID of the TLP header matches the function, then address translation proceeds. This check is only performed if the "Function Number Match Enable" bit of the "iATU Control 2 Register" is set.
Note: This register field is sticky.
                }
            }
            doc {
                iATU Region Control 1 Register.iATU Region Control 1 Register.
            }
        }
        register IATU_REGION_CTRL_2_OFF_INBOUND_2 @'h504 {
            bytes 4;
            field MSG_CODE @'h0 {
                bits 8;
                access rw;
                hard_reset 'h0;
                doc {
                    MSG TLPs: (Message Code). When the TYPE field of an inbound Msg/MsgD TLP is matched to this value, then address translation proceeds (when all other enabled field-matches are successful). This check is only performed if the "Message Code Match Enable" bit of the "iATU Control 2 Register" is set.

Memory TLPs: (ST;Steering Tag). When the ST field of an inbound TLP is matched to this value, then address translation proceeds. This check is only performed if the "ST Match Enable" bit of the "iATU Control2 Register" is set. The setting is independent of the setting of the TH field. Only Valid when the CX_TPH_ENABLE configuration parameter is 1.

Note: This register field is sticky.
                }
            }
            field BAR_NUM @'h8 {
                bits 3;
                access rw;
                hard_reset 'h0;
                doc {
                    BAR Number. When the BAR number of an inbound MEM or IO TLP " that is matched by the normal internal BAR address matching mechanism " is the same as this field, address translation proceeds (when all other enabled field-matches are successful). This check is only performed if the "Match Mode" bit of the "iATU Control 2 Register" is set.
 - 000b - BAR0
 - 001b - BAR1
 - 010b - BAR2
 - 011b - BAR3
 - 100b - BAR4
 - 101b - BAR5
 - 110b - ROM
 - 111b - reserved
 - IO translation would require either 00100b or 00101b in the inbound TLP TYPE; the BAR Number set in the range 000b - 101b and that BAR configured as an IO BAR.
Note: This register field is sticky.
                }
            }
            field MSG_TYPE_MATCH_MODE @'hd {
                access rw;
                hard_reset 'h0;
                doc {
                    Message Type Match Mode.

When enabled, and if single address location translate enable is set, then inbound TLPs of type MSG/MSGd which match the type field of the iatu_region_ctrl_1_OFF_inbound register (=>TYPE[4:3]=2'b10) will be translated.
Message type match mode overrides any value of MATCH_MODE field in this register. Usage scenarios for this are translation of VDM or ATS messages when AXI bridge is configured on client interface.

Note: This register field is sticky.
                }
            }
            field TC_MATCH_EN @'he {
                access rw;
                hard_reset 'h0;
                doc {
                    TC Match Enable. Ensures that a successful TC TLP field comparison match (see TC field of the "iATU Control 1 Register") occurs for address translation to proceed.

Note: This register field is sticky.
                }
            }
            field TD_MATCH_EN @'hf {
                access rw;
                hard_reset 'h0;
                doc {
                    TD Match Enable. Ensures that a successful TD TLP field comparison match (see TD field of the "iATU Control 1 Register") occurs for address translation to proceed.

Note: This register field is sticky.
                }
            }
            field ATTR_MATCH_EN @'h10 {
                access rw;
                hard_reset 'h0;
                doc {
                    ATTR Match Enable. Ensures that a successful ATTR TLP field comparison match (see ATTR field of the "iATU Control 1 Register") occurs for address translation to proceed.

Note: This register field is sticky.
                }
            }
            field FUNC_NUM_MATCH_EN @'h13 {
                access rw;
                hard_reset 'h0;
                doc {
                    Function Number Match Enable. Ensures that a successful Function Number TLP field comparison match (see Function Number field of the "iATU Control 1 Register") occurs (in MEM-I/O and CFG0/CFG1 transactions) for address translation to proceed.

Note: This register field is sticky.
                }
            }
            field MSG_CODE_MATCH_EN @'h15 {
                access rw;
                hard_reset 'h0;
                doc {
                    Message Code Match Enable (Msg TLPS). Ensures that a successful message Code TLP field comparison match (see Message Code field of the "iATU Control 2 Register") occurs (in MSG transactions) for address translation to proceed.

ST Match Enable (Mem TLPs). Ensures that a successful ST TLP field comparison match (see ST field of the "iATU Control 2 Register") occurs (in MEM transactions) for address translation to proceed. Only Valid when the CX_TPH_ENABLE configuration parameter is 1

Note: This register field is sticky.
                }
            }
            field SINGLE_ADDR_LOC_TRANS_EN @'h17 {
                access rw;
                hard_reset 'h0;
                doc {
                    Single Address Location Translate Enable.

When enabled, Rx TLPs can be translated to a single address location as determined by the target address register of the iATU region.
The main usage scenario is translation of Messages (such as Vendor Defined or ATS Messages) to MWr TLPs when the AXI bridge is enabled.

Note: This register field is sticky.
                }
            }
            field RESPONSE_CODE @'h18 {
                bits 2;
                access rw;
                hard_reset 'h0;
                doc {
                    Response Code. Defines the type of response to give for accesses matching this region. This overrides the normal RADM filter response. Note that this feature is not available for any region where Single Address Location Translate is enabled.
 - 00 - Normal RADM filter response is used.
 - 01 - Unsupported request (UR)
 - 10 - Completer abort (CA)
 - 11 - Not used / undefined / reserved.
Note: This register field is sticky.
                }
            }
            field FUZZY_TYPE_MATCH_CODE @'h1b {
                access rw;
                hard_reset 'h0;
                doc {
                    Fuzzy Type Match Mode. When enabled, the iATU relaxes the matching of the TLP TYPE field against the expected TYPE field so that
 - CfgRd0 and CfgRd1 TLPs are seen as identical. Similarly with CfgWr0 and CfgWr1.
 - MWr, MRd and MRdLk TLPs are seen as identical
 - The Routing field of Msg/MsgD TLPs is ignored
 - FetchAdd, Swap and CAS are seen as identical.
For example, CFG0 in the TYPE field in the "iATU Control 1 Register" matches against an inbound CfgRd0, CfgRd1, CfgWr0 or CfgWr1 TLP.

Note: This register field is sticky.
                }
            }
            field CFG_SHIFT_MODE @'h1c {
                access rw;
                hard_reset 'h0;
                doc {
                    CFG Shift Mode. This is useful for CFG transactions where the PCIe configuration mechanism maps bits [27:12] of the address to the bus/device and function number. This allows a CFG configuration space to be located in any 256MB window of your application memory space using a 28-bit effective address. Shifts bits [31:16] of the untranslated address to form bits [27:12] of the translated address.

Note: This register field is sticky.
                }
            }
            field INVERT_MODE @'h1d {
                access rw;
                hard_reset 'h0;
                doc {
                    Invert Mode. When set the address matching region is inverted. Therefore, an address match occurs when the untranslated address is in the region outside the defined range (Base Address to Limit Address).

Note: This register field is sticky.
                }
            }
            field MATCH_MODE @'h1e {
                access rw;
                hard_reset 'h0;
                doc {
                    Match Mode. Determines Inbound matching mode for TLPs. The mode depends on the type of TLP that is received as follows:

 For MEM-I/O TLPs, this field is interpreted as follows:
 - 0: Address Match Mode. The iATU operates using addresses as in the outbound direction. The Region Base and Limit Registers must be setup.
 - 1:BAR Match Mode. BAR matching is used. The "BAR Number" field is relevant. Not used for RC.
For CFG0 TLPs, this field is interpreted as follows:
 - 0: Routing ID Match Mode. The iATU interprets the Routing ID (Bytes 8 to 11 of TLP header) as an address. This corresponds to the upper 16 bits of the address in MEM-I/O transactions. The Routing ID of the TLP must be within the base and limit of the iATU region for matching to proceed.
 - 1: Accept Mode. The iATU accepts all CFG0 transactions as address matches. The routing ID in the CFG0 TLP is ignored. This is useful as all received CFG0 TLPs should be processed regardless of the Bus number.
For MSG/MSGD TLPs, this field is interpreted as follows:
 - 0: Address Match Mode. The iATU treats the third dword and fourth dword of the inbound MSG/MSGD TLP as an address and it is matched against the Region Base and Limit Registers.
 - 1: Vendor ID Match Mode. This mode is relevant for ID-routed Vendor Defined Messages. The iATU ignores the Routing ID (Bus, Device, Function) in bits [31:16] of the third dword of the TLP header, but matches against the Vendor ID in bits [15:0] of the third dword of the TLP header. Bits [15:0] of the Region Upper Base register should be programmed with the required Vendor ID. The lower Base and Limit Register should be programmed to translate TLPs based on vendor specific information in the fourth dword of the TLP header.
 -	If SINGLE_ADDRESS_LOCATION_TRANSLATE_EN = 1 AND MSG_TYPE_MATCH_MODE = 1, then Match Mode is ignored.
Note: This register field is sticky.
                }
            }
            field REGION_EN @'h1f {
                access rw;
                hard_reset 'h0;
                doc {
                    Region Enable. This bit must be set to '1' for address translation to take place.

Note: This register field is sticky.
                }
            }
            doc {
                iATU Region Control 2 Register.iATU Region Control 2 Register.
            }
        }
        register IATU_LWR_BASE_ADDR_OFF_INBOUND_2 @'h508 {
            bytes 4;
            field LWR_BASE_HW @'h0 {
                bits 12;
                access ro;
                hard_reset 'h0;
                doc {
                    Forms bits [n-1:0] of the start address of the address region to be translated. The start address must be aligned to a CX_ATU_MIN_REGION_SIZE kB boundary, so these bits are always 0.
A write to this location is ignored by the PCIe controller.

n is log2(CX_ATU_MIN_REGION_SIZE)
                }
            }
            field LWR_BASE_RW @'hc {
                bits 20;
                access rw;
                hard_reset 'h0;
                doc {
                    Forms bits [31:n] of the start address of the address region to be translated. 
n is log2(CX_ATU_MIN_REGION_SIZE)

Note: This register field is sticky.
                }
            }
            doc {
                iATU Lower Base Address Register. The CX_ATU_MIN_REGION_SIZE configuration parameter (Value Range: 4 kB, 8 kB, 16 kB, 32 kB, 64 kB defaults to 64 kB) specifies the minimum size of an address translation region. For example, if set to 64 kB; the lower 16 bits of the Base, Limit and Target registers are zero and all address regions are aligned on 64 kB boundaries. More precisely, the lower log2(CX_ATU_MIN_REGION_SIZE) bits are zero.iATU Lower Base Address Register. The CX_ATU_MIN_REGION_SIZE configuration parameter (Value Range: 4 kB, 8 kB, 16 kB, 32 kB, 64 kB defaults to 64 kB) specifies the minimum size of an address translation region. For example, if set to 64 kB; the lower 16 bits of the Base, Limit and Target registers are zero and all address regions are aligned on 64 kB boundaries. More precisely, the lower log2(CX_ATU_MIN_REGION_SIZE) bits are zero.
            }
        }
        register IATU_UPPER_BASE_ADDR_OFF_INBOUND_2 @'h50c {
            bytes 4;
            field UPPER_BASE_RW @'h0 {
                bits 32;
                access rw;
                hard_reset 'h0;
                doc {
                    Forms bits [63:32] of the start (and end) address of the address region to be translated.

Note: This register field is sticky.
                }
            }
            doc {
                iATU Upper Base Address Register.iATU Upper Base Address Register.
            }
        }
        register IATU_LIMIT_ADDR_OFF_INBOUND_2 @'h510 {
            bytes 4;
            field LIMIT_ADDR_HW @'h0 {
                bits 12;
                access ro;
                hard_reset 'h0;
                doc {
                    Forms lower bits of the end address of the address region to be translated. The end address must be aligned to a CX_ATU_MIN_REGION_SIZE kB boundary, so these bits are always all ones.
A write to this location is ignored by the PCIe controller.
                }
            }
            field LIMIT_ADDR_RW @'hc {
                bits 20;
                access rw;
                hard_reset 'h0;
                doc {
                    Forms upper bits of the end address of the address region to be translated.

Note: This register field is sticky.
                }
            }
            doc {
                iATU Limit Address Register.iATU Limit Address Register.
            }
        }
        register IATU_LWR_TARGET_ADDR_OFF_INBOUND_2 @'h514 {
            bytes 4;
            field LWR_TARGET_HW @'h0 {
                bits 12;
                access ro;
                hard_reset 'h0;
                doc {
                    Forms the LSB's of the Lower Target part of the new address of the translated region. The start address must be aligned to a CX_ATU_MIN_REGION_SIZE kB boundary (in address match mode); and to the Bar size boundary (in BAR match mode) so that these bits are always '0'. If the BAR is smaller than the iATU region size, then the iATU target address must align to the iATU region size; otherwise it must align to the BAR size.

A write to this location is ignored by the PCIe controller.
 - Field size depends on log2(CX_ATU_MIN_REGION_SIZE) in address match mode.
 - Field size depends on log2(BAR_MASK+1) in BAR match mode.
                }
            }
            field LWR_TARGET_RW @'hc {
                bits 20;
                access rw;
                hard_reset 'h0;
                doc {
                    Forms MSB's of the Lower Target part of the new address of the translated region. These bits are always '0'.
 - Field size depends on log2(CX_ATU_MIN_REGION_SIZE) in address match mode.
 - Field size depends on log2(BAR_MASK+1) in BAR match mode.
Note: This register field is sticky.
                }
            }
            doc {
                iATU Lower Target Address Register.iATU Lower Target Address Register.
            }
        }
        register IATU_UPPER_TARGET_ADDR_OFF_INBOUND_2 @'h518 {
            bytes 4;
            field UPPER_TARGET_RW @'h0 {
                bits 32;
                access rw;
                hard_reset 'h0;
                doc {
                    Forms bits [63:32] of the start address (Upper Target part) of the new address of the translated region. In systems with a 32-bit address space, this register is not used and therefore writing to this register has no effect.

Note: This register field is sticky.
                }
            }
            doc {
                iATU Upper Target Address Register.iATU Upper Target Address Register.
            }
        }
        register IATU_UPPR_LIMIT_ADDR_OFF_INBOUND_2 @'h520 {
            bytes 4;
            field UPPR_LIMIT_ADDR_RW @'h0 {
                bits 4;
                access rw;
                hard_reset 'h0;
                doc {
                    Forms the LSB's of the Upper Limit part of the region "end address" to be translated. Only applies to 64-bit systems and when the INCREASE_REGION_SIZE field in IATU_REGION_CTRL_1_OFF_INBOUND_i is '1'

Note: This register field is sticky.
                }
            }
            field UPPR_LIMIT_ADDR_HW @'h4 {
                bits 28;
                access ro;
                hard_reset 'h0;
                doc {
                    Forms MSB's of the Upper Limit part of the region "end address" to be translated. Only applies to 64-bit systems and when the INCREASE_REGION_SIZE field in IATU_REGION_CTRL_1_OFF_INBOUND_i is '1'. These bits are always '0'.
                }
            }
            doc {
                iATU Upper Limit Address Register. The CX_MAX_ATU_REGION_SIZE configuration parameter (Value Range: 0->32, 8=1TB) specifies the maximum region size of an address translation region. This register is only used when the INCREASE_REGION_SIZE field in IATU_REGION_CTRL_1_OFF_INBOUND_i is '1'.iATU Upper Limit Address Register. The CX_MAX_ATU_REGION_SIZE configuration parameter (Value Range: 0->32, 8=1TB) specifies the maximum region size of an address translation region. This register is only used when the INCREASE_REGION_SIZE field in IATU_REGION_CTRL_1_OFF_INBOUND_i is '1'.
            }
        }
        register IATU_REGION_CTRL_1_OFF_OUTBOUND_3 @'h600 {
            bytes 4;
            field TYPE @'h0 {
                bits 5;
                access rw;
                hard_reset 'h0;
                doc {
                    When the address of an outbound TLP is matched to this region, then the TYPE field of the TLP is changed to the value in this register.

Note: This register field is sticky.
                }
            }
            field TC @'h5 {
                bits 3;
                access rw;
                hard_reset 'h0;
                doc {
                    When the address of an outbound TLP is matched to this region, then the TC field of the TLP is changed to the value in this register.

Note: This register field is sticky.
                }
            }
            field TD @'h8 {
                access rw;
                hard_reset 'h0;
                doc {
                    This is a reserved field. Do not use.

Note: This register field is sticky.
                }
            }
            field ATTR @'h9 {
                bits 2;
                access rw;
                hard_reset 'h0;
                doc {
                    When the address of an outbound TLP is matched to this region, then the ATTR field of the TLP is changed to the value in this register.

Note: This register field is sticky.
                }
            }
            field INCREASE_REGION_SIZE @'hd {
                access rw;
                hard_reset 'h0;
                doc {
                    Increase the maximum ATU Region size. When set, the maximum ATU Region size is determined by CX_ATU_MAX_REGION_SIZE. When clear, the maximum ATU Region size is 4 GB (default).

Note: This register field is sticky.
                }
            }
            field CTRL_1_FUNC_NUM @'h14 {
                bits 3;
                access rw;
                hard_reset 'h0;
                doc {
                    Function Number.
 - When the address of an outbound TLP is matched to this region and the FUNC_BYPASS field in the "iATU Control 2 Register" is '0', then the function number used in generating the function part of the requester ID (RID) field of the TLP is taken from this 5-bit register. The value in this register must be 0x0 unless multifunction operation in the controller is enabled (CX_NFUNC > 1).
 - When you are using the AXI Bridge, then this field is swapped before AXI decomposition occurs so that the correct "Max_Read_Request_Size" and "Max_Payload_Size" values are used.

Note: This register field is sticky.
                }
            }
            doc {
                iATU Region Control 1 Register.iATU Region Control 1 Register.
            }
        }
        register IATU_REGION_CTRL_2_OFF_OUTBOUND_3 @'h604 {
            bytes 4;
            field MSG_CODE @'h0 {
                bits 8;
                access rw;
                hard_reset 'h0;
                doc {
                    MSG TLPs (Message Code). When the address of an outbound TLP is matched to this region, and the translated TLP TYPE field is Msg or MsgD; then the message field of the TLP is changed to the value in this register.

Memory TLPs: (ST;Steering Tag). When the ST field of an outbound TLP is matched to this region, and the translated TLP TYPE field targets memory space; then the ST field of the TLP is changed to the value in this register. Only Valid when the CX_TPH_ENABLE configuration parameter is 1.

Note: This register field is sticky.
                }
            }
            field TAG @'h8 {
                bits 8;
                access rw;
                hard_reset 'h0;
                doc {
                    TAG.

The substituted TAG field (byte 6) in the outgoing TLP header when TAG_SUBSTITUTE_EN is set.

Note: This register field is sticky.
                }
            }
            field TAG_SUBSTITUTE_EN @'h10 {
                access rw;
                hard_reset 'h0;
                doc {
                    TAG Substitute Enable.

When enabled and region address is matched, the iATU substitutes the TAG field of the outbound TLP header with the contents of the TAG field in this register. The expected usage scenario is translation from AXI MWr to Vendor Defined Msg/MsgD.

Note (CX_TPH_ENABLE=1): TAG substitution for MWr will not occur because this field (byte 6) in the TLP header is the ST field. ST substitution can still take place using the MSG_CODE field in IATU_REGION_CTRL_2_OFF_OUTBOUND_i.

Note: This register field is sticky.
                }
            }
            field MSB2BITS_TAG @'h11 {
                bits 2;
                access rw;
                hard_reset 'h0;
                doc {
                    TAG.

Two most significant bits of the substituted TAG field in the outgoing TLP header when TAG_SUBSTITUTE_EN is set. 

Note: This register field is sticky.
                }
            }
            field FUNC_BYPASS @'h13 {
                access rw;
                hard_reset 'h0;
                doc {
                    Function Number Translation Bypass. In this mode, the function number of the translated TLP is taken from your application transmit interface and not from the CTRL_1_FUNC_NUM field of the "iATU Control 1 Register" or the VF_NUMBER field of the "iATU Control 3 Register."

Note: This register field is sticky.
                }
            }
            field SNP @'h14 {
                access rw;
                hard_reset 'h0;
                doc {
                    Serialize Non-Posted Requests. In this mode, when the AXI Bridge is populated, same AXI ID Non-Posted Read/Write Requests are transmitted on the wire if there are no other same ID Non-Posted Requests outstanding.

Note: This register field is sticky.
                }
            }
            field TLP_HEADER_FIELDS_BYPASS @'h15 {
                access rw;
                hard_reset 'h0;
                doc {
                    TLP Header Fields Translation Bypass.  In this mode header fields of the translated TLP is taken from your application transmit interface or, if AMBA is configured,  from the AMBA sideband bus (slv_awmisc_info) and not from the corresponding fields of the IATU_REGION_CTRL_1_OFF_OUTBOUND_i  or IATU_REGION_CTRL_2_OFF_OUTBOUND_i registers. The header fields are
 -	TC
 -	PH
 -	TH
 -	ST
 -	AT
 -	Attr (IDO, RO and NS).
Note: This register field is sticky. 

Note: This register field is sticky.
                }
            }
            field INHIBIT_PAYLOAD @'h16 {
                access rw;
                hard_reset 'h0;
                doc {
                    Inhibit TLP Payload Data for TLP's in Matched Region; assign iATU region to be TLP without data.
When enabled and region address is matched, the iATU marks all TLPs as having no payload data by forcing the TLP header Fmt[1] bit =0, regardless of the application inputs such as slv_wstrb.
 - 1: Fmt[1] =0 so that only TLP type without data is sent. For example, a Msg instead of MsgD will be sent.
 - 0: Fmt[1] =0/1 so that TLPs with or without data can be sent. 
Note: This register field is sticky.
                }
            }
            field HEADER_SUBSTITUTE_EN @'h17 {
                access rw;
                hard_reset 'h0;
                doc {
                    Header Substitute Enable.

When enabled and region address is matched, the iATU fully substitutes bytes 8-11 (for 3 DWORD header) or bytes 12-15 (for 4 DWORD header) of the outbound TLP header with the contents of the LWR_TARGET_RW field in IATU_LWR_TARGET_ADDR_OFF_OUTBOUND_i.
 - 1: LWR_TARGET_RW in the iATU_LWR_TARGET_ADDR_OFF_OUTBOUND_i register is used to fill bytes 8-to-11 (for 3 DWORD header) or bytes 12-to-15 (for 4 DWORD header) of the translated TLP header.
 - 0: LWR_TARGET_RW in the iATU_LWR_TARGET_ADDR_OFF_OUTBOUND_i register forms the new address of the translated region.
Note: This register field is sticky.
                }
            }
            field CFG_SHIFT_MODE @'h1c {
                access rw;
                hard_reset 'h0;
                doc {
                    CFG Shift Mode.

The iATU uses bits [27:12] of the untranslated address (on the XALI0/1/2 interface or AXI slave interface address) to form the BDF number of the outgoing CFG TLP.

This supports the Enhanced Configuration Address Mapping (ECAM) mechanism (Section 7.2.2 of the PCI Express Base 3.1 Specification, revision 1.0) by allowing all outgoing I/O and MEM TLPs (that have been translated to CFG) to be mapped from memory space into any 256 MB region of the PCIe configuration space.

Note: This register field is sticky.
                }
            }
            field INVERT_MODE @'h1d {
                access rw;
                hard_reset 'h0;
                doc {
                    Invert Mode. When set the address matching region is inverted. Therefore, an address match occurs when the untranslated address is in the region outside the defined range (Base Address to Limit Address).

Note: This register field is sticky.
                }
            }
            field REGION_EN @'h1f {
                access rw;
                hard_reset 'h0;
                doc {
                    Region Enable. This bit must be set to '1' for address translation to take place.

Note: This register field is sticky.
                }
            }
            doc {
                iATU Region Control 2 Register.iATU Region Control 2 Register.
            }
        }
        register IATU_LWR_BASE_ADDR_OFF_OUTBOUND_3 @'h608 {
            bytes 4;
            field LWR_BASE_HW @'h0 {
                bits 12;
                access ro;
                hard_reset 'h0;
                doc {
                    Forms bits [n-1:0] of the start address of the address region to be translated. The start address must be aligned to a CX_ATU_MIN_REGION_SIZE kB boundary, so these bits are always 0.
A write to this location is ignored by the PCIe controller.

n is log2(CX_ATU_MIN_REGION_SIZE)
                }
            }
            field LWR_BASE_RW @'hc {
                bits 20;
                access rw;
                hard_reset 'h0;
                doc {
                    Forms bits [31:n] of the start address of the address region to be translated. 
n is log2(CX_ATU_MIN_REGION_SIZE)

Note: This register field is sticky.
                }
            }
            doc {
                iATU Lower Base Address Register. The CX_ATU_MIN_REGION_SIZE configuration parameter (Value Range: 4 kB, 8 kB, 16 kB, 32 kB, 64 kB defaults to 64 kB) specifies the minimum size of an address translation region. For example, if set to 64 kB; the lower 16 bits of the Base, Limit and Target registers are zero and all address regions are aligned on 64 kB boundaries. More precisely, the lower log2(CX_ATU_MIN_REGION_SIZE) bits are zero.iATU Lower Base Address Register. The CX_ATU_MIN_REGION_SIZE configuration parameter (Value Range: 4 kB, 8 kB, 16 kB, 32 kB, 64 kB defaults to 64 kB) specifies the minimum size of an address translation region. For example, if set to 64 kB; the lower 16 bits of the Base, Limit and Target registers are zero and all address regions are aligned on 64 kB boundaries. More precisely, the lower log2(CX_ATU_MIN_REGION_SIZE) bits are zero.
            }
        }
        register IATU_UPPER_BASE_ADDR_OFF_OUTBOUND_3 @'h60c {
            bytes 4;
            field UPPER_BASE_RW @'h0 {
                bits 32;
                access rw;
                hard_reset 'h0;
                doc {
                    Forms bits [63:32] of the start (and end) address of the address region to be translated. In systems with a 32-bit address space, this register is not used and therefore writing to this register has no effect.

Note: This register field is sticky.
                }
            }
            doc {
                iATU Upper Base Address Register.iATU Upper Base Address Register.
            }
        }
        register IATU_LIMIT_ADDR_OFF_OUTBOUND_3 @'h610 {
            bytes 4;
            field LIMIT_ADDR_HW @'h0 {
                bits 12;
                access ro;
                hard_reset 'h0;
                doc {
                    Forms lower bits of the end address of the address region to be translated. The end address must be aligned to a CX_ATU_MIN_REGION_SIZE kB boundary, so these bits are always all ones.
A write to this location is ignored by the PCIe controller.
                }
            }
            field LIMIT_ADDR_RW @'hc {
                bits 20;
                access rw;
                hard_reset 'h0;
                doc {
                    Forms upper bits of the end address of the address region to be translated.

Note: This register field is sticky.
                }
            }
            doc {
                iATU Limit Address Register.iATU Limit Address Register.
            }
        }
        register IATU_LWR_TARGET_ADDR_OFF_OUTBOUND_3 @'h614 {
            bytes 4;
            field LWR_TARGET_RW_OUTBOUND @'h0 {
                bits 32;
                access rw;
                hard_reset 'h0;
                doc {
                    When HEADER_SUBSTITUTE_EN in IATU_REGION_CTRL_2_OFF_OUTBOUND_ is '0' (normal operation):
 - LWR_TARGET_RW[31:n] forms MSB's of the Lower Target part of the new address of the translated region;
 - LWR_TARGET_RW[n-1:0] are not used. (The start address must be aligned to a CX_ATU_MIN_REGION_SIZE kB boundary, so the lower bits of the start address of the new address of the translated region (bits n-1:0) are always '0').
 - n is log2(CX_ATU_MIN_REGION_SIZE).
When HEADER_SUBSTITUTE_EN in IATU_REGION_CTRL_2_OFF_OUTBOUND_i is '1':
 - LWR_TARGET_RW[31:0] forms bytes 8-11 (for 3 dword header) or bytes 12-15 (for 4 dword header) of the outbound TLP header. Usage scenarios include the transmission of Vendor Defined Messages where the controller determines the content of bytes 12 to 15 of the TLP header.
Note: This register field is sticky.
                }
            }
            doc {
                iATU Lower Target Address Register.iATU Lower Target Address Register.
            }
        }
        register IATU_UPPER_TARGET_ADDR_OFF_OUTBOUND_3 @'h618 {
            bytes 4;
            field UPPER_TARGET_RW @'h0 {
                bits 32;
                access rw;
                hard_reset 'h0;
                doc {
                    Forms bits [63:32] of the start address (Upper Target part) of the new address of the translated region.

Note: This register field is sticky.
                }
            }
            doc {
                iATU Upper Target Address Register.iATU Upper Target Address Register.
            }
        }
        register IATU_UPPR_LIMIT_ADDR_OFF_OUTBOUND_3 @'h620 {
            bytes 4;
            field UPPR_LIMIT_ADDR_RW @'h0 {
                bits 4;
                access rw;
                hard_reset 'h0;
                doc {
                    Forms the LSB's of the Upper Limit part of the region "end address" to be translated. Only applies to 64-bit systems and when the INCREASE_REGION_SIZE field in IATU_REGION_CTRL_1_OFF_OUTBOUND_i is '1'

Note: This register field is sticky.
                }
            }
            field UPPR_LIMIT_ADDR_HW @'h4 {
                bits 28;
                access ro;
                hard_reset 'h0;
                doc {
                    Forms MSB's of the Upper Limit part of the region "end address" to be translated. Only applies to 64-bit systems and when the INCREASE_REGION_SIZE field in IATU_REGION_CTRL_1_OFF_OUTBOUND_i is '1'. These bits are always '0'.
                }
            }
            doc {
                iATU Upper Limit Address Register. The CX_MAX_ATU_REGION_SIZE configuration parameter (Value Range: 0->32, 8=1TB) specifies the maximum region size of an address translation region. This register is only used when the INCREASE_REGION_SIZE field in IATU_REGION_CTRL_1_OFF_OUTBOUND_i is '1'.iATU Upper Limit Address Register. The CX_MAX_ATU_REGION_SIZE configuration parameter (Value Range: 0->32, 8=1TB) specifies the maximum region size of an address translation region. This register is only used when the INCREASE_REGION_SIZE field in IATU_REGION_CTRL_1_OFF_OUTBOUND_i is '1'.
            }
        }
        register IATU_REGION_CTRL_1_OFF_INBOUND_3 @'h700 {
            bytes 4;
            field TYPE @'h0 {
                bits 5;
                access rw;
                hard_reset 'h0;
                doc {
                    When the TYPE field of an inbound TLP is matched to this value, then address translation proceeds (when all other enabled field-matches are successful).

Note: This register field is sticky.
                }
            }
            field TC @'h5 {
                bits 3;
                access rw;
                hard_reset 'h0;
                doc {
                    When the TC field of an inbound TLP is matched to this value, then address translation proceeds (when all other enabled field-matches are successful). This check is only performed if the "TC Match Enable" bit of the "iATU Control 2 Register" is set.

Note: This register field is sticky.
                }
            }
            field TD @'h8 {
                access rw;
                hard_reset 'h0;
                doc {
                    When the TD field of an inbound TLP is matched to this value, then address translation proceeds (when all other enabled field-matches are successful). This check is only performed if the "TD Match Enable" bit of the "iATU Control 2 Register" is set.

Note: This register field is sticky.
                }
            }
            field ATTR @'h9 {
                bits 2;
                access rw;
                hard_reset 'h0;
                doc {
                    When the ATTR field of an inbound TLP is matched to this value, then address translation proceeds (when all other enabled field-matches are successful). This check is only performed if the "ATTR Match Enable" bit of the "iATU Control 2 Register" is set.

Note: This register field is sticky.
                }
            }
            field INCREASE_REGION_SIZE @'hd {
                access rw;
                hard_reset 'h0;
                doc {
                    Increase the maximum ATU Region size. When set, the maximum ATU Region size is determined by CX_ATU_MAX_REGION_SIZE. When clear, the maximum ATU Region size is 4 GB (default).

Note: This register field is sticky.
                }
            }
            field CTRL_1_FUNC_NUM @'h14 {
                bits 3;
                access rw;
                hard_reset 'h0;
                doc {
                    Function Number.
 - MEM-I/O: When the Address and BAR matching logic in the controller indicate that a MEM-I/O transaction matches a BAR in the function corresponding to this value, then address translation proceeds. This check is only performed if the "Function Number Match Enable" bit of the "iATU Control 2 Register" is set.
 - CFG0/CFG1: When the destination function number as specified in the routing ID of the TLP header matches the function, then address translation proceeds. This check is only performed if the "Function Number Match Enable" bit of the "iATU Control 2 Register" is set.
Note: This register field is sticky.
                }
            }
            doc {
                iATU Region Control 1 Register.iATU Region Control 1 Register.
            }
        }
        register IATU_REGION_CTRL_2_OFF_INBOUND_3 @'h704 {
            bytes 4;
            field MSG_CODE @'h0 {
                bits 8;
                access rw;
                hard_reset 'h0;
                doc {
                    MSG TLPs: (Message Code). When the TYPE field of an inbound Msg/MsgD TLP is matched to this value, then address translation proceeds (when all other enabled field-matches are successful). This check is only performed if the "Message Code Match Enable" bit of the "iATU Control 2 Register" is set.

Memory TLPs: (ST;Steering Tag). When the ST field of an inbound TLP is matched to this value, then address translation proceeds. This check is only performed if the "ST Match Enable" bit of the "iATU Control2 Register" is set. The setting is independent of the setting of the TH field. Only Valid when the CX_TPH_ENABLE configuration parameter is 1.

Note: This register field is sticky.
                }
            }
            field BAR_NUM @'h8 {
                bits 3;
                access rw;
                hard_reset 'h0;
                doc {
                    BAR Number. When the BAR number of an inbound MEM or IO TLP " that is matched by the normal internal BAR address matching mechanism " is the same as this field, address translation proceeds (when all other enabled field-matches are successful). This check is only performed if the "Match Mode" bit of the "iATU Control 2 Register" is set.
 - 000b - BAR0
 - 001b - BAR1
 - 010b - BAR2
 - 011b - BAR3
 - 100b - BAR4
 - 101b - BAR5
 - 110b - ROM
 - 111b - reserved
 - IO translation would require either 00100b or 00101b in the inbound TLP TYPE; the BAR Number set in the range 000b - 101b and that BAR configured as an IO BAR.
Note: This register field is sticky.
                }
            }
            field MSG_TYPE_MATCH_MODE @'hd {
                access rw;
                hard_reset 'h0;
                doc {
                    Message Type Match Mode.

When enabled, and if single address location translate enable is set, then inbound TLPs of type MSG/MSGd which match the type field of the iatu_region_ctrl_1_OFF_inbound register (=>TYPE[4:3]=2'b10) will be translated.
Message type match mode overrides any value of MATCH_MODE field in this register. Usage scenarios for this are translation of VDM or ATS messages when AXI bridge is configured on client interface.

Note: This register field is sticky.
                }
            }
            field TC_MATCH_EN @'he {
                access rw;
                hard_reset 'h0;
                doc {
                    TC Match Enable. Ensures that a successful TC TLP field comparison match (see TC field of the "iATU Control 1 Register") occurs for address translation to proceed.

Note: This register field is sticky.
                }
            }
            field TD_MATCH_EN @'hf {
                access rw;
                hard_reset 'h0;
                doc {
                    TD Match Enable. Ensures that a successful TD TLP field comparison match (see TD field of the "iATU Control 1 Register") occurs for address translation to proceed.

Note: This register field is sticky.
                }
            }
            field ATTR_MATCH_EN @'h10 {
                access rw;
                hard_reset 'h0;
                doc {
                    ATTR Match Enable. Ensures that a successful ATTR TLP field comparison match (see ATTR field of the "iATU Control 1 Register") occurs for address translation to proceed.

Note: This register field is sticky.
                }
            }
            field FUNC_NUM_MATCH_EN @'h13 {
                access rw;
                hard_reset 'h0;
                doc {
                    Function Number Match Enable. Ensures that a successful Function Number TLP field comparison match (see Function Number field of the "iATU Control 1 Register") occurs (in MEM-I/O and CFG0/CFG1 transactions) for address translation to proceed.

Note: This register field is sticky.
                }
            }
            field MSG_CODE_MATCH_EN @'h15 {
                access rw;
                hard_reset 'h0;
                doc {
                    Message Code Match Enable (Msg TLPS). Ensures that a successful message Code TLP field comparison match (see Message Code field of the "iATU Control 2 Register") occurs (in MSG transactions) for address translation to proceed.

ST Match Enable (Mem TLPs). Ensures that a successful ST TLP field comparison match (see ST field of the "iATU Control 2 Register") occurs (in MEM transactions) for address translation to proceed. Only Valid when the CX_TPH_ENABLE configuration parameter is 1

Note: This register field is sticky.
                }
            }
            field SINGLE_ADDR_LOC_TRANS_EN @'h17 {
                access rw;
                hard_reset 'h0;
                doc {
                    Single Address Location Translate Enable.

When enabled, Rx TLPs can be translated to a single address location as determined by the target address register of the iATU region.
The main usage scenario is translation of Messages (such as Vendor Defined or ATS Messages) to MWr TLPs when the AXI bridge is enabled.

Note: This register field is sticky.
                }
            }
            field RESPONSE_CODE @'h18 {
                bits 2;
                access rw;
                hard_reset 'h0;
                doc {
                    Response Code. Defines the type of response to give for accesses matching this region. This overrides the normal RADM filter response. Note that this feature is not available for any region where Single Address Location Translate is enabled.
 - 00 - Normal RADM filter response is used.
 - 01 - Unsupported request (UR)
 - 10 - Completer abort (CA)
 - 11 - Not used / undefined / reserved.
Note: This register field is sticky.
                }
            }
            field FUZZY_TYPE_MATCH_CODE @'h1b {
                access rw;
                hard_reset 'h0;
                doc {
                    Fuzzy Type Match Mode. When enabled, the iATU relaxes the matching of the TLP TYPE field against the expected TYPE field so that
 - CfgRd0 and CfgRd1 TLPs are seen as identical. Similarly with CfgWr0 and CfgWr1.
 - MWr, MRd and MRdLk TLPs are seen as identical
 - The Routing field of Msg/MsgD TLPs is ignored
 - FetchAdd, Swap and CAS are seen as identical.
For example, CFG0 in the TYPE field in the "iATU Control 1 Register" matches against an inbound CfgRd0, CfgRd1, CfgWr0 or CfgWr1 TLP.

Note: This register field is sticky.
                }
            }
            field CFG_SHIFT_MODE @'h1c {
                access rw;
                hard_reset 'h0;
                doc {
                    CFG Shift Mode. This is useful for CFG transactions where the PCIe configuration mechanism maps bits [27:12] of the address to the bus/device and function number. This allows a CFG configuration space to be located in any 256MB window of your application memory space using a 28-bit effective address. Shifts bits [31:16] of the untranslated address to form bits [27:12] of the translated address.

Note: This register field is sticky.
                }
            }
            field INVERT_MODE @'h1d {
                access rw;
                hard_reset 'h0;
                doc {
                    Invert Mode. When set the address matching region is inverted. Therefore, an address match occurs when the untranslated address is in the region outside the defined range (Base Address to Limit Address).

Note: This register field is sticky.
                }
            }
            field MATCH_MODE @'h1e {
                access rw;
                hard_reset 'h0;
                doc {
                    Match Mode. Determines Inbound matching mode for TLPs. The mode depends on the type of TLP that is received as follows:

 For MEM-I/O TLPs, this field is interpreted as follows:
 - 0: Address Match Mode. The iATU operates using addresses as in the outbound direction. The Region Base and Limit Registers must be setup.
 - 1:BAR Match Mode. BAR matching is used. The "BAR Number" field is relevant. Not used for RC.
For CFG0 TLPs, this field is interpreted as follows:
 - 0: Routing ID Match Mode. The iATU interprets the Routing ID (Bytes 8 to 11 of TLP header) as an address. This corresponds to the upper 16 bits of the address in MEM-I/O transactions. The Routing ID of the TLP must be within the base and limit of the iATU region for matching to proceed.
 - 1: Accept Mode. The iATU accepts all CFG0 transactions as address matches. The routing ID in the CFG0 TLP is ignored. This is useful as all received CFG0 TLPs should be processed regardless of the Bus number.
For MSG/MSGD TLPs, this field is interpreted as follows:
 - 0: Address Match Mode. The iATU treats the third dword and fourth dword of the inbound MSG/MSGD TLP as an address and it is matched against the Region Base and Limit Registers.
 - 1: Vendor ID Match Mode. This mode is relevant for ID-routed Vendor Defined Messages. The iATU ignores the Routing ID (Bus, Device, Function) in bits [31:16] of the third dword of the TLP header, but matches against the Vendor ID in bits [15:0] of the third dword of the TLP header. Bits [15:0] of the Region Upper Base register should be programmed with the required Vendor ID. The lower Base and Limit Register should be programmed to translate TLPs based on vendor specific information in the fourth dword of the TLP header.
 -	If SINGLE_ADDRESS_LOCATION_TRANSLATE_EN = 1 AND MSG_TYPE_MATCH_MODE = 1, then Match Mode is ignored.
Note: This register field is sticky.
                }
            }
            field REGION_EN @'h1f {
                access rw;
                hard_reset 'h0;
                doc {
                    Region Enable. This bit must be set to '1' for address translation to take place.

Note: This register field is sticky.
                }
            }
            doc {
                iATU Region Control 2 Register.iATU Region Control 2 Register.
            }
        }
        register IATU_LWR_BASE_ADDR_OFF_INBOUND_3 @'h708 {
            bytes 4;
            field LWR_BASE_HW @'h0 {
                bits 12;
                access ro;
                hard_reset 'h0;
                doc {
                    Forms bits [n-1:0] of the start address of the address region to be translated. The start address must be aligned to a CX_ATU_MIN_REGION_SIZE kB boundary, so these bits are always 0.
A write to this location is ignored by the PCIe controller.

n is log2(CX_ATU_MIN_REGION_SIZE)
                }
            }
            field LWR_BASE_RW @'hc {
                bits 20;
                access rw;
                hard_reset 'h0;
                doc {
                    Forms bits [31:n] of the start address of the address region to be translated. 
n is log2(CX_ATU_MIN_REGION_SIZE)

Note: This register field is sticky.
                }
            }
            doc {
                iATU Lower Base Address Register. The CX_ATU_MIN_REGION_SIZE configuration parameter (Value Range: 4 kB, 8 kB, 16 kB, 32 kB, 64 kB defaults to 64 kB) specifies the minimum size of an address translation region. For example, if set to 64 kB; the lower 16 bits of the Base, Limit and Target registers are zero and all address regions are aligned on 64 kB boundaries. More precisely, the lower log2(CX_ATU_MIN_REGION_SIZE) bits are zero.iATU Lower Base Address Register. The CX_ATU_MIN_REGION_SIZE configuration parameter (Value Range: 4 kB, 8 kB, 16 kB, 32 kB, 64 kB defaults to 64 kB) specifies the minimum size of an address translation region. For example, if set to 64 kB; the lower 16 bits of the Base, Limit and Target registers are zero and all address regions are aligned on 64 kB boundaries. More precisely, the lower log2(CX_ATU_MIN_REGION_SIZE) bits are zero.
            }
        }
        register IATU_UPPER_BASE_ADDR_OFF_INBOUND_3 @'h70c {
            bytes 4;
            field UPPER_BASE_RW @'h0 {
                bits 32;
                access rw;
                hard_reset 'h0;
                doc {
                    Forms bits [63:32] of the start (and end) address of the address region to be translated.

Note: This register field is sticky.
                }
            }
            doc {
                iATU Upper Base Address Register.iATU Upper Base Address Register.
            }
        }
        register IATU_LIMIT_ADDR_OFF_INBOUND_3 @'h710 {
            bytes 4;
            field LIMIT_ADDR_HW @'h0 {
                bits 12;
                access ro;
                hard_reset 'h0;
                doc {
                    Forms lower bits of the end address of the address region to be translated. The end address must be aligned to a CX_ATU_MIN_REGION_SIZE kB boundary, so these bits are always all ones.
A write to this location is ignored by the PCIe controller.
                }
            }
            field LIMIT_ADDR_RW @'hc {
                bits 20;
                access rw;
                hard_reset 'h0;
                doc {
                    Forms upper bits of the end address of the address region to be translated.

Note: This register field is sticky.
                }
            }
            doc {
                iATU Limit Address Register.iATU Limit Address Register.
            }
        }
        register IATU_LWR_TARGET_ADDR_OFF_INBOUND_3 @'h714 {
            bytes 4;
            field LWR_TARGET_HW @'h0 {
                bits 12;
                access ro;
                hard_reset 'h0;
                doc {
                    Forms the LSB's of the Lower Target part of the new address of the translated region. The start address must be aligned to a CX_ATU_MIN_REGION_SIZE kB boundary (in address match mode); and to the Bar size boundary (in BAR match mode) so that these bits are always '0'. If the BAR is smaller than the iATU region size, then the iATU target address must align to the iATU region size; otherwise it must align to the BAR size.

A write to this location is ignored by the PCIe controller.
 - Field size depends on log2(CX_ATU_MIN_REGION_SIZE) in address match mode.
 - Field size depends on log2(BAR_MASK+1) in BAR match mode.
                }
            }
            field LWR_TARGET_RW @'hc {
                bits 20;
                access rw;
                hard_reset 'h0;
                doc {
                    Forms MSB's of the Lower Target part of the new address of the translated region. These bits are always '0'.
 - Field size depends on log2(CX_ATU_MIN_REGION_SIZE) in address match mode.
 - Field size depends on log2(BAR_MASK+1) in BAR match mode.
Note: This register field is sticky.
                }
            }
            doc {
                iATU Lower Target Address Register.iATU Lower Target Address Register.
            }
        }
        register IATU_UPPER_TARGET_ADDR_OFF_INBOUND_3 @'h718 {
            bytes 4;
            field UPPER_TARGET_RW @'h0 {
                bits 32;
                access rw;
                hard_reset 'h0;
                doc {
                    Forms bits [63:32] of the start address (Upper Target part) of the new address of the translated region. In systems with a 32-bit address space, this register is not used and therefore writing to this register has no effect.

Note: This register field is sticky.
                }
            }
            doc {
                iATU Upper Target Address Register.iATU Upper Target Address Register.
            }
        }
        register IATU_UPPR_LIMIT_ADDR_OFF_INBOUND_3 @'h720 {
            bytes 4;
            field UPPR_LIMIT_ADDR_RW @'h0 {
                bits 4;
                access rw;
                hard_reset 'h0;
                doc {
                    Forms the LSB's of the Upper Limit part of the region "end address" to be translated. Only applies to 64-bit systems and when the INCREASE_REGION_SIZE field in IATU_REGION_CTRL_1_OFF_INBOUND_i is '1'

Note: This register field is sticky.
                }
            }
            field UPPR_LIMIT_ADDR_HW @'h4 {
                bits 28;
                access ro;
                hard_reset 'h0;
                doc {
                    Forms MSB's of the Upper Limit part of the region "end address" to be translated. Only applies to 64-bit systems and when the INCREASE_REGION_SIZE field in IATU_REGION_CTRL_1_OFF_INBOUND_i is '1'. These bits are always '0'.
                }
            }
            doc {
                iATU Upper Limit Address Register. The CX_MAX_ATU_REGION_SIZE configuration parameter (Value Range: 0->32, 8=1TB) specifies the maximum region size of an address translation region. This register is only used when the INCREASE_REGION_SIZE field in IATU_REGION_CTRL_1_OFF_INBOUND_i is '1'.iATU Upper Limit Address Register. The CX_MAX_ATU_REGION_SIZE configuration parameter (Value Range: 0->32, 8=1TB) specifies the maximum region size of an address translation region. This register is only used when the INCREASE_REGION_SIZE field in IATU_REGION_CTRL_1_OFF_INBOUND_i is '1'.
            }
        }
        register IATU_REGION_CTRL_1_OFF_OUTBOUND_4 @'h800 {
            bytes 4;
            field TYPE @'h0 {
                bits 5;
                access rw;
                hard_reset 'h0;
                doc {
                    When the address of an outbound TLP is matched to this region, then the TYPE field of the TLP is changed to the value in this register.

Note: This register field is sticky.
                }
            }
            field TC @'h5 {
                bits 3;
                access rw;
                hard_reset 'h0;
                doc {
                    When the address of an outbound TLP is matched to this region, then the TC field of the TLP is changed to the value in this register.

Note: This register field is sticky.
                }
            }
            field TD @'h8 {
                access rw;
                hard_reset 'h0;
                doc {
                    This is a reserved field. Do not use.

Note: This register field is sticky.
                }
            }
            field ATTR @'h9 {
                bits 2;
                access rw;
                hard_reset 'h0;
                doc {
                    When the address of an outbound TLP is matched to this region, then the ATTR field of the TLP is changed to the value in this register.

Note: This register field is sticky.
                }
            }
            field INCREASE_REGION_SIZE @'hd {
                access rw;
                hard_reset 'h0;
                doc {
                    Increase the maximum ATU Region size. When set, the maximum ATU Region size is determined by CX_ATU_MAX_REGION_SIZE. When clear, the maximum ATU Region size is 4 GB (default).

Note: This register field is sticky.
                }
            }
            field CTRL_1_FUNC_NUM @'h14 {
                bits 3;
                access rw;
                hard_reset 'h0;
                doc {
                    Function Number.
 - When the address of an outbound TLP is matched to this region and the FUNC_BYPASS field in the "iATU Control 2 Register" is '0', then the function number used in generating the function part of the requester ID (RID) field of the TLP is taken from this 5-bit register. The value in this register must be 0x0 unless multifunction operation in the controller is enabled (CX_NFUNC > 1).
 - When you are using the AXI Bridge, then this field is swapped before AXI decomposition occurs so that the correct "Max_Read_Request_Size" and "Max_Payload_Size" values are used.

Note: This register field is sticky.
                }
            }
            doc {
                iATU Region Control 1 Register.iATU Region Control 1 Register.
            }
        }
        register IATU_REGION_CTRL_2_OFF_OUTBOUND_4 @'h804 {
            bytes 4;
            field MSG_CODE @'h0 {
                bits 8;
                access rw;
                hard_reset 'h0;
                doc {
                    MSG TLPs (Message Code). When the address of an outbound TLP is matched to this region, and the translated TLP TYPE field is Msg or MsgD; then the message field of the TLP is changed to the value in this register.

Memory TLPs: (ST;Steering Tag). When the ST field of an outbound TLP is matched to this region, and the translated TLP TYPE field targets memory space; then the ST field of the TLP is changed to the value in this register. Only Valid when the CX_TPH_ENABLE configuration parameter is 1.

Note: This register field is sticky.
                }
            }
            field TAG @'h8 {
                bits 8;
                access rw;
                hard_reset 'h0;
                doc {
                    TAG.

The substituted TAG field (byte 6) in the outgoing TLP header when TAG_SUBSTITUTE_EN is set.

Note: This register field is sticky.
                }
            }
            field TAG_SUBSTITUTE_EN @'h10 {
                access rw;
                hard_reset 'h0;
                doc {
                    TAG Substitute Enable.

When enabled and region address is matched, the iATU substitutes the TAG field of the outbound TLP header with the contents of the TAG field in this register. The expected usage scenario is translation from AXI MWr to Vendor Defined Msg/MsgD.

Note (CX_TPH_ENABLE=1): TAG substitution for MWr will not occur because this field (byte 6) in the TLP header is the ST field. ST substitution can still take place using the MSG_CODE field in IATU_REGION_CTRL_2_OFF_OUTBOUND_i.

Note: This register field is sticky.
                }
            }
            field MSB2BITS_TAG @'h11 {
                bits 2;
                access rw;
                hard_reset 'h0;
                doc {
                    TAG.

Two most significant bits of the substituted TAG field in the outgoing TLP header when TAG_SUBSTITUTE_EN is set. 

Note: This register field is sticky.
                }
            }
            field FUNC_BYPASS @'h13 {
                access rw;
                hard_reset 'h0;
                doc {
                    Function Number Translation Bypass. In this mode, the function number of the translated TLP is taken from your application transmit interface and not from the CTRL_1_FUNC_NUM field of the "iATU Control 1 Register" or the VF_NUMBER field of the "iATU Control 3 Register."

Note: This register field is sticky.
                }
            }
            field SNP @'h14 {
                access rw;
                hard_reset 'h0;
                doc {
                    Serialize Non-Posted Requests. In this mode, when the AXI Bridge is populated, same AXI ID Non-Posted Read/Write Requests are transmitted on the wire if there are no other same ID Non-Posted Requests outstanding.

Note: This register field is sticky.
                }
            }
            field TLP_HEADER_FIELDS_BYPASS @'h15 {
                access rw;
                hard_reset 'h0;
                doc {
                    TLP Header Fields Translation Bypass.  In this mode header fields of the translated TLP is taken from your application transmit interface or, if AMBA is configured,  from the AMBA sideband bus (slv_awmisc_info) and not from the corresponding fields of the IATU_REGION_CTRL_1_OFF_OUTBOUND_i  or IATU_REGION_CTRL_2_OFF_OUTBOUND_i registers. The header fields are
 -	TC
 -	PH
 -	TH
 -	ST
 -	AT
 -	Attr (IDO, RO and NS).
Note: This register field is sticky. 

Note: This register field is sticky.
                }
            }
            field INHIBIT_PAYLOAD @'h16 {
                access rw;
                hard_reset 'h0;
                doc {
                    Inhibit TLP Payload Data for TLP's in Matched Region; assign iATU region to be TLP without data.
When enabled and region address is matched, the iATU marks all TLPs as having no payload data by forcing the TLP header Fmt[1] bit =0, regardless of the application inputs such as slv_wstrb.
 - 1: Fmt[1] =0 so that only TLP type without data is sent. For example, a Msg instead of MsgD will be sent.
 - 0: Fmt[1] =0/1 so that TLPs with or without data can be sent. 
Note: This register field is sticky.
                }
            }
            field HEADER_SUBSTITUTE_EN @'h17 {
                access rw;
                hard_reset 'h0;
                doc {
                    Header Substitute Enable.

When enabled and region address is matched, the iATU fully substitutes bytes 8-11 (for 3 DWORD header) or bytes 12-15 (for 4 DWORD header) of the outbound TLP header with the contents of the LWR_TARGET_RW field in IATU_LWR_TARGET_ADDR_OFF_OUTBOUND_i.
 - 1: LWR_TARGET_RW in the iATU_LWR_TARGET_ADDR_OFF_OUTBOUND_i register is used to fill bytes 8-to-11 (for 3 DWORD header) or bytes 12-to-15 (for 4 DWORD header) of the translated TLP header.
 - 0: LWR_TARGET_RW in the iATU_LWR_TARGET_ADDR_OFF_OUTBOUND_i register forms the new address of the translated region.
Note: This register field is sticky.
                }
            }
            field CFG_SHIFT_MODE @'h1c {
                access rw;
                hard_reset 'h0;
                doc {
                    CFG Shift Mode.

The iATU uses bits [27:12] of the untranslated address (on the XALI0/1/2 interface or AXI slave interface address) to form the BDF number of the outgoing CFG TLP.

This supports the Enhanced Configuration Address Mapping (ECAM) mechanism (Section 7.2.2 of the PCI Express Base 3.1 Specification, revision 1.0) by allowing all outgoing I/O and MEM TLPs (that have been translated to CFG) to be mapped from memory space into any 256 MB region of the PCIe configuration space.

Note: This register field is sticky.
                }
            }
            field INVERT_MODE @'h1d {
                access rw;
                hard_reset 'h0;
                doc {
                    Invert Mode. When set the address matching region is inverted. Therefore, an address match occurs when the untranslated address is in the region outside the defined range (Base Address to Limit Address).

Note: This register field is sticky.
                }
            }
            field REGION_EN @'h1f {
                access rw;
                hard_reset 'h0;
                doc {
                    Region Enable. This bit must be set to '1' for address translation to take place.

Note: This register field is sticky.
                }
            }
            doc {
                iATU Region Control 2 Register.iATU Region Control 2 Register.
            }
        }
        register IATU_LWR_BASE_ADDR_OFF_OUTBOUND_4 @'h808 {
            bytes 4;
            field LWR_BASE_HW @'h0 {
                bits 12;
                access ro;
                hard_reset 'h0;
                doc {
                    Forms bits [n-1:0] of the start address of the address region to be translated. The start address must be aligned to a CX_ATU_MIN_REGION_SIZE kB boundary, so these bits are always 0.
A write to this location is ignored by the PCIe controller.

n is log2(CX_ATU_MIN_REGION_SIZE)
                }
            }
            field LWR_BASE_RW @'hc {
                bits 20;
                access rw;
                hard_reset 'h0;
                doc {
                    Forms bits [31:n] of the start address of the address region to be translated. 
n is log2(CX_ATU_MIN_REGION_SIZE)

Note: This register field is sticky.
                }
            }
            doc {
                iATU Lower Base Address Register. The CX_ATU_MIN_REGION_SIZE configuration parameter (Value Range: 4 kB, 8 kB, 16 kB, 32 kB, 64 kB defaults to 64 kB) specifies the minimum size of an address translation region. For example, if set to 64 kB; the lower 16 bits of the Base, Limit and Target registers are zero and all address regions are aligned on 64 kB boundaries. More precisely, the lower log2(CX_ATU_MIN_REGION_SIZE) bits are zero.iATU Lower Base Address Register. The CX_ATU_MIN_REGION_SIZE configuration parameter (Value Range: 4 kB, 8 kB, 16 kB, 32 kB, 64 kB defaults to 64 kB) specifies the minimum size of an address translation region. For example, if set to 64 kB; the lower 16 bits of the Base, Limit and Target registers are zero and all address regions are aligned on 64 kB boundaries. More precisely, the lower log2(CX_ATU_MIN_REGION_SIZE) bits are zero.
            }
        }
        register IATU_UPPER_BASE_ADDR_OFF_OUTBOUND_4 @'h80c {
            bytes 4;
            field UPPER_BASE_RW @'h0 {
                bits 32;
                access rw;
                hard_reset 'h0;
                doc {
                    Forms bits [63:32] of the start (and end) address of the address region to be translated. In systems with a 32-bit address space, this register is not used and therefore writing to this register has no effect.

Note: This register field is sticky.
                }
            }
            doc {
                iATU Upper Base Address Register.iATU Upper Base Address Register.
            }
        }
        register IATU_LIMIT_ADDR_OFF_OUTBOUND_4 @'h810 {
            bytes 4;
            field LIMIT_ADDR_HW @'h0 {
                bits 12;
                access ro;
                hard_reset 'h0;
                doc {
                    Forms lower bits of the end address of the address region to be translated. The end address must be aligned to a CX_ATU_MIN_REGION_SIZE kB boundary, so these bits are always all ones.
A write to this location is ignored by the PCIe controller.
                }
            }
            field LIMIT_ADDR_RW @'hc {
                bits 20;
                access rw;
                hard_reset 'h0;
                doc {
                    Forms upper bits of the end address of the address region to be translated.

Note: This register field is sticky.
                }
            }
            doc {
                iATU Limit Address Register.iATU Limit Address Register.
            }
        }
        register IATU_LWR_TARGET_ADDR_OFF_OUTBOUND_4 @'h814 {
            bytes 4;
            field LWR_TARGET_RW_OUTBOUND @'h0 {
                bits 32;
                access rw;
                hard_reset 'h0;
                doc {
                    When HEADER_SUBSTITUTE_EN in IATU_REGION_CTRL_2_OFF_OUTBOUND_ is '0' (normal operation):
 - LWR_TARGET_RW[31:n] forms MSB's of the Lower Target part of the new address of the translated region;
 - LWR_TARGET_RW[n-1:0] are not used. (The start address must be aligned to a CX_ATU_MIN_REGION_SIZE kB boundary, so the lower bits of the start address of the new address of the translated region (bits n-1:0) are always '0').
 - n is log2(CX_ATU_MIN_REGION_SIZE).
When HEADER_SUBSTITUTE_EN in IATU_REGION_CTRL_2_OFF_OUTBOUND_i is '1':
 - LWR_TARGET_RW[31:0] forms bytes 8-11 (for 3 dword header) or bytes 12-15 (for 4 dword header) of the outbound TLP header. Usage scenarios include the transmission of Vendor Defined Messages where the controller determines the content of bytes 12 to 15 of the TLP header.
Note: This register field is sticky.
                }
            }
            doc {
                iATU Lower Target Address Register.iATU Lower Target Address Register.
            }
        }
        register IATU_UPPER_TARGET_ADDR_OFF_OUTBOUND_4 @'h818 {
            bytes 4;
            field UPPER_TARGET_RW @'h0 {
                bits 32;
                access rw;
                hard_reset 'h0;
                doc {
                    Forms bits [63:32] of the start address (Upper Target part) of the new address of the translated region.

Note: This register field is sticky.
                }
            }
            doc {
                iATU Upper Target Address Register.iATU Upper Target Address Register.
            }
        }
        register IATU_UPPR_LIMIT_ADDR_OFF_OUTBOUND_4 @'h820 {
            bytes 4;
            field UPPR_LIMIT_ADDR_RW @'h0 {
                bits 4;
                access rw;
                hard_reset 'h0;
                doc {
                    Forms the LSB's of the Upper Limit part of the region "end address" to be translated. Only applies to 64-bit systems and when the INCREASE_REGION_SIZE field in IATU_REGION_CTRL_1_OFF_OUTBOUND_i is '1'

Note: This register field is sticky.
                }
            }
            field UPPR_LIMIT_ADDR_HW @'h4 {
                bits 28;
                access ro;
                hard_reset 'h0;
                doc {
                    Forms MSB's of the Upper Limit part of the region "end address" to be translated. Only applies to 64-bit systems and when the INCREASE_REGION_SIZE field in IATU_REGION_CTRL_1_OFF_OUTBOUND_i is '1'. These bits are always '0'.
                }
            }
            doc {
                iATU Upper Limit Address Register. The CX_MAX_ATU_REGION_SIZE configuration parameter (Value Range: 0->32, 8=1TB) specifies the maximum region size of an address translation region. This register is only used when the INCREASE_REGION_SIZE field in IATU_REGION_CTRL_1_OFF_OUTBOUND_i is '1'.iATU Upper Limit Address Register. The CX_MAX_ATU_REGION_SIZE configuration parameter (Value Range: 0->32, 8=1TB) specifies the maximum region size of an address translation region. This register is only used when the INCREASE_REGION_SIZE field in IATU_REGION_CTRL_1_OFF_OUTBOUND_i is '1'.
            }
        }
        register IATU_REGION_CTRL_1_OFF_INBOUND_4 @'h900 {
            bytes 4;
            field TYPE @'h0 {
                bits 5;
                access rw;
                hard_reset 'h0;
                doc {
                    When the TYPE field of an inbound TLP is matched to this value, then address translation proceeds (when all other enabled field-matches are successful).

Note: This register field is sticky.
                }
            }
            field TC @'h5 {
                bits 3;
                access rw;
                hard_reset 'h0;
                doc {
                    When the TC field of an inbound TLP is matched to this value, then address translation proceeds (when all other enabled field-matches are successful). This check is only performed if the "TC Match Enable" bit of the "iATU Control 2 Register" is set.

Note: This register field is sticky.
                }
            }
            field TD @'h8 {
                access rw;
                hard_reset 'h0;
                doc {
                    When the TD field of an inbound TLP is matched to this value, then address translation proceeds (when all other enabled field-matches are successful). This check is only performed if the "TD Match Enable" bit of the "iATU Control 2 Register" is set.

Note: This register field is sticky.
                }
            }
            field ATTR @'h9 {
                bits 2;
                access rw;
                hard_reset 'h0;
                doc {
                    When the ATTR field of an inbound TLP is matched to this value, then address translation proceeds (when all other enabled field-matches are successful). This check is only performed if the "ATTR Match Enable" bit of the "iATU Control 2 Register" is set.

Note: This register field is sticky.
                }
            }
            field INCREASE_REGION_SIZE @'hd {
                access rw;
                hard_reset 'h0;
                doc {
                    Increase the maximum ATU Region size. When set, the maximum ATU Region size is determined by CX_ATU_MAX_REGION_SIZE. When clear, the maximum ATU Region size is 4 GB (default).

Note: This register field is sticky.
                }
            }
            field CTRL_1_FUNC_NUM @'h14 {
                bits 3;
                access rw;
                hard_reset 'h0;
                doc {
                    Function Number.
 - MEM-I/O: When the Address and BAR matching logic in the controller indicate that a MEM-I/O transaction matches a BAR in the function corresponding to this value, then address translation proceeds. This check is only performed if the "Function Number Match Enable" bit of the "iATU Control 2 Register" is set.
 - CFG0/CFG1: When the destination function number as specified in the routing ID of the TLP header matches the function, then address translation proceeds. This check is only performed if the "Function Number Match Enable" bit of the "iATU Control 2 Register" is set.
Note: This register field is sticky.
                }
            }
            doc {
                iATU Region Control 1 Register.iATU Region Control 1 Register.
            }
        }
        register IATU_REGION_CTRL_2_OFF_INBOUND_4 @'h904 {
            bytes 4;
            field MSG_CODE @'h0 {
                bits 8;
                access rw;
                hard_reset 'h0;
                doc {
                    MSG TLPs: (Message Code). When the TYPE field of an inbound Msg/MsgD TLP is matched to this value, then address translation proceeds (when all other enabled field-matches are successful). This check is only performed if the "Message Code Match Enable" bit of the "iATU Control 2 Register" is set.

Memory TLPs: (ST;Steering Tag). When the ST field of an inbound TLP is matched to this value, then address translation proceeds. This check is only performed if the "ST Match Enable" bit of the "iATU Control2 Register" is set. The setting is independent of the setting of the TH field. Only Valid when the CX_TPH_ENABLE configuration parameter is 1.

Note: This register field is sticky.
                }
            }
            field BAR_NUM @'h8 {
                bits 3;
                access rw;
                hard_reset 'h0;
                doc {
                    BAR Number. When the BAR number of an inbound MEM or IO TLP " that is matched by the normal internal BAR address matching mechanism " is the same as this field, address translation proceeds (when all other enabled field-matches are successful). This check is only performed if the "Match Mode" bit of the "iATU Control 2 Register" is set.
 - 000b - BAR0
 - 001b - BAR1
 - 010b - BAR2
 - 011b - BAR3
 - 100b - BAR4
 - 101b - BAR5
 - 110b - ROM
 - 111b - reserved
 - IO translation would require either 00100b or 00101b in the inbound TLP TYPE; the BAR Number set in the range 000b - 101b and that BAR configured as an IO BAR.
Note: This register field is sticky.
                }
            }
            field MSG_TYPE_MATCH_MODE @'hd {
                access rw;
                hard_reset 'h0;
                doc {
                    Message Type Match Mode.

When enabled, and if single address location translate enable is set, then inbound TLPs of type MSG/MSGd which match the type field of the iatu_region_ctrl_1_OFF_inbound register (=>TYPE[4:3]=2'b10) will be translated.
Message type match mode overrides any value of MATCH_MODE field in this register. Usage scenarios for this are translation of VDM or ATS messages when AXI bridge is configured on client interface.

Note: This register field is sticky.
                }
            }
            field TC_MATCH_EN @'he {
                access rw;
                hard_reset 'h0;
                doc {
                    TC Match Enable. Ensures that a successful TC TLP field comparison match (see TC field of the "iATU Control 1 Register") occurs for address translation to proceed.

Note: This register field is sticky.
                }
            }
            field TD_MATCH_EN @'hf {
                access rw;
                hard_reset 'h0;
                doc {
                    TD Match Enable. Ensures that a successful TD TLP field comparison match (see TD field of the "iATU Control 1 Register") occurs for address translation to proceed.

Note: This register field is sticky.
                }
            }
            field ATTR_MATCH_EN @'h10 {
                access rw;
                hard_reset 'h0;
                doc {
                    ATTR Match Enable. Ensures that a successful ATTR TLP field comparison match (see ATTR field of the "iATU Control 1 Register") occurs for address translation to proceed.

Note: This register field is sticky.
                }
            }
            field FUNC_NUM_MATCH_EN @'h13 {
                access rw;
                hard_reset 'h0;
                doc {
                    Function Number Match Enable. Ensures that a successful Function Number TLP field comparison match (see Function Number field of the "iATU Control 1 Register") occurs (in MEM-I/O and CFG0/CFG1 transactions) for address translation to proceed.

Note: This register field is sticky.
                }
            }
            field MSG_CODE_MATCH_EN @'h15 {
                access rw;
                hard_reset 'h0;
                doc {
                    Message Code Match Enable (Msg TLPS). Ensures that a successful message Code TLP field comparison match (see Message Code field of the "iATU Control 2 Register") occurs (in MSG transactions) for address translation to proceed.

ST Match Enable (Mem TLPs). Ensures that a successful ST TLP field comparison match (see ST field of the "iATU Control 2 Register") occurs (in MEM transactions) for address translation to proceed. Only Valid when the CX_TPH_ENABLE configuration parameter is 1

Note: This register field is sticky.
                }
            }
            field SINGLE_ADDR_LOC_TRANS_EN @'h17 {
                access rw;
                hard_reset 'h0;
                doc {
                    Single Address Location Translate Enable.

When enabled, Rx TLPs can be translated to a single address location as determined by the target address register of the iATU region.
The main usage scenario is translation of Messages (such as Vendor Defined or ATS Messages) to MWr TLPs when the AXI bridge is enabled.

Note: This register field is sticky.
                }
            }
            field RESPONSE_CODE @'h18 {
                bits 2;
                access rw;
                hard_reset 'h0;
                doc {
                    Response Code. Defines the type of response to give for accesses matching this region. This overrides the normal RADM filter response. Note that this feature is not available for any region where Single Address Location Translate is enabled.
 - 00 - Normal RADM filter response is used.
 - 01 - Unsupported request (UR)
 - 10 - Completer abort (CA)
 - 11 - Not used / undefined / reserved.
Note: This register field is sticky.
                }
            }
            field FUZZY_TYPE_MATCH_CODE @'h1b {
                access rw;
                hard_reset 'h0;
                doc {
                    Fuzzy Type Match Mode. When enabled, the iATU relaxes the matching of the TLP TYPE field against the expected TYPE field so that
 - CfgRd0 and CfgRd1 TLPs are seen as identical. Similarly with CfgWr0 and CfgWr1.
 - MWr, MRd and MRdLk TLPs are seen as identical
 - The Routing field of Msg/MsgD TLPs is ignored
 - FetchAdd, Swap and CAS are seen as identical.
For example, CFG0 in the TYPE field in the "iATU Control 1 Register" matches against an inbound CfgRd0, CfgRd1, CfgWr0 or CfgWr1 TLP.

Note: This register field is sticky.
                }
            }
            field CFG_SHIFT_MODE @'h1c {
                access rw;
                hard_reset 'h0;
                doc {
                    CFG Shift Mode. This is useful for CFG transactions where the PCIe configuration mechanism maps bits [27:12] of the address to the bus/device and function number. This allows a CFG configuration space to be located in any 256MB window of your application memory space using a 28-bit effective address. Shifts bits [31:16] of the untranslated address to form bits [27:12] of the translated address.

Note: This register field is sticky.
                }
            }
            field INVERT_MODE @'h1d {
                access rw;
                hard_reset 'h0;
                doc {
                    Invert Mode. When set the address matching region is inverted. Therefore, an address match occurs when the untranslated address is in the region outside the defined range (Base Address to Limit Address).

Note: This register field is sticky.
                }
            }
            field MATCH_MODE @'h1e {
                access rw;
                hard_reset 'h0;
                doc {
                    Match Mode. Determines Inbound matching mode for TLPs. The mode depends on the type of TLP that is received as follows:

 For MEM-I/O TLPs, this field is interpreted as follows:
 - 0: Address Match Mode. The iATU operates using addresses as in the outbound direction. The Region Base and Limit Registers must be setup.
 - 1:BAR Match Mode. BAR matching is used. The "BAR Number" field is relevant. Not used for RC.
For CFG0 TLPs, this field is interpreted as follows:
 - 0: Routing ID Match Mode. The iATU interprets the Routing ID (Bytes 8 to 11 of TLP header) as an address. This corresponds to the upper 16 bits of the address in MEM-I/O transactions. The Routing ID of the TLP must be within the base and limit of the iATU region for matching to proceed.
 - 1: Accept Mode. The iATU accepts all CFG0 transactions as address matches. The routing ID in the CFG0 TLP is ignored. This is useful as all received CFG0 TLPs should be processed regardless of the Bus number.
For MSG/MSGD TLPs, this field is interpreted as follows:
 - 0: Address Match Mode. The iATU treats the third dword and fourth dword of the inbound MSG/MSGD TLP as an address and it is matched against the Region Base and Limit Registers.
 - 1: Vendor ID Match Mode. This mode is relevant for ID-routed Vendor Defined Messages. The iATU ignores the Routing ID (Bus, Device, Function) in bits [31:16] of the third dword of the TLP header, but matches against the Vendor ID in bits [15:0] of the third dword of the TLP header. Bits [15:0] of the Region Upper Base register should be programmed with the required Vendor ID. The lower Base and Limit Register should be programmed to translate TLPs based on vendor specific information in the fourth dword of the TLP header.
 -	If SINGLE_ADDRESS_LOCATION_TRANSLATE_EN = 1 AND MSG_TYPE_MATCH_MODE = 1, then Match Mode is ignored.
Note: This register field is sticky.
                }
            }
            field REGION_EN @'h1f {
                access rw;
                hard_reset 'h0;
                doc {
                    Region Enable. This bit must be set to '1' for address translation to take place.

Note: This register field is sticky.
                }
            }
            doc {
                iATU Region Control 2 Register.iATU Region Control 2 Register.
            }
        }
        register IATU_LWR_BASE_ADDR_OFF_INBOUND_4 @'h908 {
            bytes 4;
            field LWR_BASE_HW @'h0 {
                bits 12;
                access ro;
                hard_reset 'h0;
                doc {
                    Forms bits [n-1:0] of the start address of the address region to be translated. The start address must be aligned to a CX_ATU_MIN_REGION_SIZE kB boundary, so these bits are always 0.
A write to this location is ignored by the PCIe controller.

n is log2(CX_ATU_MIN_REGION_SIZE)
                }
            }
            field LWR_BASE_RW @'hc {
                bits 20;
                access rw;
                hard_reset 'h0;
                doc {
                    Forms bits [31:n] of the start address of the address region to be translated. 
n is log2(CX_ATU_MIN_REGION_SIZE)

Note: This register field is sticky.
                }
            }
            doc {
                iATU Lower Base Address Register. The CX_ATU_MIN_REGION_SIZE configuration parameter (Value Range: 4 kB, 8 kB, 16 kB, 32 kB, 64 kB defaults to 64 kB) specifies the minimum size of an address translation region. For example, if set to 64 kB; the lower 16 bits of the Base, Limit and Target registers are zero and all address regions are aligned on 64 kB boundaries. More precisely, the lower log2(CX_ATU_MIN_REGION_SIZE) bits are zero.iATU Lower Base Address Register. The CX_ATU_MIN_REGION_SIZE configuration parameter (Value Range: 4 kB, 8 kB, 16 kB, 32 kB, 64 kB defaults to 64 kB) specifies the minimum size of an address translation region. For example, if set to 64 kB; the lower 16 bits of the Base, Limit and Target registers are zero and all address regions are aligned on 64 kB boundaries. More precisely, the lower log2(CX_ATU_MIN_REGION_SIZE) bits are zero.
            }
        }
        register IATU_UPPER_BASE_ADDR_OFF_INBOUND_4 @'h90c {
            bytes 4;
            field UPPER_BASE_RW @'h0 {
                bits 32;
                access rw;
                hard_reset 'h0;
                doc {
                    Forms bits [63:32] of the start (and end) address of the address region to be translated.

Note: This register field is sticky.
                }
            }
            doc {
                iATU Upper Base Address Register.iATU Upper Base Address Register.
            }
        }
        register IATU_LIMIT_ADDR_OFF_INBOUND_4 @'h910 {
            bytes 4;
            field LIMIT_ADDR_HW @'h0 {
                bits 12;
                access ro;
                hard_reset 'h0;
                doc {
                    Forms lower bits of the end address of the address region to be translated. The end address must be aligned to a CX_ATU_MIN_REGION_SIZE kB boundary, so these bits are always all ones.
A write to this location is ignored by the PCIe controller.
                }
            }
            field LIMIT_ADDR_RW @'hc {
                bits 20;
                access rw;
                hard_reset 'h0;
                doc {
                    Forms upper bits of the end address of the address region to be translated.

Note: This register field is sticky.
                }
            }
            doc {
                iATU Limit Address Register.iATU Limit Address Register.
            }
        }
        register IATU_LWR_TARGET_ADDR_OFF_INBOUND_4 @'h914 {
            bytes 4;
            field LWR_TARGET_HW @'h0 {
                bits 12;
                access ro;
                hard_reset 'h0;
                doc {
                    Forms the LSB's of the Lower Target part of the new address of the translated region. The start address must be aligned to a CX_ATU_MIN_REGION_SIZE kB boundary (in address match mode); and to the Bar size boundary (in BAR match mode) so that these bits are always '0'. If the BAR is smaller than the iATU region size, then the iATU target address must align to the iATU region size; otherwise it must align to the BAR size.

A write to this location is ignored by the PCIe controller.
 - Field size depends on log2(CX_ATU_MIN_REGION_SIZE) in address match mode.
 - Field size depends on log2(BAR_MASK+1) in BAR match mode.
                }
            }
            field LWR_TARGET_RW @'hc {
                bits 20;
                access rw;
                hard_reset 'h0;
                doc {
                    Forms MSB's of the Lower Target part of the new address of the translated region. These bits are always '0'.
 - Field size depends on log2(CX_ATU_MIN_REGION_SIZE) in address match mode.
 - Field size depends on log2(BAR_MASK+1) in BAR match mode.
Note: This register field is sticky.
                }
            }
            doc {
                iATU Lower Target Address Register.iATU Lower Target Address Register.
            }
        }
        register IATU_UPPER_TARGET_ADDR_OFF_INBOUND_4 @'h918 {
            bytes 4;
            field UPPER_TARGET_RW @'h0 {
                bits 32;
                access rw;
                hard_reset 'h0;
                doc {
                    Forms bits [63:32] of the start address (Upper Target part) of the new address of the translated region. In systems with a 32-bit address space, this register is not used and therefore writing to this register has no effect.

Note: This register field is sticky.
                }
            }
            doc {
                iATU Upper Target Address Register.iATU Upper Target Address Register.
            }
        }
        register IATU_UPPR_LIMIT_ADDR_OFF_INBOUND_4 @'h920 {
            bytes 4;
            field UPPR_LIMIT_ADDR_RW @'h0 {
                bits 4;
                access rw;
                hard_reset 'h0;
                doc {
                    Forms the LSB's of the Upper Limit part of the region "end address" to be translated. Only applies to 64-bit systems and when the INCREASE_REGION_SIZE field in IATU_REGION_CTRL_1_OFF_INBOUND_i is '1'

Note: This register field is sticky.
                }
            }
            field UPPR_LIMIT_ADDR_HW @'h4 {
                bits 28;
                access ro;
                hard_reset 'h0;
                doc {
                    Forms MSB's of the Upper Limit part of the region "end address" to be translated. Only applies to 64-bit systems and when the INCREASE_REGION_SIZE field in IATU_REGION_CTRL_1_OFF_INBOUND_i is '1'. These bits are always '0'.
                }
            }
            doc {
                iATU Upper Limit Address Register. The CX_MAX_ATU_REGION_SIZE configuration parameter (Value Range: 0->32, 8=1TB) specifies the maximum region size of an address translation region. This register is only used when the INCREASE_REGION_SIZE field in IATU_REGION_CTRL_1_OFF_INBOUND_i is '1'.iATU Upper Limit Address Register. The CX_MAX_ATU_REGION_SIZE configuration parameter (Value Range: 0->32, 8=1TB) specifies the maximum region size of an address translation region. This register is only used when the INCREASE_REGION_SIZE field in IATU_REGION_CTRL_1_OFF_INBOUND_i is '1'.
            }
        }
        register IATU_REGION_CTRL_1_OFF_OUTBOUND_5 @'ha00 {
            bytes 4;
            field TYPE @'h0 {
                bits 5;
                access rw;
                hard_reset 'h0;
                doc {
                    When the address of an outbound TLP is matched to this region, then the TYPE field of the TLP is changed to the value in this register.

Note: This register field is sticky.
                }
            }
            field TC @'h5 {
                bits 3;
                access rw;
                hard_reset 'h0;
                doc {
                    When the address of an outbound TLP is matched to this region, then the TC field of the TLP is changed to the value in this register.

Note: This register field is sticky.
                }
            }
            field TD @'h8 {
                access rw;
                hard_reset 'h0;
                doc {
                    This is a reserved field. Do not use.

Note: This register field is sticky.
                }
            }
            field ATTR @'h9 {
                bits 2;
                access rw;
                hard_reset 'h0;
                doc {
                    When the address of an outbound TLP is matched to this region, then the ATTR field of the TLP is changed to the value in this register.

Note: This register field is sticky.
                }
            }
            field INCREASE_REGION_SIZE @'hd {
                access rw;
                hard_reset 'h0;
                doc {
                    Increase the maximum ATU Region size. When set, the maximum ATU Region size is determined by CX_ATU_MAX_REGION_SIZE. When clear, the maximum ATU Region size is 4 GB (default).

Note: This register field is sticky.
                }
            }
            field CTRL_1_FUNC_NUM @'h14 {
                bits 3;
                access rw;
                hard_reset 'h0;
                doc {
                    Function Number.
 - When the address of an outbound TLP is matched to this region and the FUNC_BYPASS field in the "iATU Control 2 Register" is '0', then the function number used in generating the function part of the requester ID (RID) field of the TLP is taken from this 5-bit register. The value in this register must be 0x0 unless multifunction operation in the controller is enabled (CX_NFUNC > 1).
 - When you are using the AXI Bridge, then this field is swapped before AXI decomposition occurs so that the correct "Max_Read_Request_Size" and "Max_Payload_Size" values are used.

Note: This register field is sticky.
                }
            }
            doc {
                iATU Region Control 1 Register.iATU Region Control 1 Register.
            }
        }
        register IATU_REGION_CTRL_2_OFF_OUTBOUND_5 @'ha04 {
            bytes 4;
            field MSG_CODE @'h0 {
                bits 8;
                access rw;
                hard_reset 'h0;
                doc {
                    MSG TLPs (Message Code). When the address of an outbound TLP is matched to this region, and the translated TLP TYPE field is Msg or MsgD; then the message field of the TLP is changed to the value in this register.

Memory TLPs: (ST;Steering Tag). When the ST field of an outbound TLP is matched to this region, and the translated TLP TYPE field targets memory space; then the ST field of the TLP is changed to the value in this register. Only Valid when the CX_TPH_ENABLE configuration parameter is 1.

Note: This register field is sticky.
                }
            }
            field TAG @'h8 {
                bits 8;
                access rw;
                hard_reset 'h0;
                doc {
                    TAG.

The substituted TAG field (byte 6) in the outgoing TLP header when TAG_SUBSTITUTE_EN is set.

Note: This register field is sticky.
                }
            }
            field TAG_SUBSTITUTE_EN @'h10 {
                access rw;
                hard_reset 'h0;
                doc {
                    TAG Substitute Enable.

When enabled and region address is matched, the iATU substitutes the TAG field of the outbound TLP header with the contents of the TAG field in this register. The expected usage scenario is translation from AXI MWr to Vendor Defined Msg/MsgD.

Note (CX_TPH_ENABLE=1): TAG substitution for MWr will not occur because this field (byte 6) in the TLP header is the ST field. ST substitution can still take place using the MSG_CODE field in IATU_REGION_CTRL_2_OFF_OUTBOUND_i.

Note: This register field is sticky.
                }
            }
            field MSB2BITS_TAG @'h11 {
                bits 2;
                access rw;
                hard_reset 'h0;
                doc {
                    TAG.

Two most significant bits of the substituted TAG field in the outgoing TLP header when TAG_SUBSTITUTE_EN is set. 

Note: This register field is sticky.
                }
            }
            field FUNC_BYPASS @'h13 {
                access rw;
                hard_reset 'h0;
                doc {
                    Function Number Translation Bypass. In this mode, the function number of the translated TLP is taken from your application transmit interface and not from the CTRL_1_FUNC_NUM field of the "iATU Control 1 Register" or the VF_NUMBER field of the "iATU Control 3 Register."

Note: This register field is sticky.
                }
            }
            field SNP @'h14 {
                access rw;
                hard_reset 'h0;
                doc {
                    Serialize Non-Posted Requests. In this mode, when the AXI Bridge is populated, same AXI ID Non-Posted Read/Write Requests are transmitted on the wire if there are no other same ID Non-Posted Requests outstanding.

Note: This register field is sticky.
                }
            }
            field TLP_HEADER_FIELDS_BYPASS @'h15 {
                access rw;
                hard_reset 'h0;
                doc {
                    TLP Header Fields Translation Bypass.  In this mode header fields of the translated TLP is taken from your application transmit interface or, if AMBA is configured,  from the AMBA sideband bus (slv_awmisc_info) and not from the corresponding fields of the IATU_REGION_CTRL_1_OFF_OUTBOUND_i  or IATU_REGION_CTRL_2_OFF_OUTBOUND_i registers. The header fields are
 -	TC
 -	PH
 -	TH
 -	ST
 -	AT
 -	Attr (IDO, RO and NS).
Note: This register field is sticky. 

Note: This register field is sticky.
                }
            }
            field INHIBIT_PAYLOAD @'h16 {
                access rw;
                hard_reset 'h0;
                doc {
                    Inhibit TLP Payload Data for TLP's in Matched Region; assign iATU region to be TLP without data.
When enabled and region address is matched, the iATU marks all TLPs as having no payload data by forcing the TLP header Fmt[1] bit =0, regardless of the application inputs such as slv_wstrb.
 - 1: Fmt[1] =0 so that only TLP type without data is sent. For example, a Msg instead of MsgD will be sent.
 - 0: Fmt[1] =0/1 so that TLPs with or without data can be sent. 
Note: This register field is sticky.
                }
            }
            field HEADER_SUBSTITUTE_EN @'h17 {
                access rw;
                hard_reset 'h0;
                doc {
                    Header Substitute Enable.

When enabled and region address is matched, the iATU fully substitutes bytes 8-11 (for 3 DWORD header) or bytes 12-15 (for 4 DWORD header) of the outbound TLP header with the contents of the LWR_TARGET_RW field in IATU_LWR_TARGET_ADDR_OFF_OUTBOUND_i.
 - 1: LWR_TARGET_RW in the iATU_LWR_TARGET_ADDR_OFF_OUTBOUND_i register is used to fill bytes 8-to-11 (for 3 DWORD header) or bytes 12-to-15 (for 4 DWORD header) of the translated TLP header.
 - 0: LWR_TARGET_RW in the iATU_LWR_TARGET_ADDR_OFF_OUTBOUND_i register forms the new address of the translated region.
Note: This register field is sticky.
                }
            }
            field CFG_SHIFT_MODE @'h1c {
                access rw;
                hard_reset 'h0;
                doc {
                    CFG Shift Mode.

The iATU uses bits [27:12] of the untranslated address (on the XALI0/1/2 interface or AXI slave interface address) to form the BDF number of the outgoing CFG TLP.

This supports the Enhanced Configuration Address Mapping (ECAM) mechanism (Section 7.2.2 of the PCI Express Base 3.1 Specification, revision 1.0) by allowing all outgoing I/O and MEM TLPs (that have been translated to CFG) to be mapped from memory space into any 256 MB region of the PCIe configuration space.

Note: This register field is sticky.
                }
            }
            field INVERT_MODE @'h1d {
                access rw;
                hard_reset 'h0;
                doc {
                    Invert Mode. When set the address matching region is inverted. Therefore, an address match occurs when the untranslated address is in the region outside the defined range (Base Address to Limit Address).

Note: This register field is sticky.
                }
            }
            field REGION_EN @'h1f {
                access rw;
                hard_reset 'h0;
                doc {
                    Region Enable. This bit must be set to '1' for address translation to take place.

Note: This register field is sticky.
                }
            }
            doc {
                iATU Region Control 2 Register.iATU Region Control 2 Register.
            }
        }
        register IATU_LWR_BASE_ADDR_OFF_OUTBOUND_5 @'ha08 {
            bytes 4;
            field LWR_BASE_HW @'h0 {
                bits 12;
                access ro;
                hard_reset 'h0;
                doc {
                    Forms bits [n-1:0] of the start address of the address region to be translated. The start address must be aligned to a CX_ATU_MIN_REGION_SIZE kB boundary, so these bits are always 0.
A write to this location is ignored by the PCIe controller.

n is log2(CX_ATU_MIN_REGION_SIZE)
                }
            }
            field LWR_BASE_RW @'hc {
                bits 20;
                access rw;
                hard_reset 'h0;
                doc {
                    Forms bits [31:n] of the start address of the address region to be translated. 
n is log2(CX_ATU_MIN_REGION_SIZE)

Note: This register field is sticky.
                }
            }
            doc {
                iATU Lower Base Address Register. The CX_ATU_MIN_REGION_SIZE configuration parameter (Value Range: 4 kB, 8 kB, 16 kB, 32 kB, 64 kB defaults to 64 kB) specifies the minimum size of an address translation region. For example, if set to 64 kB; the lower 16 bits of the Base, Limit and Target registers are zero and all address regions are aligned on 64 kB boundaries. More precisely, the lower log2(CX_ATU_MIN_REGION_SIZE) bits are zero.iATU Lower Base Address Register. The CX_ATU_MIN_REGION_SIZE configuration parameter (Value Range: 4 kB, 8 kB, 16 kB, 32 kB, 64 kB defaults to 64 kB) specifies the minimum size of an address translation region. For example, if set to 64 kB; the lower 16 bits of the Base, Limit and Target registers are zero and all address regions are aligned on 64 kB boundaries. More precisely, the lower log2(CX_ATU_MIN_REGION_SIZE) bits are zero.
            }
        }
        register IATU_UPPER_BASE_ADDR_OFF_OUTBOUND_5 @'ha0c {
            bytes 4;
            field UPPER_BASE_RW @'h0 {
                bits 32;
                access rw;
                hard_reset 'h0;
                doc {
                    Forms bits [63:32] of the start (and end) address of the address region to be translated. In systems with a 32-bit address space, this register is not used and therefore writing to this register has no effect.

Note: This register field is sticky.
                }
            }
            doc {
                iATU Upper Base Address Register.iATU Upper Base Address Register.
            }
        }
        register IATU_LIMIT_ADDR_OFF_OUTBOUND_5 @'ha10 {
            bytes 4;
            field LIMIT_ADDR_HW @'h0 {
                bits 12;
                access ro;
                hard_reset 'h0;
                doc {
                    Forms lower bits of the end address of the address region to be translated. The end address must be aligned to a CX_ATU_MIN_REGION_SIZE kB boundary, so these bits are always all ones.
A write to this location is ignored by the PCIe controller.
                }
            }
            field LIMIT_ADDR_RW @'hc {
                bits 20;
                access rw;
                hard_reset 'h0;
                doc {
                    Forms upper bits of the end address of the address region to be translated.

Note: This register field is sticky.
                }
            }
            doc {
                iATU Limit Address Register.iATU Limit Address Register.
            }
        }
        register IATU_LWR_TARGET_ADDR_OFF_OUTBOUND_5 @'ha14 {
            bytes 4;
            field LWR_TARGET_RW_OUTBOUND @'h0 {
                bits 32;
                access rw;
                hard_reset 'h0;
                doc {
                    When HEADER_SUBSTITUTE_EN in IATU_REGION_CTRL_2_OFF_OUTBOUND_ is '0' (normal operation):
 - LWR_TARGET_RW[31:n] forms MSB's of the Lower Target part of the new address of the translated region;
 - LWR_TARGET_RW[n-1:0] are not used. (The start address must be aligned to a CX_ATU_MIN_REGION_SIZE kB boundary, so the lower bits of the start address of the new address of the translated region (bits n-1:0) are always '0').
 - n is log2(CX_ATU_MIN_REGION_SIZE).
When HEADER_SUBSTITUTE_EN in IATU_REGION_CTRL_2_OFF_OUTBOUND_i is '1':
 - LWR_TARGET_RW[31:0] forms bytes 8-11 (for 3 dword header) or bytes 12-15 (for 4 dword header) of the outbound TLP header. Usage scenarios include the transmission of Vendor Defined Messages where the controller determines the content of bytes 12 to 15 of the TLP header.
Note: This register field is sticky.
                }
            }
            doc {
                iATU Lower Target Address Register.iATU Lower Target Address Register.
            }
        }
        register IATU_UPPER_TARGET_ADDR_OFF_OUTBOUND_5 @'ha18 {
            bytes 4;
            field UPPER_TARGET_RW @'h0 {
                bits 32;
                access rw;
                hard_reset 'h0;
                doc {
                    Forms bits [63:32] of the start address (Upper Target part) of the new address of the translated region.

Note: This register field is sticky.
                }
            }
            doc {
                iATU Upper Target Address Register.iATU Upper Target Address Register.
            }
        }
        register IATU_UPPR_LIMIT_ADDR_OFF_OUTBOUND_5 @'ha20 {
            bytes 4;
            field UPPR_LIMIT_ADDR_RW @'h0 {
                bits 4;
                access rw;
                hard_reset 'h0;
                doc {
                    Forms the LSB's of the Upper Limit part of the region "end address" to be translated. Only applies to 64-bit systems and when the INCREASE_REGION_SIZE field in IATU_REGION_CTRL_1_OFF_OUTBOUND_i is '1'

Note: This register field is sticky.
                }
            }
            field UPPR_LIMIT_ADDR_HW @'h4 {
                bits 28;
                access ro;
                hard_reset 'h0;
                doc {
                    Forms MSB's of the Upper Limit part of the region "end address" to be translated. Only applies to 64-bit systems and when the INCREASE_REGION_SIZE field in IATU_REGION_CTRL_1_OFF_OUTBOUND_i is '1'. These bits are always '0'.
                }
            }
            doc {
                iATU Upper Limit Address Register. The CX_MAX_ATU_REGION_SIZE configuration parameter (Value Range: 0->32, 8=1TB) specifies the maximum region size of an address translation region. This register is only used when the INCREASE_REGION_SIZE field in IATU_REGION_CTRL_1_OFF_OUTBOUND_i is '1'.iATU Upper Limit Address Register. The CX_MAX_ATU_REGION_SIZE configuration parameter (Value Range: 0->32, 8=1TB) specifies the maximum region size of an address translation region. This register is only used when the INCREASE_REGION_SIZE field in IATU_REGION_CTRL_1_OFF_OUTBOUND_i is '1'.
            }
        }
        register IATU_REGION_CTRL_1_OFF_INBOUND_5 @'hb00 {
            bytes 4;
            field TYPE @'h0 {
                bits 5;
                access rw;
                hard_reset 'h0;
                doc {
                    When the TYPE field of an inbound TLP is matched to this value, then address translation proceeds (when all other enabled field-matches are successful).

Note: This register field is sticky.
                }
            }
            field TC @'h5 {
                bits 3;
                access rw;
                hard_reset 'h0;
                doc {
                    When the TC field of an inbound TLP is matched to this value, then address translation proceeds (when all other enabled field-matches are successful). This check is only performed if the "TC Match Enable" bit of the "iATU Control 2 Register" is set.

Note: This register field is sticky.
                }
            }
            field TD @'h8 {
                access rw;
                hard_reset 'h0;
                doc {
                    When the TD field of an inbound TLP is matched to this value, then address translation proceeds (when all other enabled field-matches are successful). This check is only performed if the "TD Match Enable" bit of the "iATU Control 2 Register" is set.

Note: This register field is sticky.
                }
            }
            field ATTR @'h9 {
                bits 2;
                access rw;
                hard_reset 'h0;
                doc {
                    When the ATTR field of an inbound TLP is matched to this value, then address translation proceeds (when all other enabled field-matches are successful). This check is only performed if the "ATTR Match Enable" bit of the "iATU Control 2 Register" is set.

Note: This register field is sticky.
                }
            }
            field INCREASE_REGION_SIZE @'hd {
                access rw;
                hard_reset 'h0;
                doc {
                    Increase the maximum ATU Region size. When set, the maximum ATU Region size is determined by CX_ATU_MAX_REGION_SIZE. When clear, the maximum ATU Region size is 4 GB (default).

Note: This register field is sticky.
                }
            }
            field CTRL_1_FUNC_NUM @'h14 {
                bits 3;
                access rw;
                hard_reset 'h0;
                doc {
                    Function Number.
 - MEM-I/O: When the Address and BAR matching logic in the controller indicate that a MEM-I/O transaction matches a BAR in the function corresponding to this value, then address translation proceeds. This check is only performed if the "Function Number Match Enable" bit of the "iATU Control 2 Register" is set.
 - CFG0/CFG1: When the destination function number as specified in the routing ID of the TLP header matches the function, then address translation proceeds. This check is only performed if the "Function Number Match Enable" bit of the "iATU Control 2 Register" is set.
Note: This register field is sticky.
                }
            }
            doc {
                iATU Region Control 1 Register.iATU Region Control 1 Register.
            }
        }
        register IATU_REGION_CTRL_2_OFF_INBOUND_5 @'hb04 {
            bytes 4;
            field MSG_CODE @'h0 {
                bits 8;
                access rw;
                hard_reset 'h0;
                doc {
                    MSG TLPs: (Message Code). When the TYPE field of an inbound Msg/MsgD TLP is matched to this value, then address translation proceeds (when all other enabled field-matches are successful). This check is only performed if the "Message Code Match Enable" bit of the "iATU Control 2 Register" is set.

Memory TLPs: (ST;Steering Tag). When the ST field of an inbound TLP is matched to this value, then address translation proceeds. This check is only performed if the "ST Match Enable" bit of the "iATU Control2 Register" is set. The setting is independent of the setting of the TH field. Only Valid when the CX_TPH_ENABLE configuration parameter is 1.

Note: This register field is sticky.
                }
            }
            field BAR_NUM @'h8 {
                bits 3;
                access rw;
                hard_reset 'h0;
                doc {
                    BAR Number. When the BAR number of an inbound MEM or IO TLP " that is matched by the normal internal BAR address matching mechanism " is the same as this field, address translation proceeds (when all other enabled field-matches are successful). This check is only performed if the "Match Mode" bit of the "iATU Control 2 Register" is set.
 - 000b - BAR0
 - 001b - BAR1
 - 010b - BAR2
 - 011b - BAR3
 - 100b - BAR4
 - 101b - BAR5
 - 110b - ROM
 - 111b - reserved
 - IO translation would require either 00100b or 00101b in the inbound TLP TYPE; the BAR Number set in the range 000b - 101b and that BAR configured as an IO BAR.
Note: This register field is sticky.
                }
            }
            field MSG_TYPE_MATCH_MODE @'hd {
                access rw;
                hard_reset 'h0;
                doc {
                    Message Type Match Mode.

When enabled, and if single address location translate enable is set, then inbound TLPs of type MSG/MSGd which match the type field of the iatu_region_ctrl_1_OFF_inbound register (=>TYPE[4:3]=2'b10) will be translated.
Message type match mode overrides any value of MATCH_MODE field in this register. Usage scenarios for this are translation of VDM or ATS messages when AXI bridge is configured on client interface.

Note: This register field is sticky.
                }
            }
            field TC_MATCH_EN @'he {
                access rw;
                hard_reset 'h0;
                doc {
                    TC Match Enable. Ensures that a successful TC TLP field comparison match (see TC field of the "iATU Control 1 Register") occurs for address translation to proceed.

Note: This register field is sticky.
                }
            }
            field TD_MATCH_EN @'hf {
                access rw;
                hard_reset 'h0;
                doc {
                    TD Match Enable. Ensures that a successful TD TLP field comparison match (see TD field of the "iATU Control 1 Register") occurs for address translation to proceed.

Note: This register field is sticky.
                }
            }
            field ATTR_MATCH_EN @'h10 {
                access rw;
                hard_reset 'h0;
                doc {
                    ATTR Match Enable. Ensures that a successful ATTR TLP field comparison match (see ATTR field of the "iATU Control 1 Register") occurs for address translation to proceed.

Note: This register field is sticky.
                }
            }
            field FUNC_NUM_MATCH_EN @'h13 {
                access rw;
                hard_reset 'h0;
                doc {
                    Function Number Match Enable. Ensures that a successful Function Number TLP field comparison match (see Function Number field of the "iATU Control 1 Register") occurs (in MEM-I/O and CFG0/CFG1 transactions) for address translation to proceed.

Note: This register field is sticky.
                }
            }
            field MSG_CODE_MATCH_EN @'h15 {
                access rw;
                hard_reset 'h0;
                doc {
                    Message Code Match Enable (Msg TLPS). Ensures that a successful message Code TLP field comparison match (see Message Code field of the "iATU Control 2 Register") occurs (in MSG transactions) for address translation to proceed.

ST Match Enable (Mem TLPs). Ensures that a successful ST TLP field comparison match (see ST field of the "iATU Control 2 Register") occurs (in MEM transactions) for address translation to proceed. Only Valid when the CX_TPH_ENABLE configuration parameter is 1

Note: This register field is sticky.
                }
            }
            field SINGLE_ADDR_LOC_TRANS_EN @'h17 {
                access rw;
                hard_reset 'h0;
                doc {
                    Single Address Location Translate Enable.

When enabled, Rx TLPs can be translated to a single address location as determined by the target address register of the iATU region.
The main usage scenario is translation of Messages (such as Vendor Defined or ATS Messages) to MWr TLPs when the AXI bridge is enabled.

Note: This register field is sticky.
                }
            }
            field RESPONSE_CODE @'h18 {
                bits 2;
                access rw;
                hard_reset 'h0;
                doc {
                    Response Code. Defines the type of response to give for accesses matching this region. This overrides the normal RADM filter response. Note that this feature is not available for any region where Single Address Location Translate is enabled.
 - 00 - Normal RADM filter response is used.
 - 01 - Unsupported request (UR)
 - 10 - Completer abort (CA)
 - 11 - Not used / undefined / reserved.
Note: This register field is sticky.
                }
            }
            field FUZZY_TYPE_MATCH_CODE @'h1b {
                access rw;
                hard_reset 'h0;
                doc {
                    Fuzzy Type Match Mode. When enabled, the iATU relaxes the matching of the TLP TYPE field against the expected TYPE field so that
 - CfgRd0 and CfgRd1 TLPs are seen as identical. Similarly with CfgWr0 and CfgWr1.
 - MWr, MRd and MRdLk TLPs are seen as identical
 - The Routing field of Msg/MsgD TLPs is ignored
 - FetchAdd, Swap and CAS are seen as identical.
For example, CFG0 in the TYPE field in the "iATU Control 1 Register" matches against an inbound CfgRd0, CfgRd1, CfgWr0 or CfgWr1 TLP.

Note: This register field is sticky.
                }
            }
            field CFG_SHIFT_MODE @'h1c {
                access rw;
                hard_reset 'h0;
                doc {
                    CFG Shift Mode. This is useful for CFG transactions where the PCIe configuration mechanism maps bits [27:12] of the address to the bus/device and function number. This allows a CFG configuration space to be located in any 256MB window of your application memory space using a 28-bit effective address. Shifts bits [31:16] of the untranslated address to form bits [27:12] of the translated address.

Note: This register field is sticky.
                }
            }
            field INVERT_MODE @'h1d {
                access rw;
                hard_reset 'h0;
                doc {
                    Invert Mode. When set the address matching region is inverted. Therefore, an address match occurs when the untranslated address is in the region outside the defined range (Base Address to Limit Address).

Note: This register field is sticky.
                }
            }
            field MATCH_MODE @'h1e {
                access rw;
                hard_reset 'h0;
                doc {
                    Match Mode. Determines Inbound matching mode for TLPs. The mode depends on the type of TLP that is received as follows:

 For MEM-I/O TLPs, this field is interpreted as follows:
 - 0: Address Match Mode. The iATU operates using addresses as in the outbound direction. The Region Base and Limit Registers must be setup.
 - 1:BAR Match Mode. BAR matching is used. The "BAR Number" field is relevant. Not used for RC.
For CFG0 TLPs, this field is interpreted as follows:
 - 0: Routing ID Match Mode. The iATU interprets the Routing ID (Bytes 8 to 11 of TLP header) as an address. This corresponds to the upper 16 bits of the address in MEM-I/O transactions. The Routing ID of the TLP must be within the base and limit of the iATU region for matching to proceed.
 - 1: Accept Mode. The iATU accepts all CFG0 transactions as address matches. The routing ID in the CFG0 TLP is ignored. This is useful as all received CFG0 TLPs should be processed regardless of the Bus number.
For MSG/MSGD TLPs, this field is interpreted as follows:
 - 0: Address Match Mode. The iATU treats the third dword and fourth dword of the inbound MSG/MSGD TLP as an address and it is matched against the Region Base and Limit Registers.
 - 1: Vendor ID Match Mode. This mode is relevant for ID-routed Vendor Defined Messages. The iATU ignores the Routing ID (Bus, Device, Function) in bits [31:16] of the third dword of the TLP header, but matches against the Vendor ID in bits [15:0] of the third dword of the TLP header. Bits [15:0] of the Region Upper Base register should be programmed with the required Vendor ID. The lower Base and Limit Register should be programmed to translate TLPs based on vendor specific information in the fourth dword of the TLP header.
 -	If SINGLE_ADDRESS_LOCATION_TRANSLATE_EN = 1 AND MSG_TYPE_MATCH_MODE = 1, then Match Mode is ignored.
Note: This register field is sticky.
                }
            }
            field REGION_EN @'h1f {
                access rw;
                hard_reset 'h0;
                doc {
                    Region Enable. This bit must be set to '1' for address translation to take place.

Note: This register field is sticky.
                }
            }
            doc {
                iATU Region Control 2 Register.iATU Region Control 2 Register.
            }
        }
        register IATU_LWR_BASE_ADDR_OFF_INBOUND_5 @'hb08 {
            bytes 4;
            field LWR_BASE_HW @'h0 {
                bits 12;
                access ro;
                hard_reset 'h0;
                doc {
                    Forms bits [n-1:0] of the start address of the address region to be translated. The start address must be aligned to a CX_ATU_MIN_REGION_SIZE kB boundary, so these bits are always 0.
A write to this location is ignored by the PCIe controller.

n is log2(CX_ATU_MIN_REGION_SIZE)
                }
            }
            field LWR_BASE_RW @'hc {
                bits 20;
                access rw;
                hard_reset 'h0;
                doc {
                    Forms bits [31:n] of the start address of the address region to be translated. 
n is log2(CX_ATU_MIN_REGION_SIZE)

Note: This register field is sticky.
                }
            }
            doc {
                iATU Lower Base Address Register. The CX_ATU_MIN_REGION_SIZE configuration parameter (Value Range: 4 kB, 8 kB, 16 kB, 32 kB, 64 kB defaults to 64 kB) specifies the minimum size of an address translation region. For example, if set to 64 kB; the lower 16 bits of the Base, Limit and Target registers are zero and all address regions are aligned on 64 kB boundaries. More precisely, the lower log2(CX_ATU_MIN_REGION_SIZE) bits are zero.iATU Lower Base Address Register. The CX_ATU_MIN_REGION_SIZE configuration parameter (Value Range: 4 kB, 8 kB, 16 kB, 32 kB, 64 kB defaults to 64 kB) specifies the minimum size of an address translation region. For example, if set to 64 kB; the lower 16 bits of the Base, Limit and Target registers are zero and all address regions are aligned on 64 kB boundaries. More precisely, the lower log2(CX_ATU_MIN_REGION_SIZE) bits are zero.
            }
        }
        register IATU_UPPER_BASE_ADDR_OFF_INBOUND_5 @'hb0c {
            bytes 4;
            field UPPER_BASE_RW @'h0 {
                bits 32;
                access rw;
                hard_reset 'h0;
                doc {
                    Forms bits [63:32] of the start (and end) address of the address region to be translated.

Note: This register field is sticky.
                }
            }
            doc {
                iATU Upper Base Address Register.iATU Upper Base Address Register.
            }
        }
        register IATU_LIMIT_ADDR_OFF_INBOUND_5 @'hb10 {
            bytes 4;
            field LIMIT_ADDR_HW @'h0 {
                bits 12;
                access ro;
                hard_reset 'h0;
                doc {
                    Forms lower bits of the end address of the address region to be translated. The end address must be aligned to a CX_ATU_MIN_REGION_SIZE kB boundary, so these bits are always all ones.
A write to this location is ignored by the PCIe controller.
                }
            }
            field LIMIT_ADDR_RW @'hc {
                bits 20;
                access rw;
                hard_reset 'h0;
                doc {
                    Forms upper bits of the end address of the address region to be translated.

Note: This register field is sticky.
                }
            }
            doc {
                iATU Limit Address Register.iATU Limit Address Register.
            }
        }
        register IATU_LWR_TARGET_ADDR_OFF_INBOUND_5 @'hb14 {
            bytes 4;
            field LWR_TARGET_HW @'h0 {
                bits 12;
                access ro;
                hard_reset 'h0;
                doc {
                    Forms the LSB's of the Lower Target part of the new address of the translated region. The start address must be aligned to a CX_ATU_MIN_REGION_SIZE kB boundary (in address match mode); and to the Bar size boundary (in BAR match mode) so that these bits are always '0'. If the BAR is smaller than the iATU region size, then the iATU target address must align to the iATU region size; otherwise it must align to the BAR size.

A write to this location is ignored by the PCIe controller.
 - Field size depends on log2(CX_ATU_MIN_REGION_SIZE) in address match mode.
 - Field size depends on log2(BAR_MASK+1) in BAR match mode.
                }
            }
            field LWR_TARGET_RW @'hc {
                bits 20;
                access rw;
                hard_reset 'h0;
                doc {
                    Forms MSB's of the Lower Target part of the new address of the translated region. These bits are always '0'.
 - Field size depends on log2(CX_ATU_MIN_REGION_SIZE) in address match mode.
 - Field size depends on log2(BAR_MASK+1) in BAR match mode.
Note: This register field is sticky.
                }
            }
            doc {
                iATU Lower Target Address Register.iATU Lower Target Address Register.
            }
        }
        register IATU_UPPER_TARGET_ADDR_OFF_INBOUND_5 @'hb18 {
            bytes 4;
            field UPPER_TARGET_RW @'h0 {
                bits 32;
                access rw;
                hard_reset 'h0;
                doc {
                    Forms bits [63:32] of the start address (Upper Target part) of the new address of the translated region. In systems with a 32-bit address space, this register is not used and therefore writing to this register has no effect.

Note: This register field is sticky.
                }
            }
            doc {
                iATU Upper Target Address Register.iATU Upper Target Address Register.
            }
        }
        register IATU_UPPR_LIMIT_ADDR_OFF_INBOUND_5 @'hb20 {
            bytes 4;
            field UPPR_LIMIT_ADDR_RW @'h0 {
                bits 4;
                access rw;
                hard_reset 'h0;
                doc {
                    Forms the LSB's of the Upper Limit part of the region "end address" to be translated. Only applies to 64-bit systems and when the INCREASE_REGION_SIZE field in IATU_REGION_CTRL_1_OFF_INBOUND_i is '1'

Note: This register field is sticky.
                }
            }
            field UPPR_LIMIT_ADDR_HW @'h4 {
                bits 28;
                access ro;
                hard_reset 'h0;
                doc {
                    Forms MSB's of the Upper Limit part of the region "end address" to be translated. Only applies to 64-bit systems and when the INCREASE_REGION_SIZE field in IATU_REGION_CTRL_1_OFF_INBOUND_i is '1'. These bits are always '0'.
                }
            }
            doc {
                iATU Upper Limit Address Register. The CX_MAX_ATU_REGION_SIZE configuration parameter (Value Range: 0->32, 8=1TB) specifies the maximum region size of an address translation region. This register is only used when the INCREASE_REGION_SIZE field in IATU_REGION_CTRL_1_OFF_INBOUND_i is '1'.iATU Upper Limit Address Register. The CX_MAX_ATU_REGION_SIZE configuration parameter (Value Range: 0->32, 8=1TB) specifies the maximum region size of an address translation region. This register is only used when the INCREASE_REGION_SIZE field in IATU_REGION_CTRL_1_OFF_INBOUND_i is '1'.
            }
        }
        register IATU_REGION_CTRL_1_OFF_OUTBOUND_6 @'hc00 {
            bytes 4;
            field TYPE @'h0 {
                bits 5;
                access rw;
                hard_reset 'h0;
                doc {
                    When the address of an outbound TLP is matched to this region, then the TYPE field of the TLP is changed to the value in this register.

Note: This register field is sticky.
                }
            }
            field TC @'h5 {
                bits 3;
                access rw;
                hard_reset 'h0;
                doc {
                    When the address of an outbound TLP is matched to this region, then the TC field of the TLP is changed to the value in this register.

Note: This register field is sticky.
                }
            }
            field TD @'h8 {
                access rw;
                hard_reset 'h0;
                doc {
                    This is a reserved field. Do not use.

Note: This register field is sticky.
                }
            }
            field ATTR @'h9 {
                bits 2;
                access rw;
                hard_reset 'h0;
                doc {
                    When the address of an outbound TLP is matched to this region, then the ATTR field of the TLP is changed to the value in this register.

Note: This register field is sticky.
                }
            }
            field INCREASE_REGION_SIZE @'hd {
                access rw;
                hard_reset 'h0;
                doc {
                    Increase the maximum ATU Region size. When set, the maximum ATU Region size is determined by CX_ATU_MAX_REGION_SIZE. When clear, the maximum ATU Region size is 4 GB (default).

Note: This register field is sticky.
                }
            }
            field CTRL_1_FUNC_NUM @'h14 {
                bits 3;
                access rw;
                hard_reset 'h0;
                doc {
                    Function Number.
 - When the address of an outbound TLP is matched to this region and the FUNC_BYPASS field in the "iATU Control 2 Register" is '0', then the function number used in generating the function part of the requester ID (RID) field of the TLP is taken from this 5-bit register. The value in this register must be 0x0 unless multifunction operation in the controller is enabled (CX_NFUNC > 1).
 - When you are using the AXI Bridge, then this field is swapped before AXI decomposition occurs so that the correct "Max_Read_Request_Size" and "Max_Payload_Size" values are used.

Note: This register field is sticky.
                }
            }
            doc {
                iATU Region Control 1 Register.iATU Region Control 1 Register.
            }
        }
        register IATU_REGION_CTRL_2_OFF_OUTBOUND_6 @'hc04 {
            bytes 4;
            field MSG_CODE @'h0 {
                bits 8;
                access rw;
                hard_reset 'h0;
                doc {
                    MSG TLPs (Message Code). When the address of an outbound TLP is matched to this region, and the translated TLP TYPE field is Msg or MsgD; then the message field of the TLP is changed to the value in this register.

Memory TLPs: (ST;Steering Tag). When the ST field of an outbound TLP is matched to this region, and the translated TLP TYPE field targets memory space; then the ST field of the TLP is changed to the value in this register. Only Valid when the CX_TPH_ENABLE configuration parameter is 1.

Note: This register field is sticky.
                }
            }
            field TAG @'h8 {
                bits 8;
                access rw;
                hard_reset 'h0;
                doc {
                    TAG.

The substituted TAG field (byte 6) in the outgoing TLP header when TAG_SUBSTITUTE_EN is set.

Note: This register field is sticky.
                }
            }
            field TAG_SUBSTITUTE_EN @'h10 {
                access rw;
                hard_reset 'h0;
                doc {
                    TAG Substitute Enable.

When enabled and region address is matched, the iATU substitutes the TAG field of the outbound TLP header with the contents of the TAG field in this register. The expected usage scenario is translation from AXI MWr to Vendor Defined Msg/MsgD.

Note (CX_TPH_ENABLE=1): TAG substitution for MWr will not occur because this field (byte 6) in the TLP header is the ST field. ST substitution can still take place using the MSG_CODE field in IATU_REGION_CTRL_2_OFF_OUTBOUND_i.

Note: This register field is sticky.
                }
            }
            field MSB2BITS_TAG @'h11 {
                bits 2;
                access rw;
                hard_reset 'h0;
                doc {
                    TAG.

Two most significant bits of the substituted TAG field in the outgoing TLP header when TAG_SUBSTITUTE_EN is set. 

Note: This register field is sticky.
                }
            }
            field FUNC_BYPASS @'h13 {
                access rw;
                hard_reset 'h0;
                doc {
                    Function Number Translation Bypass. In this mode, the function number of the translated TLP is taken from your application transmit interface and not from the CTRL_1_FUNC_NUM field of the "iATU Control 1 Register" or the VF_NUMBER field of the "iATU Control 3 Register."

Note: This register field is sticky.
                }
            }
            field SNP @'h14 {
                access rw;
                hard_reset 'h0;
                doc {
                    Serialize Non-Posted Requests. In this mode, when the AXI Bridge is populated, same AXI ID Non-Posted Read/Write Requests are transmitted on the wire if there are no other same ID Non-Posted Requests outstanding.

Note: This register field is sticky.
                }
            }
            field TLP_HEADER_FIELDS_BYPASS @'h15 {
                access rw;
                hard_reset 'h0;
                doc {
                    TLP Header Fields Translation Bypass.  In this mode header fields of the translated TLP is taken from your application transmit interface or, if AMBA is configured,  from the AMBA sideband bus (slv_awmisc_info) and not from the corresponding fields of the IATU_REGION_CTRL_1_OFF_OUTBOUND_i  or IATU_REGION_CTRL_2_OFF_OUTBOUND_i registers. The header fields are
 -	TC
 -	PH
 -	TH
 -	ST
 -	AT
 -	Attr (IDO, RO and NS).
Note: This register field is sticky. 

Note: This register field is sticky.
                }
            }
            field INHIBIT_PAYLOAD @'h16 {
                access rw;
                hard_reset 'h0;
                doc {
                    Inhibit TLP Payload Data for TLP's in Matched Region; assign iATU region to be TLP without data.
When enabled and region address is matched, the iATU marks all TLPs as having no payload data by forcing the TLP header Fmt[1] bit =0, regardless of the application inputs such as slv_wstrb.
 - 1: Fmt[1] =0 so that only TLP type without data is sent. For example, a Msg instead of MsgD will be sent.
 - 0: Fmt[1] =0/1 so that TLPs with or without data can be sent. 
Note: This register field is sticky.
                }
            }
            field HEADER_SUBSTITUTE_EN @'h17 {
                access rw;
                hard_reset 'h0;
                doc {
                    Header Substitute Enable.

When enabled and region address is matched, the iATU fully substitutes bytes 8-11 (for 3 DWORD header) or bytes 12-15 (for 4 DWORD header) of the outbound TLP header with the contents of the LWR_TARGET_RW field in IATU_LWR_TARGET_ADDR_OFF_OUTBOUND_i.
 - 1: LWR_TARGET_RW in the iATU_LWR_TARGET_ADDR_OFF_OUTBOUND_i register is used to fill bytes 8-to-11 (for 3 DWORD header) or bytes 12-to-15 (for 4 DWORD header) of the translated TLP header.
 - 0: LWR_TARGET_RW in the iATU_LWR_TARGET_ADDR_OFF_OUTBOUND_i register forms the new address of the translated region.
Note: This register field is sticky.
                }
            }
            field CFG_SHIFT_MODE @'h1c {
                access rw;
                hard_reset 'h0;
                doc {
                    CFG Shift Mode.

The iATU uses bits [27:12] of the untranslated address (on the XALI0/1/2 interface or AXI slave interface address) to form the BDF number of the outgoing CFG TLP.

This supports the Enhanced Configuration Address Mapping (ECAM) mechanism (Section 7.2.2 of the PCI Express Base 3.1 Specification, revision 1.0) by allowing all outgoing I/O and MEM TLPs (that have been translated to CFG) to be mapped from memory space into any 256 MB region of the PCIe configuration space.

Note: This register field is sticky.
                }
            }
            field INVERT_MODE @'h1d {
                access rw;
                hard_reset 'h0;
                doc {
                    Invert Mode. When set the address matching region is inverted. Therefore, an address match occurs when the untranslated address is in the region outside the defined range (Base Address to Limit Address).

Note: This register field is sticky.
                }
            }
            field REGION_EN @'h1f {
                access rw;
                hard_reset 'h0;
                doc {
                    Region Enable. This bit must be set to '1' for address translation to take place.

Note: This register field is sticky.
                }
            }
            doc {
                iATU Region Control 2 Register.iATU Region Control 2 Register.
            }
        }
        register IATU_LWR_BASE_ADDR_OFF_OUTBOUND_6 @'hc08 {
            bytes 4;
            field LWR_BASE_HW @'h0 {
                bits 12;
                access ro;
                hard_reset 'h0;
                doc {
                    Forms bits [n-1:0] of the start address of the address region to be translated. The start address must be aligned to a CX_ATU_MIN_REGION_SIZE kB boundary, so these bits are always 0.
A write to this location is ignored by the PCIe controller.

n is log2(CX_ATU_MIN_REGION_SIZE)
                }
            }
            field LWR_BASE_RW @'hc {
                bits 20;
                access rw;
                hard_reset 'h0;
                doc {
                    Forms bits [31:n] of the start address of the address region to be translated. 
n is log2(CX_ATU_MIN_REGION_SIZE)

Note: This register field is sticky.
                }
            }
            doc {
                iATU Lower Base Address Register. The CX_ATU_MIN_REGION_SIZE configuration parameter (Value Range: 4 kB, 8 kB, 16 kB, 32 kB, 64 kB defaults to 64 kB) specifies the minimum size of an address translation region. For example, if set to 64 kB; the lower 16 bits of the Base, Limit and Target registers are zero and all address regions are aligned on 64 kB boundaries. More precisely, the lower log2(CX_ATU_MIN_REGION_SIZE) bits are zero.iATU Lower Base Address Register. The CX_ATU_MIN_REGION_SIZE configuration parameter (Value Range: 4 kB, 8 kB, 16 kB, 32 kB, 64 kB defaults to 64 kB) specifies the minimum size of an address translation region. For example, if set to 64 kB; the lower 16 bits of the Base, Limit and Target registers are zero and all address regions are aligned on 64 kB boundaries. More precisely, the lower log2(CX_ATU_MIN_REGION_SIZE) bits are zero.
            }
        }
        register IATU_UPPER_BASE_ADDR_OFF_OUTBOUND_6 @'hc0c {
            bytes 4;
            field UPPER_BASE_RW @'h0 {
                bits 32;
                access rw;
                hard_reset 'h0;
                doc {
                    Forms bits [63:32] of the start (and end) address of the address region to be translated. In systems with a 32-bit address space, this register is not used and therefore writing to this register has no effect.

Note: This register field is sticky.
                }
            }
            doc {
                iATU Upper Base Address Register.iATU Upper Base Address Register.
            }
        }
        register IATU_LIMIT_ADDR_OFF_OUTBOUND_6 @'hc10 {
            bytes 4;
            field LIMIT_ADDR_HW @'h0 {
                bits 12;
                access ro;
                hard_reset 'h0;
                doc {
                    Forms lower bits of the end address of the address region to be translated. The end address must be aligned to a CX_ATU_MIN_REGION_SIZE kB boundary, so these bits are always all ones.
A write to this location is ignored by the PCIe controller.
                }
            }
            field LIMIT_ADDR_RW @'hc {
                bits 20;
                access rw;
                hard_reset 'h0;
                doc {
                    Forms upper bits of the end address of the address region to be translated.

Note: This register field is sticky.
                }
            }
            doc {
                iATU Limit Address Register.iATU Limit Address Register.
            }
        }
        register IATU_LWR_TARGET_ADDR_OFF_OUTBOUND_6 @'hc14 {
            bytes 4;
            field LWR_TARGET_RW_OUTBOUND @'h0 {
                bits 32;
                access rw;
                hard_reset 'h0;
                doc {
                    When HEADER_SUBSTITUTE_EN in IATU_REGION_CTRL_2_OFF_OUTBOUND_ is '0' (normal operation):
 - LWR_TARGET_RW[31:n] forms MSB's of the Lower Target part of the new address of the translated region;
 - LWR_TARGET_RW[n-1:0] are not used. (The start address must be aligned to a CX_ATU_MIN_REGION_SIZE kB boundary, so the lower bits of the start address of the new address of the translated region (bits n-1:0) are always '0').
 - n is log2(CX_ATU_MIN_REGION_SIZE).
When HEADER_SUBSTITUTE_EN in IATU_REGION_CTRL_2_OFF_OUTBOUND_i is '1':
 - LWR_TARGET_RW[31:0] forms bytes 8-11 (for 3 dword header) or bytes 12-15 (for 4 dword header) of the outbound TLP header. Usage scenarios include the transmission of Vendor Defined Messages where the controller determines the content of bytes 12 to 15 of the TLP header.
Note: This register field is sticky.
                }
            }
            doc {
                iATU Lower Target Address Register.iATU Lower Target Address Register.
            }
        }
        register IATU_UPPER_TARGET_ADDR_OFF_OUTBOUND_6 @'hc18 {
            bytes 4;
            field UPPER_TARGET_RW @'h0 {
                bits 32;
                access rw;
                hard_reset 'h0;
                doc {
                    Forms bits [63:32] of the start address (Upper Target part) of the new address of the translated region.

Note: This register field is sticky.
                }
            }
            doc {
                iATU Upper Target Address Register.iATU Upper Target Address Register.
            }
        }
        register IATU_UPPR_LIMIT_ADDR_OFF_OUTBOUND_6 @'hc20 {
            bytes 4;
            field UPPR_LIMIT_ADDR_RW @'h0 {
                bits 4;
                access rw;
                hard_reset 'h0;
                doc {
                    Forms the LSB's of the Upper Limit part of the region "end address" to be translated. Only applies to 64-bit systems and when the INCREASE_REGION_SIZE field in IATU_REGION_CTRL_1_OFF_OUTBOUND_i is '1'

Note: This register field is sticky.
                }
            }
            field UPPR_LIMIT_ADDR_HW @'h4 {
                bits 28;
                access ro;
                hard_reset 'h0;
                doc {
                    Forms MSB's of the Upper Limit part of the region "end address" to be translated. Only applies to 64-bit systems and when the INCREASE_REGION_SIZE field in IATU_REGION_CTRL_1_OFF_OUTBOUND_i is '1'. These bits are always '0'.
                }
            }
            doc {
                iATU Upper Limit Address Register. The CX_MAX_ATU_REGION_SIZE configuration parameter (Value Range: 0->32, 8=1TB) specifies the maximum region size of an address translation region. This register is only used when the INCREASE_REGION_SIZE field in IATU_REGION_CTRL_1_OFF_OUTBOUND_i is '1'.iATU Upper Limit Address Register. The CX_MAX_ATU_REGION_SIZE configuration parameter (Value Range: 0->32, 8=1TB) specifies the maximum region size of an address translation region. This register is only used when the INCREASE_REGION_SIZE field in IATU_REGION_CTRL_1_OFF_OUTBOUND_i is '1'.
            }
        }
        register IATU_REGION_CTRL_1_OFF_INBOUND_6 @'hd00 {
            bytes 4;
            field TYPE @'h0 {
                bits 5;
                access rw;
                hard_reset 'h0;
                doc {
                    When the TYPE field of an inbound TLP is matched to this value, then address translation proceeds (when all other enabled field-matches are successful).

Note: This register field is sticky.
                }
            }
            field TC @'h5 {
                bits 3;
                access rw;
                hard_reset 'h0;
                doc {
                    When the TC field of an inbound TLP is matched to this value, then address translation proceeds (when all other enabled field-matches are successful). This check is only performed if the "TC Match Enable" bit of the "iATU Control 2 Register" is set.

Note: This register field is sticky.
                }
            }
            field TD @'h8 {
                access rw;
                hard_reset 'h0;
                doc {
                    When the TD field of an inbound TLP is matched to this value, then address translation proceeds (when all other enabled field-matches are successful). This check is only performed if the "TD Match Enable" bit of the "iATU Control 2 Register" is set.

Note: This register field is sticky.
                }
            }
            field ATTR @'h9 {
                bits 2;
                access rw;
                hard_reset 'h0;
                doc {
                    When the ATTR field of an inbound TLP is matched to this value, then address translation proceeds (when all other enabled field-matches are successful). This check is only performed if the "ATTR Match Enable" bit of the "iATU Control 2 Register" is set.

Note: This register field is sticky.
                }
            }
            field INCREASE_REGION_SIZE @'hd {
                access rw;
                hard_reset 'h0;
                doc {
                    Increase the maximum ATU Region size. When set, the maximum ATU Region size is determined by CX_ATU_MAX_REGION_SIZE. When clear, the maximum ATU Region size is 4 GB (default).

Note: This register field is sticky.
                }
            }
            field CTRL_1_FUNC_NUM @'h14 {
                bits 3;
                access rw;
                hard_reset 'h0;
                doc {
                    Function Number.
 - MEM-I/O: When the Address and BAR matching logic in the controller indicate that a MEM-I/O transaction matches a BAR in the function corresponding to this value, then address translation proceeds. This check is only performed if the "Function Number Match Enable" bit of the "iATU Control 2 Register" is set.
 - CFG0/CFG1: When the destination function number as specified in the routing ID of the TLP header matches the function, then address translation proceeds. This check is only performed if the "Function Number Match Enable" bit of the "iATU Control 2 Register" is set.
Note: This register field is sticky.
                }
            }
            doc {
                iATU Region Control 1 Register.iATU Region Control 1 Register.
            }
        }
        register IATU_REGION_CTRL_2_OFF_INBOUND_6 @'hd04 {
            bytes 4;
            field MSG_CODE @'h0 {
                bits 8;
                access rw;
                hard_reset 'h0;
                doc {
                    MSG TLPs: (Message Code). When the TYPE field of an inbound Msg/MsgD TLP is matched to this value, then address translation proceeds (when all other enabled field-matches are successful). This check is only performed if the "Message Code Match Enable" bit of the "iATU Control 2 Register" is set.

Memory TLPs: (ST;Steering Tag). When the ST field of an inbound TLP is matched to this value, then address translation proceeds. This check is only performed if the "ST Match Enable" bit of the "iATU Control2 Register" is set. The setting is independent of the setting of the TH field. Only Valid when the CX_TPH_ENABLE configuration parameter is 1.

Note: This register field is sticky.
                }
            }
            field BAR_NUM @'h8 {
                bits 3;
                access rw;
                hard_reset 'h0;
                doc {
                    BAR Number. When the BAR number of an inbound MEM or IO TLP " that is matched by the normal internal BAR address matching mechanism " is the same as this field, address translation proceeds (when all other enabled field-matches are successful). This check is only performed if the "Match Mode" bit of the "iATU Control 2 Register" is set.
 - 000b - BAR0
 - 001b - BAR1
 - 010b - BAR2
 - 011b - BAR3
 - 100b - BAR4
 - 101b - BAR5
 - 110b - ROM
 - 111b - reserved
 - IO translation would require either 00100b or 00101b in the inbound TLP TYPE; the BAR Number set in the range 000b - 101b and that BAR configured as an IO BAR.
Note: This register field is sticky.
                }
            }
            field MSG_TYPE_MATCH_MODE @'hd {
                access rw;
                hard_reset 'h0;
                doc {
                    Message Type Match Mode.

When enabled, and if single address location translate enable is set, then inbound TLPs of type MSG/MSGd which match the type field of the iatu_region_ctrl_1_OFF_inbound register (=>TYPE[4:3]=2'b10) will be translated.
Message type match mode overrides any value of MATCH_MODE field in this register. Usage scenarios for this are translation of VDM or ATS messages when AXI bridge is configured on client interface.

Note: This register field is sticky.
                }
            }
            field TC_MATCH_EN @'he {
                access rw;
                hard_reset 'h0;
                doc {
                    TC Match Enable. Ensures that a successful TC TLP field comparison match (see TC field of the "iATU Control 1 Register") occurs for address translation to proceed.

Note: This register field is sticky.
                }
            }
            field TD_MATCH_EN @'hf {
                access rw;
                hard_reset 'h0;
                doc {
                    TD Match Enable. Ensures that a successful TD TLP field comparison match (see TD field of the "iATU Control 1 Register") occurs for address translation to proceed.

Note: This register field is sticky.
                }
            }
            field ATTR_MATCH_EN @'h10 {
                access rw;
                hard_reset 'h0;
                doc {
                    ATTR Match Enable. Ensures that a successful ATTR TLP field comparison match (see ATTR field of the "iATU Control 1 Register") occurs for address translation to proceed.

Note: This register field is sticky.
                }
            }
            field FUNC_NUM_MATCH_EN @'h13 {
                access rw;
                hard_reset 'h0;
                doc {
                    Function Number Match Enable. Ensures that a successful Function Number TLP field comparison match (see Function Number field of the "iATU Control 1 Register") occurs (in MEM-I/O and CFG0/CFG1 transactions) for address translation to proceed.

Note: This register field is sticky.
                }
            }
            field MSG_CODE_MATCH_EN @'h15 {
                access rw;
                hard_reset 'h0;
                doc {
                    Message Code Match Enable (Msg TLPS). Ensures that a successful message Code TLP field comparison match (see Message Code field of the "iATU Control 2 Register") occurs (in MSG transactions) for address translation to proceed.

ST Match Enable (Mem TLPs). Ensures that a successful ST TLP field comparison match (see ST field of the "iATU Control 2 Register") occurs (in MEM transactions) for address translation to proceed. Only Valid when the CX_TPH_ENABLE configuration parameter is 1

Note: This register field is sticky.
                }
            }
            field SINGLE_ADDR_LOC_TRANS_EN @'h17 {
                access rw;
                hard_reset 'h0;
                doc {
                    Single Address Location Translate Enable.

When enabled, Rx TLPs can be translated to a single address location as determined by the target address register of the iATU region.
The main usage scenario is translation of Messages (such as Vendor Defined or ATS Messages) to MWr TLPs when the AXI bridge is enabled.

Note: This register field is sticky.
                }
            }
            field RESPONSE_CODE @'h18 {
                bits 2;
                access rw;
                hard_reset 'h0;
                doc {
                    Response Code. Defines the type of response to give for accesses matching this region. This overrides the normal RADM filter response. Note that this feature is not available for any region where Single Address Location Translate is enabled.
 - 00 - Normal RADM filter response is used.
 - 01 - Unsupported request (UR)
 - 10 - Completer abort (CA)
 - 11 - Not used / undefined / reserved.
Note: This register field is sticky.
                }
            }
            field FUZZY_TYPE_MATCH_CODE @'h1b {
                access rw;
                hard_reset 'h0;
                doc {
                    Fuzzy Type Match Mode. When enabled, the iATU relaxes the matching of the TLP TYPE field against the expected TYPE field so that
 - CfgRd0 and CfgRd1 TLPs are seen as identical. Similarly with CfgWr0 and CfgWr1.
 - MWr, MRd and MRdLk TLPs are seen as identical
 - The Routing field of Msg/MsgD TLPs is ignored
 - FetchAdd, Swap and CAS are seen as identical.
For example, CFG0 in the TYPE field in the "iATU Control 1 Register" matches against an inbound CfgRd0, CfgRd1, CfgWr0 or CfgWr1 TLP.

Note: This register field is sticky.
                }
            }
            field CFG_SHIFT_MODE @'h1c {
                access rw;
                hard_reset 'h0;
                doc {
                    CFG Shift Mode. This is useful for CFG transactions where the PCIe configuration mechanism maps bits [27:12] of the address to the bus/device and function number. This allows a CFG configuration space to be located in any 256MB window of your application memory space using a 28-bit effective address. Shifts bits [31:16] of the untranslated address to form bits [27:12] of the translated address.

Note: This register field is sticky.
                }
            }
            field INVERT_MODE @'h1d {
                access rw;
                hard_reset 'h0;
                doc {
                    Invert Mode. When set the address matching region is inverted. Therefore, an address match occurs when the untranslated address is in the region outside the defined range (Base Address to Limit Address).

Note: This register field is sticky.
                }
            }
            field MATCH_MODE @'h1e {
                access rw;
                hard_reset 'h0;
                doc {
                    Match Mode. Determines Inbound matching mode for TLPs. The mode depends on the type of TLP that is received as follows:

 For MEM-I/O TLPs, this field is interpreted as follows:
 - 0: Address Match Mode. The iATU operates using addresses as in the outbound direction. The Region Base and Limit Registers must be setup.
 - 1:BAR Match Mode. BAR matching is used. The "BAR Number" field is relevant. Not used for RC.
For CFG0 TLPs, this field is interpreted as follows:
 - 0: Routing ID Match Mode. The iATU interprets the Routing ID (Bytes 8 to 11 of TLP header) as an address. This corresponds to the upper 16 bits of the address in MEM-I/O transactions. The Routing ID of the TLP must be within the base and limit of the iATU region for matching to proceed.
 - 1: Accept Mode. The iATU accepts all CFG0 transactions as address matches. The routing ID in the CFG0 TLP is ignored. This is useful as all received CFG0 TLPs should be processed regardless of the Bus number.
For MSG/MSGD TLPs, this field is interpreted as follows:
 - 0: Address Match Mode. The iATU treats the third dword and fourth dword of the inbound MSG/MSGD TLP as an address and it is matched against the Region Base and Limit Registers.
 - 1: Vendor ID Match Mode. This mode is relevant for ID-routed Vendor Defined Messages. The iATU ignores the Routing ID (Bus, Device, Function) in bits [31:16] of the third dword of the TLP header, but matches against the Vendor ID in bits [15:0] of the third dword of the TLP header. Bits [15:0] of the Region Upper Base register should be programmed with the required Vendor ID. The lower Base and Limit Register should be programmed to translate TLPs based on vendor specific information in the fourth dword of the TLP header.
 -	If SINGLE_ADDRESS_LOCATION_TRANSLATE_EN = 1 AND MSG_TYPE_MATCH_MODE = 1, then Match Mode is ignored.
Note: This register field is sticky.
                }
            }
            field REGION_EN @'h1f {
                access rw;
                hard_reset 'h0;
                doc {
                    Region Enable. This bit must be set to '1' for address translation to take place.

Note: This register field is sticky.
                }
            }
            doc {
                iATU Region Control 2 Register.iATU Region Control 2 Register.
            }
        }
        register IATU_LWR_BASE_ADDR_OFF_INBOUND_6 @'hd08 {
            bytes 4;
            field LWR_BASE_HW @'h0 {
                bits 12;
                access ro;
                hard_reset 'h0;
                doc {
                    Forms bits [n-1:0] of the start address of the address region to be translated. The start address must be aligned to a CX_ATU_MIN_REGION_SIZE kB boundary, so these bits are always 0.
A write to this location is ignored by the PCIe controller.

n is log2(CX_ATU_MIN_REGION_SIZE)
                }
            }
            field LWR_BASE_RW @'hc {
                bits 20;
                access rw;
                hard_reset 'h0;
                doc {
                    Forms bits [31:n] of the start address of the address region to be translated. 
n is log2(CX_ATU_MIN_REGION_SIZE)

Note: This register field is sticky.
                }
            }
            doc {
                iATU Lower Base Address Register. The CX_ATU_MIN_REGION_SIZE configuration parameter (Value Range: 4 kB, 8 kB, 16 kB, 32 kB, 64 kB defaults to 64 kB) specifies the minimum size of an address translation region. For example, if set to 64 kB; the lower 16 bits of the Base, Limit and Target registers are zero and all address regions are aligned on 64 kB boundaries. More precisely, the lower log2(CX_ATU_MIN_REGION_SIZE) bits are zero.iATU Lower Base Address Register. The CX_ATU_MIN_REGION_SIZE configuration parameter (Value Range: 4 kB, 8 kB, 16 kB, 32 kB, 64 kB defaults to 64 kB) specifies the minimum size of an address translation region. For example, if set to 64 kB; the lower 16 bits of the Base, Limit and Target registers are zero and all address regions are aligned on 64 kB boundaries. More precisely, the lower log2(CX_ATU_MIN_REGION_SIZE) bits are zero.
            }
        }
        register IATU_UPPER_BASE_ADDR_OFF_INBOUND_6 @'hd0c {
            bytes 4;
            field UPPER_BASE_RW @'h0 {
                bits 32;
                access rw;
                hard_reset 'h0;
                doc {
                    Forms bits [63:32] of the start (and end) address of the address region to be translated.

Note: This register field is sticky.
                }
            }
            doc {
                iATU Upper Base Address Register.iATU Upper Base Address Register.
            }
        }
        register IATU_LIMIT_ADDR_OFF_INBOUND_6 @'hd10 {
            bytes 4;
            field LIMIT_ADDR_HW @'h0 {
                bits 12;
                access ro;
                hard_reset 'h0;
                doc {
                    Forms lower bits of the end address of the address region to be translated. The end address must be aligned to a CX_ATU_MIN_REGION_SIZE kB boundary, so these bits are always all ones.
A write to this location is ignored by the PCIe controller.
                }
            }
            field LIMIT_ADDR_RW @'hc {
                bits 20;
                access rw;
                hard_reset 'h0;
                doc {
                    Forms upper bits of the end address of the address region to be translated.

Note: This register field is sticky.
                }
            }
            doc {
                iATU Limit Address Register.iATU Limit Address Register.
            }
        }
        register IATU_LWR_TARGET_ADDR_OFF_INBOUND_6 @'hd14 {
            bytes 4;
            field LWR_TARGET_HW @'h0 {
                bits 12;
                access ro;
                hard_reset 'h0;
                doc {
                    Forms the LSB's of the Lower Target part of the new address of the translated region. The start address must be aligned to a CX_ATU_MIN_REGION_SIZE kB boundary (in address match mode); and to the Bar size boundary (in BAR match mode) so that these bits are always '0'. If the BAR is smaller than the iATU region size, then the iATU target address must align to the iATU region size; otherwise it must align to the BAR size.

A write to this location is ignored by the PCIe controller.
 - Field size depends on log2(CX_ATU_MIN_REGION_SIZE) in address match mode.
 - Field size depends on log2(BAR_MASK+1) in BAR match mode.
                }
            }
            field LWR_TARGET_RW @'hc {
                bits 20;
                access rw;
                hard_reset 'h0;
                doc {
                    Forms MSB's of the Lower Target part of the new address of the translated region. These bits are always '0'.
 - Field size depends on log2(CX_ATU_MIN_REGION_SIZE) in address match mode.
 - Field size depends on log2(BAR_MASK+1) in BAR match mode.
Note: This register field is sticky.
                }
            }
            doc {
                iATU Lower Target Address Register.iATU Lower Target Address Register.
            }
        }
        register IATU_UPPER_TARGET_ADDR_OFF_INBOUND_6 @'hd18 {
            bytes 4;
            field UPPER_TARGET_RW @'h0 {
                bits 32;
                access rw;
                hard_reset 'h0;
                doc {
                    Forms bits [63:32] of the start address (Upper Target part) of the new address of the translated region. In systems with a 32-bit address space, this register is not used and therefore writing to this register has no effect.

Note: This register field is sticky.
                }
            }
            doc {
                iATU Upper Target Address Register.iATU Upper Target Address Register.
            }
        }
        register IATU_UPPR_LIMIT_ADDR_OFF_INBOUND_6 @'hd20 {
            bytes 4;
            field UPPR_LIMIT_ADDR_RW @'h0 {
                bits 4;
                access rw;
                hard_reset 'h0;
                doc {
                    Forms the LSB's of the Upper Limit part of the region "end address" to be translated. Only applies to 64-bit systems and when the INCREASE_REGION_SIZE field in IATU_REGION_CTRL_1_OFF_INBOUND_i is '1'

Note: This register field is sticky.
                }
            }
            field UPPR_LIMIT_ADDR_HW @'h4 {
                bits 28;
                access ro;
                hard_reset 'h0;
                doc {
                    Forms MSB's of the Upper Limit part of the region "end address" to be translated. Only applies to 64-bit systems and when the INCREASE_REGION_SIZE field in IATU_REGION_CTRL_1_OFF_INBOUND_i is '1'. These bits are always '0'.
                }
            }
            doc {
                iATU Upper Limit Address Register. The CX_MAX_ATU_REGION_SIZE configuration parameter (Value Range: 0->32, 8=1TB) specifies the maximum region size of an address translation region. This register is only used when the INCREASE_REGION_SIZE field in IATU_REGION_CTRL_1_OFF_INBOUND_i is '1'.iATU Upper Limit Address Register. The CX_MAX_ATU_REGION_SIZE configuration parameter (Value Range: 0->32, 8=1TB) specifies the maximum region size of an address translation region. This register is only used when the INCREASE_REGION_SIZE field in IATU_REGION_CTRL_1_OFF_INBOUND_i is '1'.
            }
        }
        register IATU_REGION_CTRL_1_OFF_OUTBOUND_7 @'he00 {
            bytes 4;
            field TYPE @'h0 {
                bits 5;
                access rw;
                hard_reset 'h0;
                doc {
                    When the address of an outbound TLP is matched to this region, then the TYPE field of the TLP is changed to the value in this register.

Note: This register field is sticky.
                }
            }
            field TC @'h5 {
                bits 3;
                access rw;
                hard_reset 'h0;
                doc {
                    When the address of an outbound TLP is matched to this region, then the TC field of the TLP is changed to the value in this register.

Note: This register field is sticky.
                }
            }
            field TD @'h8 {
                access rw;
                hard_reset 'h0;
                doc {
                    This is a reserved field. Do not use.

Note: This register field is sticky.
                }
            }
            field ATTR @'h9 {
                bits 2;
                access rw;
                hard_reset 'h0;
                doc {
                    When the address of an outbound TLP is matched to this region, then the ATTR field of the TLP is changed to the value in this register.

Note: This register field is sticky.
                }
            }
            field INCREASE_REGION_SIZE @'hd {
                access rw;
                hard_reset 'h0;
                doc {
                    Increase the maximum ATU Region size. When set, the maximum ATU Region size is determined by CX_ATU_MAX_REGION_SIZE. When clear, the maximum ATU Region size is 4 GB (default).

Note: This register field is sticky.
                }
            }
            field CTRL_1_FUNC_NUM @'h14 {
                bits 3;
                access rw;
                hard_reset 'h0;
                doc {
                    Function Number.
 - When the address of an outbound TLP is matched to this region and the FUNC_BYPASS field in the "iATU Control 2 Register" is '0', then the function number used in generating the function part of the requester ID (RID) field of the TLP is taken from this 5-bit register. The value in this register must be 0x0 unless multifunction operation in the controller is enabled (CX_NFUNC > 1).
 - When you are using the AXI Bridge, then this field is swapped before AXI decomposition occurs so that the correct "Max_Read_Request_Size" and "Max_Payload_Size" values are used.

Note: This register field is sticky.
                }
            }
            doc {
                iATU Region Control 1 Register.iATU Region Control 1 Register.
            }
        }
        register IATU_REGION_CTRL_2_OFF_OUTBOUND_7 @'he04 {
            bytes 4;
            field MSG_CODE @'h0 {
                bits 8;
                access rw;
                hard_reset 'h0;
                doc {
                    MSG TLPs (Message Code). When the address of an outbound TLP is matched to this region, and the translated TLP TYPE field is Msg or MsgD; then the message field of the TLP is changed to the value in this register.

Memory TLPs: (ST;Steering Tag). When the ST field of an outbound TLP is matched to this region, and the translated TLP TYPE field targets memory space; then the ST field of the TLP is changed to the value in this register. Only Valid when the CX_TPH_ENABLE configuration parameter is 1.

Note: This register field is sticky.
                }
            }
            field TAG @'h8 {
                bits 8;
                access rw;
                hard_reset 'h0;
                doc {
                    TAG.

The substituted TAG field (byte 6) in the outgoing TLP header when TAG_SUBSTITUTE_EN is set.

Note: This register field is sticky.
                }
            }
            field TAG_SUBSTITUTE_EN @'h10 {
                access rw;
                hard_reset 'h0;
                doc {
                    TAG Substitute Enable.

When enabled and region address is matched, the iATU substitutes the TAG field of the outbound TLP header with the contents of the TAG field in this register. The expected usage scenario is translation from AXI MWr to Vendor Defined Msg/MsgD.

Note (CX_TPH_ENABLE=1): TAG substitution for MWr will not occur because this field (byte 6) in the TLP header is the ST field. ST substitution can still take place using the MSG_CODE field in IATU_REGION_CTRL_2_OFF_OUTBOUND_i.

Note: This register field is sticky.
                }
            }
            field MSB2BITS_TAG @'h11 {
                bits 2;
                access rw;
                hard_reset 'h0;
                doc {
                    TAG.

Two most significant bits of the substituted TAG field in the outgoing TLP header when TAG_SUBSTITUTE_EN is set. 

Note: This register field is sticky.
                }
            }
            field FUNC_BYPASS @'h13 {
                access rw;
                hard_reset 'h0;
                doc {
                    Function Number Translation Bypass. In this mode, the function number of the translated TLP is taken from your application transmit interface and not from the CTRL_1_FUNC_NUM field of the "iATU Control 1 Register" or the VF_NUMBER field of the "iATU Control 3 Register."

Note: This register field is sticky.
                }
            }
            field SNP @'h14 {
                access rw;
                hard_reset 'h0;
                doc {
                    Serialize Non-Posted Requests. In this mode, when the AXI Bridge is populated, same AXI ID Non-Posted Read/Write Requests are transmitted on the wire if there are no other same ID Non-Posted Requests outstanding.

Note: This register field is sticky.
                }
            }
            field TLP_HEADER_FIELDS_BYPASS @'h15 {
                access rw;
                hard_reset 'h0;
                doc {
                    TLP Header Fields Translation Bypass.  In this mode header fields of the translated TLP is taken from your application transmit interface or, if AMBA is configured,  from the AMBA sideband bus (slv_awmisc_info) and not from the corresponding fields of the IATU_REGION_CTRL_1_OFF_OUTBOUND_i  or IATU_REGION_CTRL_2_OFF_OUTBOUND_i registers. The header fields are
 -	TC
 -	PH
 -	TH
 -	ST
 -	AT
 -	Attr (IDO, RO and NS).
Note: This register field is sticky. 

Note: This register field is sticky.
                }
            }
            field INHIBIT_PAYLOAD @'h16 {
                access rw;
                hard_reset 'h0;
                doc {
                    Inhibit TLP Payload Data for TLP's in Matched Region; assign iATU region to be TLP without data.
When enabled and region address is matched, the iATU marks all TLPs as having no payload data by forcing the TLP header Fmt[1] bit =0, regardless of the application inputs such as slv_wstrb.
 - 1: Fmt[1] =0 so that only TLP type without data is sent. For example, a Msg instead of MsgD will be sent.
 - 0: Fmt[1] =0/1 so that TLPs with or without data can be sent. 
Note: This register field is sticky.
                }
            }
            field HEADER_SUBSTITUTE_EN @'h17 {
                access rw;
                hard_reset 'h0;
                doc {
                    Header Substitute Enable.

When enabled and region address is matched, the iATU fully substitutes bytes 8-11 (for 3 DWORD header) or bytes 12-15 (for 4 DWORD header) of the outbound TLP header with the contents of the LWR_TARGET_RW field in IATU_LWR_TARGET_ADDR_OFF_OUTBOUND_i.
 - 1: LWR_TARGET_RW in the iATU_LWR_TARGET_ADDR_OFF_OUTBOUND_i register is used to fill bytes 8-to-11 (for 3 DWORD header) or bytes 12-to-15 (for 4 DWORD header) of the translated TLP header.
 - 0: LWR_TARGET_RW in the iATU_LWR_TARGET_ADDR_OFF_OUTBOUND_i register forms the new address of the translated region.
Note: This register field is sticky.
                }
            }
            field CFG_SHIFT_MODE @'h1c {
                access rw;
                hard_reset 'h0;
                doc {
                    CFG Shift Mode.

The iATU uses bits [27:12] of the untranslated address (on the XALI0/1/2 interface or AXI slave interface address) to form the BDF number of the outgoing CFG TLP.

This supports the Enhanced Configuration Address Mapping (ECAM) mechanism (Section 7.2.2 of the PCI Express Base 3.1 Specification, revision 1.0) by allowing all outgoing I/O and MEM TLPs (that have been translated to CFG) to be mapped from memory space into any 256 MB region of the PCIe configuration space.

Note: This register field is sticky.
                }
            }
            field INVERT_MODE @'h1d {
                access rw;
                hard_reset 'h0;
                doc {
                    Invert Mode. When set the address matching region is inverted. Therefore, an address match occurs when the untranslated address is in the region outside the defined range (Base Address to Limit Address).

Note: This register field is sticky.
                }
            }
            field REGION_EN @'h1f {
                access rw;
                hard_reset 'h0;
                doc {
                    Region Enable. This bit must be set to '1' for address translation to take place.

Note: This register field is sticky.
                }
            }
            doc {
                iATU Region Control 2 Register.iATU Region Control 2 Register.
            }
        }
        register IATU_LWR_BASE_ADDR_OFF_OUTBOUND_7 @'he08 {
            bytes 4;
            field LWR_BASE_HW @'h0 {
                bits 12;
                access ro;
                hard_reset 'h0;
                doc {
                    Forms bits [n-1:0] of the start address of the address region to be translated. The start address must be aligned to a CX_ATU_MIN_REGION_SIZE kB boundary, so these bits are always 0.
A write to this location is ignored by the PCIe controller.

n is log2(CX_ATU_MIN_REGION_SIZE)
                }
            }
            field LWR_BASE_RW @'hc {
                bits 20;
                access rw;
                hard_reset 'h0;
                doc {
                    Forms bits [31:n] of the start address of the address region to be translated. 
n is log2(CX_ATU_MIN_REGION_SIZE)

Note: This register field is sticky.
                }
            }
            doc {
                iATU Lower Base Address Register. The CX_ATU_MIN_REGION_SIZE configuration parameter (Value Range: 4 kB, 8 kB, 16 kB, 32 kB, 64 kB defaults to 64 kB) specifies the minimum size of an address translation region. For example, if set to 64 kB; the lower 16 bits of the Base, Limit and Target registers are zero and all address regions are aligned on 64 kB boundaries. More precisely, the lower log2(CX_ATU_MIN_REGION_SIZE) bits are zero.iATU Lower Base Address Register. The CX_ATU_MIN_REGION_SIZE configuration parameter (Value Range: 4 kB, 8 kB, 16 kB, 32 kB, 64 kB defaults to 64 kB) specifies the minimum size of an address translation region. For example, if set to 64 kB; the lower 16 bits of the Base, Limit and Target registers are zero and all address regions are aligned on 64 kB boundaries. More precisely, the lower log2(CX_ATU_MIN_REGION_SIZE) bits are zero.
            }
        }
        register IATU_UPPER_BASE_ADDR_OFF_OUTBOUND_7 @'he0c {
            bytes 4;
            field UPPER_BASE_RW @'h0 {
                bits 32;
                access rw;
                hard_reset 'h0;
                doc {
                    Forms bits [63:32] of the start (and end) address of the address region to be translated. In systems with a 32-bit address space, this register is not used and therefore writing to this register has no effect.

Note: This register field is sticky.
                }
            }
            doc {
                iATU Upper Base Address Register.iATU Upper Base Address Register.
            }
        }
        register IATU_LIMIT_ADDR_OFF_OUTBOUND_7 @'he10 {
            bytes 4;
            field LIMIT_ADDR_HW @'h0 {
                bits 12;
                access ro;
                hard_reset 'h0;
                doc {
                    Forms lower bits of the end address of the address region to be translated. The end address must be aligned to a CX_ATU_MIN_REGION_SIZE kB boundary, so these bits are always all ones.
A write to this location is ignored by the PCIe controller.
                }
            }
            field LIMIT_ADDR_RW @'hc {
                bits 20;
                access rw;
                hard_reset 'h0;
                doc {
                    Forms upper bits of the end address of the address region to be translated.

Note: This register field is sticky.
                }
            }
            doc {
                iATU Limit Address Register.iATU Limit Address Register.
            }
        }
        register IATU_LWR_TARGET_ADDR_OFF_OUTBOUND_7 @'he14 {
            bytes 4;
            field LWR_TARGET_RW_OUTBOUND @'h0 {
                bits 32;
                access rw;
                hard_reset 'h0;
                doc {
                    When HEADER_SUBSTITUTE_EN in IATU_REGION_CTRL_2_OFF_OUTBOUND_ is '0' (normal operation):
 - LWR_TARGET_RW[31:n] forms MSB's of the Lower Target part of the new address of the translated region;
 - LWR_TARGET_RW[n-1:0] are not used. (The start address must be aligned to a CX_ATU_MIN_REGION_SIZE kB boundary, so the lower bits of the start address of the new address of the translated region (bits n-1:0) are always '0').
 - n is log2(CX_ATU_MIN_REGION_SIZE).
When HEADER_SUBSTITUTE_EN in IATU_REGION_CTRL_2_OFF_OUTBOUND_i is '1':
 - LWR_TARGET_RW[31:0] forms bytes 8-11 (for 3 dword header) or bytes 12-15 (for 4 dword header) of the outbound TLP header. Usage scenarios include the transmission of Vendor Defined Messages where the controller determines the content of bytes 12 to 15 of the TLP header.
Note: This register field is sticky.
                }
            }
            doc {
                iATU Lower Target Address Register.iATU Lower Target Address Register.
            }
        }
        register IATU_UPPER_TARGET_ADDR_OFF_OUTBOUND_7 @'he18 {
            bytes 4;
            field UPPER_TARGET_RW @'h0 {
                bits 32;
                access rw;
                hard_reset 'h0;
                doc {
                    Forms bits [63:32] of the start address (Upper Target part) of the new address of the translated region.

Note: This register field is sticky.
                }
            }
            doc {
                iATU Upper Target Address Register.iATU Upper Target Address Register.
            }
        }
        register IATU_UPPR_LIMIT_ADDR_OFF_OUTBOUND_7 @'he20 {
            bytes 4;
            field UPPR_LIMIT_ADDR_RW @'h0 {
                bits 4;
                access rw;
                hard_reset 'h0;
                doc {
                    Forms the LSB's of the Upper Limit part of the region "end address" to be translated. Only applies to 64-bit systems and when the INCREASE_REGION_SIZE field in IATU_REGION_CTRL_1_OFF_OUTBOUND_i is '1'

Note: This register field is sticky.
                }
            }
            field UPPR_LIMIT_ADDR_HW @'h4 {
                bits 28;
                access ro;
                hard_reset 'h0;
                doc {
                    Forms MSB's of the Upper Limit part of the region "end address" to be translated. Only applies to 64-bit systems and when the INCREASE_REGION_SIZE field in IATU_REGION_CTRL_1_OFF_OUTBOUND_i is '1'. These bits are always '0'.
                }
            }
            doc {
                iATU Upper Limit Address Register. The CX_MAX_ATU_REGION_SIZE configuration parameter (Value Range: 0->32, 8=1TB) specifies the maximum region size of an address translation region. This register is only used when the INCREASE_REGION_SIZE field in IATU_REGION_CTRL_1_OFF_OUTBOUND_i is '1'.iATU Upper Limit Address Register. The CX_MAX_ATU_REGION_SIZE configuration parameter (Value Range: 0->32, 8=1TB) specifies the maximum region size of an address translation region. This register is only used when the INCREASE_REGION_SIZE field in IATU_REGION_CTRL_1_OFF_OUTBOUND_i is '1'.
            }
        }
        register IATU_REGION_CTRL_1_OFF_INBOUND_7 @'hf00 {
            bytes 4;
            field TYPE @'h0 {
                bits 5;
                access rw;
                hard_reset 'h0;
                doc {
                    When the TYPE field of an inbound TLP is matched to this value, then address translation proceeds (when all other enabled field-matches are successful).

Note: This register field is sticky.
                }
            }
            field TC @'h5 {
                bits 3;
                access rw;
                hard_reset 'h0;
                doc {
                    When the TC field of an inbound TLP is matched to this value, then address translation proceeds (when all other enabled field-matches are successful). This check is only performed if the "TC Match Enable" bit of the "iATU Control 2 Register" is set.

Note: This register field is sticky.
                }
            }
            field TD @'h8 {
                access rw;
                hard_reset 'h0;
                doc {
                    When the TD field of an inbound TLP is matched to this value, then address translation proceeds (when all other enabled field-matches are successful). This check is only performed if the "TD Match Enable" bit of the "iATU Control 2 Register" is set.

Note: This register field is sticky.
                }
            }
            field ATTR @'h9 {
                bits 2;
                access rw;
                hard_reset 'h0;
                doc {
                    When the ATTR field of an inbound TLP is matched to this value, then address translation proceeds (when all other enabled field-matches are successful). This check is only performed if the "ATTR Match Enable" bit of the "iATU Control 2 Register" is set.

Note: This register field is sticky.
                }
            }
            field INCREASE_REGION_SIZE @'hd {
                access rw;
                hard_reset 'h0;
                doc {
                    Increase the maximum ATU Region size. When set, the maximum ATU Region size is determined by CX_ATU_MAX_REGION_SIZE. When clear, the maximum ATU Region size is 4 GB (default).

Note: This register field is sticky.
                }
            }
            field CTRL_1_FUNC_NUM @'h14 {
                bits 3;
                access rw;
                hard_reset 'h0;
                doc {
                    Function Number.
 - MEM-I/O: When the Address and BAR matching logic in the controller indicate that a MEM-I/O transaction matches a BAR in the function corresponding to this value, then address translation proceeds. This check is only performed if the "Function Number Match Enable" bit of the "iATU Control 2 Register" is set.
 - CFG0/CFG1: When the destination function number as specified in the routing ID of the TLP header matches the function, then address translation proceeds. This check is only performed if the "Function Number Match Enable" bit of the "iATU Control 2 Register" is set.
Note: This register field is sticky.
                }
            }
            doc {
                iATU Region Control 1 Register.iATU Region Control 1 Register.
            }
        }
        register IATU_REGION_CTRL_2_OFF_INBOUND_7 @'hf04 {
            bytes 4;
            field MSG_CODE @'h0 {
                bits 8;
                access rw;
                hard_reset 'h0;
                doc {
                    MSG TLPs: (Message Code). When the TYPE field of an inbound Msg/MsgD TLP is matched to this value, then address translation proceeds (when all other enabled field-matches are successful). This check is only performed if the "Message Code Match Enable" bit of the "iATU Control 2 Register" is set.

Memory TLPs: (ST;Steering Tag). When the ST field of an inbound TLP is matched to this value, then address translation proceeds. This check is only performed if the "ST Match Enable" bit of the "iATU Control2 Register" is set. The setting is independent of the setting of the TH field. Only Valid when the CX_TPH_ENABLE configuration parameter is 1.

Note: This register field is sticky.
                }
            }
            field BAR_NUM @'h8 {
                bits 3;
                access rw;
                hard_reset 'h0;
                doc {
                    BAR Number. When the BAR number of an inbound MEM or IO TLP " that is matched by the normal internal BAR address matching mechanism " is the same as this field, address translation proceeds (when all other enabled field-matches are successful). This check is only performed if the "Match Mode" bit of the "iATU Control 2 Register" is set.
 - 000b - BAR0
 - 001b - BAR1
 - 010b - BAR2
 - 011b - BAR3
 - 100b - BAR4
 - 101b - BAR5
 - 110b - ROM
 - 111b - reserved
 - IO translation would require either 00100b or 00101b in the inbound TLP TYPE; the BAR Number set in the range 000b - 101b and that BAR configured as an IO BAR.
Note: This register field is sticky.
                }
            }
            field MSG_TYPE_MATCH_MODE @'hd {
                access rw;
                hard_reset 'h0;
                doc {
                    Message Type Match Mode.

When enabled, and if single address location translate enable is set, then inbound TLPs of type MSG/MSGd which match the type field of the iatu_region_ctrl_1_OFF_inbound register (=>TYPE[4:3]=2'b10) will be translated.
Message type match mode overrides any value of MATCH_MODE field in this register. Usage scenarios for this are translation of VDM or ATS messages when AXI bridge is configured on client interface.

Note: This register field is sticky.
                }
            }
            field TC_MATCH_EN @'he {
                access rw;
                hard_reset 'h0;
                doc {
                    TC Match Enable. Ensures that a successful TC TLP field comparison match (see TC field of the "iATU Control 1 Register") occurs for address translation to proceed.

Note: This register field is sticky.
                }
            }
            field TD_MATCH_EN @'hf {
                access rw;
                hard_reset 'h0;
                doc {
                    TD Match Enable. Ensures that a successful TD TLP field comparison match (see TD field of the "iATU Control 1 Register") occurs for address translation to proceed.

Note: This register field is sticky.
                }
            }
            field ATTR_MATCH_EN @'h10 {
                access rw;
                hard_reset 'h0;
                doc {
                    ATTR Match Enable. Ensures that a successful ATTR TLP field comparison match (see ATTR field of the "iATU Control 1 Register") occurs for address translation to proceed.

Note: This register field is sticky.
                }
            }
            field FUNC_NUM_MATCH_EN @'h13 {
                access rw;
                hard_reset 'h0;
                doc {
                    Function Number Match Enable. Ensures that a successful Function Number TLP field comparison match (see Function Number field of the "iATU Control 1 Register") occurs (in MEM-I/O and CFG0/CFG1 transactions) for address translation to proceed.

Note: This register field is sticky.
                }
            }
            field MSG_CODE_MATCH_EN @'h15 {
                access rw;
                hard_reset 'h0;
                doc {
                    Message Code Match Enable (Msg TLPS). Ensures that a successful message Code TLP field comparison match (see Message Code field of the "iATU Control 2 Register") occurs (in MSG transactions) for address translation to proceed.

ST Match Enable (Mem TLPs). Ensures that a successful ST TLP field comparison match (see ST field of the "iATU Control 2 Register") occurs (in MEM transactions) for address translation to proceed. Only Valid when the CX_TPH_ENABLE configuration parameter is 1

Note: This register field is sticky.
                }
            }
            field SINGLE_ADDR_LOC_TRANS_EN @'h17 {
                access rw;
                hard_reset 'h0;
                doc {
                    Single Address Location Translate Enable.

When enabled, Rx TLPs can be translated to a single address location as determined by the target address register of the iATU region.
The main usage scenario is translation of Messages (such as Vendor Defined or ATS Messages) to MWr TLPs when the AXI bridge is enabled.

Note: This register field is sticky.
                }
            }
            field RESPONSE_CODE @'h18 {
                bits 2;
                access rw;
                hard_reset 'h0;
                doc {
                    Response Code. Defines the type of response to give for accesses matching this region. This overrides the normal RADM filter response. Note that this feature is not available for any region where Single Address Location Translate is enabled.
 - 00 - Normal RADM filter response is used.
 - 01 - Unsupported request (UR)
 - 10 - Completer abort (CA)
 - 11 - Not used / undefined / reserved.
Note: This register field is sticky.
                }
            }
            field FUZZY_TYPE_MATCH_CODE @'h1b {
                access rw;
                hard_reset 'h0;
                doc {
                    Fuzzy Type Match Mode. When enabled, the iATU relaxes the matching of the TLP TYPE field against the expected TYPE field so that
 - CfgRd0 and CfgRd1 TLPs are seen as identical. Similarly with CfgWr0 and CfgWr1.
 - MWr, MRd and MRdLk TLPs are seen as identical
 - The Routing field of Msg/MsgD TLPs is ignored
 - FetchAdd, Swap and CAS are seen as identical.
For example, CFG0 in the TYPE field in the "iATU Control 1 Register" matches against an inbound CfgRd0, CfgRd1, CfgWr0 or CfgWr1 TLP.

Note: This register field is sticky.
                }
            }
            field CFG_SHIFT_MODE @'h1c {
                access rw;
                hard_reset 'h0;
                doc {
                    CFG Shift Mode. This is useful for CFG transactions where the PCIe configuration mechanism maps bits [27:12] of the address to the bus/device and function number. This allows a CFG configuration space to be located in any 256MB window of your application memory space using a 28-bit effective address. Shifts bits [31:16] of the untranslated address to form bits [27:12] of the translated address.

Note: This register field is sticky.
                }
            }
            field INVERT_MODE @'h1d {
                access rw;
                hard_reset 'h0;
                doc {
                    Invert Mode. When set the address matching region is inverted. Therefore, an address match occurs when the untranslated address is in the region outside the defined range (Base Address to Limit Address).

Note: This register field is sticky.
                }
            }
            field MATCH_MODE @'h1e {
                access rw;
                hard_reset 'h0;
                doc {
                    Match Mode. Determines Inbound matching mode for TLPs. The mode depends on the type of TLP that is received as follows:

 For MEM-I/O TLPs, this field is interpreted as follows:
 - 0: Address Match Mode. The iATU operates using addresses as in the outbound direction. The Region Base and Limit Registers must be setup.
 - 1:BAR Match Mode. BAR matching is used. The "BAR Number" field is relevant. Not used for RC.
For CFG0 TLPs, this field is interpreted as follows:
 - 0: Routing ID Match Mode. The iATU interprets the Routing ID (Bytes 8 to 11 of TLP header) as an address. This corresponds to the upper 16 bits of the address in MEM-I/O transactions. The Routing ID of the TLP must be within the base and limit of the iATU region for matching to proceed.
 - 1: Accept Mode. The iATU accepts all CFG0 transactions as address matches. The routing ID in the CFG0 TLP is ignored. This is useful as all received CFG0 TLPs should be processed regardless of the Bus number.
For MSG/MSGD TLPs, this field is interpreted as follows:
 - 0: Address Match Mode. The iATU treats the third dword and fourth dword of the inbound MSG/MSGD TLP as an address and it is matched against the Region Base and Limit Registers.
 - 1: Vendor ID Match Mode. This mode is relevant for ID-routed Vendor Defined Messages. The iATU ignores the Routing ID (Bus, Device, Function) in bits [31:16] of the third dword of the TLP header, but matches against the Vendor ID in bits [15:0] of the third dword of the TLP header. Bits [15:0] of the Region Upper Base register should be programmed with the required Vendor ID. The lower Base and Limit Register should be programmed to translate TLPs based on vendor specific information in the fourth dword of the TLP header.
 -	If SINGLE_ADDRESS_LOCATION_TRANSLATE_EN = 1 AND MSG_TYPE_MATCH_MODE = 1, then Match Mode is ignored.
Note: This register field is sticky.
                }
            }
            field REGION_EN @'h1f {
                access rw;
                hard_reset 'h0;
                doc {
                    Region Enable. This bit must be set to '1' for address translation to take place.

Note: This register field is sticky.
                }
            }
            doc {
                iATU Region Control 2 Register.iATU Region Control 2 Register.
            }
        }
        register IATU_LWR_BASE_ADDR_OFF_INBOUND_7 @'hf08 {
            bytes 4;
            field LWR_BASE_HW @'h0 {
                bits 12;
                access ro;
                hard_reset 'h0;
                doc {
                    Forms bits [n-1:0] of the start address of the address region to be translated. The start address must be aligned to a CX_ATU_MIN_REGION_SIZE kB boundary, so these bits are always 0.
A write to this location is ignored by the PCIe controller.

n is log2(CX_ATU_MIN_REGION_SIZE)
                }
            }
            field LWR_BASE_RW @'hc {
                bits 20;
                access rw;
                hard_reset 'h0;
                doc {
                    Forms bits [31:n] of the start address of the address region to be translated. 
n is log2(CX_ATU_MIN_REGION_SIZE)

Note: This register field is sticky.
                }
            }
            doc {
                iATU Lower Base Address Register. The CX_ATU_MIN_REGION_SIZE configuration parameter (Value Range: 4 kB, 8 kB, 16 kB, 32 kB, 64 kB defaults to 64 kB) specifies the minimum size of an address translation region. For example, if set to 64 kB; the lower 16 bits of the Base, Limit and Target registers are zero and all address regions are aligned on 64 kB boundaries. More precisely, the lower log2(CX_ATU_MIN_REGION_SIZE) bits are zero.iATU Lower Base Address Register. The CX_ATU_MIN_REGION_SIZE configuration parameter (Value Range: 4 kB, 8 kB, 16 kB, 32 kB, 64 kB defaults to 64 kB) specifies the minimum size of an address translation region. For example, if set to 64 kB; the lower 16 bits of the Base, Limit and Target registers are zero and all address regions are aligned on 64 kB boundaries. More precisely, the lower log2(CX_ATU_MIN_REGION_SIZE) bits are zero.
            }
        }
        register IATU_UPPER_BASE_ADDR_OFF_INBOUND_7 @'hf0c {
            bytes 4;
            field UPPER_BASE_RW @'h0 {
                bits 32;
                access rw;
                hard_reset 'h0;
                doc {
                    Forms bits [63:32] of the start (and end) address of the address region to be translated.

Note: This register field is sticky.
                }
            }
            doc {
                iATU Upper Base Address Register.iATU Upper Base Address Register.
            }
        }
        register IATU_LIMIT_ADDR_OFF_INBOUND_7 @'hf10 {
            bytes 4;
            field LIMIT_ADDR_HW @'h0 {
                bits 12;
                access ro;
                hard_reset 'h0;
                doc {
                    Forms lower bits of the end address of the address region to be translated. The end address must be aligned to a CX_ATU_MIN_REGION_SIZE kB boundary, so these bits are always all ones.
A write to this location is ignored by the PCIe controller.
                }
            }
            field LIMIT_ADDR_RW @'hc {
                bits 20;
                access rw;
                hard_reset 'h0;
                doc {
                    Forms upper bits of the end address of the address region to be translated.

Note: This register field is sticky.
                }
            }
            doc {
                iATU Limit Address Register.iATU Limit Address Register.
            }
        }
        register IATU_LWR_TARGET_ADDR_OFF_INBOUND_7 @'hf14 {
            bytes 4;
            field LWR_TARGET_HW @'h0 {
                bits 12;
                access ro;
                hard_reset 'h0;
                doc {
                    Forms the LSB's of the Lower Target part of the new address of the translated region. The start address must be aligned to a CX_ATU_MIN_REGION_SIZE kB boundary (in address match mode); and to the Bar size boundary (in BAR match mode) so that these bits are always '0'. If the BAR is smaller than the iATU region size, then the iATU target address must align to the iATU region size; otherwise it must align to the BAR size.

A write to this location is ignored by the PCIe controller.
 - Field size depends on log2(CX_ATU_MIN_REGION_SIZE) in address match mode.
 - Field size depends on log2(BAR_MASK+1) in BAR match mode.
                }
            }
            field LWR_TARGET_RW @'hc {
                bits 20;
                access rw;
                hard_reset 'h0;
                doc {
                    Forms MSB's of the Lower Target part of the new address of the translated region. These bits are always '0'.
 - Field size depends on log2(CX_ATU_MIN_REGION_SIZE) in address match mode.
 - Field size depends on log2(BAR_MASK+1) in BAR match mode.
Note: This register field is sticky.
                }
            }
            doc {
                iATU Lower Target Address Register.iATU Lower Target Address Register.
            }
        }
        register IATU_UPPER_TARGET_ADDR_OFF_INBOUND_7 @'hf18 {
            bytes 4;
            field UPPER_TARGET_RW @'h0 {
                bits 32;
                access rw;
                hard_reset 'h0;
                doc {
                    Forms bits [63:32] of the start address (Upper Target part) of the new address of the translated region. In systems with a 32-bit address space, this register is not used and therefore writing to this register has no effect.

Note: This register field is sticky.
                }
            }
            doc {
                iATU Upper Target Address Register.iATU Upper Target Address Register.
            }
        }
        register IATU_UPPR_LIMIT_ADDR_OFF_INBOUND_7 @'hf20 {
            bytes 4;
            field UPPR_LIMIT_ADDR_RW @'h0 {
                bits 4;
                access rw;
                hard_reset 'h0;
                doc {
                    Forms the LSB's of the Upper Limit part of the region "end address" to be translated. Only applies to 64-bit systems and when the INCREASE_REGION_SIZE field in IATU_REGION_CTRL_1_OFF_INBOUND_i is '1'

Note: This register field is sticky.
                }
            }
            field UPPR_LIMIT_ADDR_HW @'h4 {
                bits 28;
                access ro;
                hard_reset 'h0;
                doc {
                    Forms MSB's of the Upper Limit part of the region "end address" to be translated. Only applies to 64-bit systems and when the INCREASE_REGION_SIZE field in IATU_REGION_CTRL_1_OFF_INBOUND_i is '1'. These bits are always '0'.
                }
            }
            doc {
                iATU Upper Limit Address Register. The CX_MAX_ATU_REGION_SIZE configuration parameter (Value Range: 0->32, 8=1TB) specifies the maximum region size of an address translation region. This register is only used when the INCREASE_REGION_SIZE field in IATU_REGION_CTRL_1_OFF_INBOUND_i is '1'.iATU Upper Limit Address Register. The CX_MAX_ATU_REGION_SIZE configuration parameter (Value Range: 0->32, 8=1TB) specifies the maximum region size of an address translation region. This register is only used when the INCREASE_REGION_SIZE field in IATU_REGION_CTRL_1_OFF_INBOUND_i is '1'.
            }
        }
        register IATU_REGION_CTRL_1_OFF_OUTBOUND_8 @'h1000 {
            bytes 4;
            field TYPE @'h0 {
                bits 5;
                access rw;
                hard_reset 'h0;
                doc {
                    When the address of an outbound TLP is matched to this region, then the TYPE field of the TLP is changed to the value in this register.

Note: This register field is sticky.
                }
            }
            field TC @'h5 {
                bits 3;
                access rw;
                hard_reset 'h0;
                doc {
                    When the address of an outbound TLP is matched to this region, then the TC field of the TLP is changed to the value in this register.

Note: This register field is sticky.
                }
            }
            field TD @'h8 {
                access rw;
                hard_reset 'h0;
                doc {
                    This is a reserved field. Do not use.

Note: This register field is sticky.
                }
            }
            field ATTR @'h9 {
                bits 2;
                access rw;
                hard_reset 'h0;
                doc {
                    When the address of an outbound TLP is matched to this region, then the ATTR field of the TLP is changed to the value in this register.

Note: This register field is sticky.
                }
            }
            field INCREASE_REGION_SIZE @'hd {
                access rw;
                hard_reset 'h0;
                doc {
                    Increase the maximum ATU Region size. When set, the maximum ATU Region size is determined by CX_ATU_MAX_REGION_SIZE. When clear, the maximum ATU Region size is 4 GB (default).

Note: This register field is sticky.
                }
            }
            field CTRL_1_FUNC_NUM @'h14 {
                bits 3;
                access rw;
                hard_reset 'h0;
                doc {
                    Function Number.
 - When the address of an outbound TLP is matched to this region and the FUNC_BYPASS field in the "iATU Control 2 Register" is '0', then the function number used in generating the function part of the requester ID (RID) field of the TLP is taken from this 5-bit register. The value in this register must be 0x0 unless multifunction operation in the controller is enabled (CX_NFUNC > 1).
 - When you are using the AXI Bridge, then this field is swapped before AXI decomposition occurs so that the correct "Max_Read_Request_Size" and "Max_Payload_Size" values are used.

Note: This register field is sticky.
                }
            }
            doc {
                iATU Region Control 1 Register.iATU Region Control 1 Register.
            }
        }
        register IATU_REGION_CTRL_2_OFF_OUTBOUND_8 @'h1004 {
            bytes 4;
            field MSG_CODE @'h0 {
                bits 8;
                access rw;
                hard_reset 'h0;
                doc {
                    MSG TLPs (Message Code). When the address of an outbound TLP is matched to this region, and the translated TLP TYPE field is Msg or MsgD; then the message field of the TLP is changed to the value in this register.

Memory TLPs: (ST;Steering Tag). When the ST field of an outbound TLP is matched to this region, and the translated TLP TYPE field targets memory space; then the ST field of the TLP is changed to the value in this register. Only Valid when the CX_TPH_ENABLE configuration parameter is 1.

Note: This register field is sticky.
                }
            }
            field TAG @'h8 {
                bits 8;
                access rw;
                hard_reset 'h0;
                doc {
                    TAG.

The substituted TAG field (byte 6) in the outgoing TLP header when TAG_SUBSTITUTE_EN is set.

Note: This register field is sticky.
                }
            }
            field TAG_SUBSTITUTE_EN @'h10 {
                access rw;
                hard_reset 'h0;
                doc {
                    TAG Substitute Enable.

When enabled and region address is matched, the iATU substitutes the TAG field of the outbound TLP header with the contents of the TAG field in this register. The expected usage scenario is translation from AXI MWr to Vendor Defined Msg/MsgD.

Note (CX_TPH_ENABLE=1): TAG substitution for MWr will not occur because this field (byte 6) in the TLP header is the ST field. ST substitution can still take place using the MSG_CODE field in IATU_REGION_CTRL_2_OFF_OUTBOUND_i.

Note: This register field is sticky.
                }
            }
            field MSB2BITS_TAG @'h11 {
                bits 2;
                access rw;
                hard_reset 'h0;
                doc {
                    TAG.

Two most significant bits of the substituted TAG field in the outgoing TLP header when TAG_SUBSTITUTE_EN is set. 

Note: This register field is sticky.
                }
            }
            field FUNC_BYPASS @'h13 {
                access rw;
                hard_reset 'h0;
                doc {
                    Function Number Translation Bypass. In this mode, the function number of the translated TLP is taken from your application transmit interface and not from the CTRL_1_FUNC_NUM field of the "iATU Control 1 Register" or the VF_NUMBER field of the "iATU Control 3 Register."

Note: This register field is sticky.
                }
            }
            field SNP @'h14 {
                access rw;
                hard_reset 'h0;
                doc {
                    Serialize Non-Posted Requests. In this mode, when the AXI Bridge is populated, same AXI ID Non-Posted Read/Write Requests are transmitted on the wire if there are no other same ID Non-Posted Requests outstanding.

Note: This register field is sticky.
                }
            }
            field TLP_HEADER_FIELDS_BYPASS @'h15 {
                access rw;
                hard_reset 'h0;
                doc {
                    TLP Header Fields Translation Bypass.  In this mode header fields of the translated TLP is taken from your application transmit interface or, if AMBA is configured,  from the AMBA sideband bus (slv_awmisc_info) and not from the corresponding fields of the IATU_REGION_CTRL_1_OFF_OUTBOUND_i  or IATU_REGION_CTRL_2_OFF_OUTBOUND_i registers. The header fields are
 -	TC
 -	PH
 -	TH
 -	ST
 -	AT
 -	Attr (IDO, RO and NS).
Note: This register field is sticky. 

Note: This register field is sticky.
                }
            }
            field INHIBIT_PAYLOAD @'h16 {
                access rw;
                hard_reset 'h0;
                doc {
                    Inhibit TLP Payload Data for TLP's in Matched Region; assign iATU region to be TLP without data.
When enabled and region address is matched, the iATU marks all TLPs as having no payload data by forcing the TLP header Fmt[1] bit =0, regardless of the application inputs such as slv_wstrb.
 - 1: Fmt[1] =0 so that only TLP type without data is sent. For example, a Msg instead of MsgD will be sent.
 - 0: Fmt[1] =0/1 so that TLPs with or without data can be sent. 
Note: This register field is sticky.
                }
            }
            field HEADER_SUBSTITUTE_EN @'h17 {
                access rw;
                hard_reset 'h0;
                doc {
                    Header Substitute Enable.

When enabled and region address is matched, the iATU fully substitutes bytes 8-11 (for 3 DWORD header) or bytes 12-15 (for 4 DWORD header) of the outbound TLP header with the contents of the LWR_TARGET_RW field in IATU_LWR_TARGET_ADDR_OFF_OUTBOUND_i.
 - 1: LWR_TARGET_RW in the iATU_LWR_TARGET_ADDR_OFF_OUTBOUND_i register is used to fill bytes 8-to-11 (for 3 DWORD header) or bytes 12-to-15 (for 4 DWORD header) of the translated TLP header.
 - 0: LWR_TARGET_RW in the iATU_LWR_TARGET_ADDR_OFF_OUTBOUND_i register forms the new address of the translated region.
Note: This register field is sticky.
                }
            }
            field CFG_SHIFT_MODE @'h1c {
                access rw;
                hard_reset 'h0;
                doc {
                    CFG Shift Mode.

The iATU uses bits [27:12] of the untranslated address (on the XALI0/1/2 interface or AXI slave interface address) to form the BDF number of the outgoing CFG TLP.

This supports the Enhanced Configuration Address Mapping (ECAM) mechanism (Section 7.2.2 of the PCI Express Base 3.1 Specification, revision 1.0) by allowing all outgoing I/O and MEM TLPs (that have been translated to CFG) to be mapped from memory space into any 256 MB region of the PCIe configuration space.

Note: This register field is sticky.
                }
            }
            field INVERT_MODE @'h1d {
                access rw;
                hard_reset 'h0;
                doc {
                    Invert Mode. When set the address matching region is inverted. Therefore, an address match occurs when the untranslated address is in the region outside the defined range (Base Address to Limit Address).

Note: This register field is sticky.
                }
            }
            field REGION_EN @'h1f {
                access rw;
                hard_reset 'h0;
                doc {
                    Region Enable. This bit must be set to '1' for address translation to take place.

Note: This register field is sticky.
                }
            }
            doc {
                iATU Region Control 2 Register.iATU Region Control 2 Register.
            }
        }
        register IATU_LWR_BASE_ADDR_OFF_OUTBOUND_8 @'h1008 {
            bytes 4;
            field LWR_BASE_HW @'h0 {
                bits 12;
                access ro;
                hard_reset 'h0;
                doc {
                    Forms bits [n-1:0] of the start address of the address region to be translated. The start address must be aligned to a CX_ATU_MIN_REGION_SIZE kB boundary, so these bits are always 0.
A write to this location is ignored by the PCIe controller.

n is log2(CX_ATU_MIN_REGION_SIZE)
                }
            }
            field LWR_BASE_RW @'hc {
                bits 20;
                access rw;
                hard_reset 'h0;
                doc {
                    Forms bits [31:n] of the start address of the address region to be translated. 
n is log2(CX_ATU_MIN_REGION_SIZE)

Note: This register field is sticky.
                }
            }
            doc {
                iATU Lower Base Address Register. The CX_ATU_MIN_REGION_SIZE configuration parameter (Value Range: 4 kB, 8 kB, 16 kB, 32 kB, 64 kB defaults to 64 kB) specifies the minimum size of an address translation region. For example, if set to 64 kB; the lower 16 bits of the Base, Limit and Target registers are zero and all address regions are aligned on 64 kB boundaries. More precisely, the lower log2(CX_ATU_MIN_REGION_SIZE) bits are zero.iATU Lower Base Address Register. The CX_ATU_MIN_REGION_SIZE configuration parameter (Value Range: 4 kB, 8 kB, 16 kB, 32 kB, 64 kB defaults to 64 kB) specifies the minimum size of an address translation region. For example, if set to 64 kB; the lower 16 bits of the Base, Limit and Target registers are zero and all address regions are aligned on 64 kB boundaries. More precisely, the lower log2(CX_ATU_MIN_REGION_SIZE) bits are zero.
            }
        }
        register IATU_UPPER_BASE_ADDR_OFF_OUTBOUND_8 @'h100c {
            bytes 4;
            field UPPER_BASE_RW @'h0 {
                bits 32;
                access rw;
                hard_reset 'h0;
                doc {
                    Forms bits [63:32] of the start (and end) address of the address region to be translated. In systems with a 32-bit address space, this register is not used and therefore writing to this register has no effect.

Note: This register field is sticky.
                }
            }
            doc {
                iATU Upper Base Address Register.iATU Upper Base Address Register.
            }
        }
        register IATU_LIMIT_ADDR_OFF_OUTBOUND_8 @'h1010 {
            bytes 4;
            field LIMIT_ADDR_HW @'h0 {
                bits 12;
                access ro;
                hard_reset 'h0;
                doc {
                    Forms lower bits of the end address of the address region to be translated. The end address must be aligned to a CX_ATU_MIN_REGION_SIZE kB boundary, so these bits are always all ones.
A write to this location is ignored by the PCIe controller.
                }
            }
            field LIMIT_ADDR_RW @'hc {
                bits 20;
                access rw;
                hard_reset 'h0;
                doc {
                    Forms upper bits of the end address of the address region to be translated.

Note: This register field is sticky.
                }
            }
            doc {
                iATU Limit Address Register.iATU Limit Address Register.
            }
        }
        register IATU_LWR_TARGET_ADDR_OFF_OUTBOUND_8 @'h1014 {
            bytes 4;
            field LWR_TARGET_RW_OUTBOUND @'h0 {
                bits 32;
                access rw;
                hard_reset 'h0;
                doc {
                    When HEADER_SUBSTITUTE_EN in IATU_REGION_CTRL_2_OFF_OUTBOUND_ is '0' (normal operation):
 - LWR_TARGET_RW[31:n] forms MSB's of the Lower Target part of the new address of the translated region;
 - LWR_TARGET_RW[n-1:0] are not used. (The start address must be aligned to a CX_ATU_MIN_REGION_SIZE kB boundary, so the lower bits of the start address of the new address of the translated region (bits n-1:0) are always '0').
 - n is log2(CX_ATU_MIN_REGION_SIZE).
When HEADER_SUBSTITUTE_EN in IATU_REGION_CTRL_2_OFF_OUTBOUND_i is '1':
 - LWR_TARGET_RW[31:0] forms bytes 8-11 (for 3 dword header) or bytes 12-15 (for 4 dword header) of the outbound TLP header. Usage scenarios include the transmission of Vendor Defined Messages where the controller determines the content of bytes 12 to 15 of the TLP header.
Note: This register field is sticky.
                }
            }
            doc {
                iATU Lower Target Address Register.iATU Lower Target Address Register.
            }
        }
        register IATU_UPPER_TARGET_ADDR_OFF_OUTBOUND_8 @'h1018 {
            bytes 4;
            field UPPER_TARGET_RW @'h0 {
                bits 32;
                access rw;
                hard_reset 'h0;
                doc {
                    Forms bits [63:32] of the start address (Upper Target part) of the new address of the translated region.

Note: This register field is sticky.
                }
            }
            doc {
                iATU Upper Target Address Register.iATU Upper Target Address Register.
            }
        }
        register IATU_UPPR_LIMIT_ADDR_OFF_OUTBOUND_8 @'h1020 {
            bytes 4;
            field UPPR_LIMIT_ADDR_RW @'h0 {
                bits 4;
                access rw;
                hard_reset 'h0;
                doc {
                    Forms the LSB's of the Upper Limit part of the region "end address" to be translated. Only applies to 64-bit systems and when the INCREASE_REGION_SIZE field in IATU_REGION_CTRL_1_OFF_OUTBOUND_i is '1'

Note: This register field is sticky.
                }
            }
            field UPPR_LIMIT_ADDR_HW @'h4 {
                bits 28;
                access ro;
                hard_reset 'h0;
                doc {
                    Forms MSB's of the Upper Limit part of the region "end address" to be translated. Only applies to 64-bit systems and when the INCREASE_REGION_SIZE field in IATU_REGION_CTRL_1_OFF_OUTBOUND_i is '1'. These bits are always '0'.
                }
            }
            doc {
                iATU Upper Limit Address Register. The CX_MAX_ATU_REGION_SIZE configuration parameter (Value Range: 0->32, 8=1TB) specifies the maximum region size of an address translation region. This register is only used when the INCREASE_REGION_SIZE field in IATU_REGION_CTRL_1_OFF_OUTBOUND_i is '1'.iATU Upper Limit Address Register. The CX_MAX_ATU_REGION_SIZE configuration parameter (Value Range: 0->32, 8=1TB) specifies the maximum region size of an address translation region. This register is only used when the INCREASE_REGION_SIZE field in IATU_REGION_CTRL_1_OFF_OUTBOUND_i is '1'.
            }
        }
        register IATU_REGION_CTRL_1_OFF_INBOUND_8 @'h1100 {
            bytes 4;
            field TYPE @'h0 {
                bits 5;
                access rw;
                hard_reset 'h0;
                doc {
                    When the TYPE field of an inbound TLP is matched to this value, then address translation proceeds (when all other enabled field-matches are successful).

Note: This register field is sticky.
                }
            }
            field TC @'h5 {
                bits 3;
                access rw;
                hard_reset 'h0;
                doc {
                    When the TC field of an inbound TLP is matched to this value, then address translation proceeds (when all other enabled field-matches are successful). This check is only performed if the "TC Match Enable" bit of the "iATU Control 2 Register" is set.

Note: This register field is sticky.
                }
            }
            field TD @'h8 {
                access rw;
                hard_reset 'h0;
                doc {
                    When the TD field of an inbound TLP is matched to this value, then address translation proceeds (when all other enabled field-matches are successful). This check is only performed if the "TD Match Enable" bit of the "iATU Control 2 Register" is set.

Note: This register field is sticky.
                }
            }
            field ATTR @'h9 {
                bits 2;
                access rw;
                hard_reset 'h0;
                doc {
                    When the ATTR field of an inbound TLP is matched to this value, then address translation proceeds (when all other enabled field-matches are successful). This check is only performed if the "ATTR Match Enable" bit of the "iATU Control 2 Register" is set.

Note: This register field is sticky.
                }
            }
            field INCREASE_REGION_SIZE @'hd {
                access rw;
                hard_reset 'h0;
                doc {
                    Increase the maximum ATU Region size. When set, the maximum ATU Region size is determined by CX_ATU_MAX_REGION_SIZE. When clear, the maximum ATU Region size is 4 GB (default).

Note: This register field is sticky.
                }
            }
            field CTRL_1_FUNC_NUM @'h14 {
                bits 3;
                access rw;
                hard_reset 'h0;
                doc {
                    Function Number.
 - MEM-I/O: When the Address and BAR matching logic in the controller indicate that a MEM-I/O transaction matches a BAR in the function corresponding to this value, then address translation proceeds. This check is only performed if the "Function Number Match Enable" bit of the "iATU Control 2 Register" is set.
 - CFG0/CFG1: When the destination function number as specified in the routing ID of the TLP header matches the function, then address translation proceeds. This check is only performed if the "Function Number Match Enable" bit of the "iATU Control 2 Register" is set.
Note: This register field is sticky.
                }
            }
            doc {
                iATU Region Control 1 Register.iATU Region Control 1 Register.
            }
        }
        register IATU_REGION_CTRL_2_OFF_INBOUND_8 @'h1104 {
            bytes 4;
            field MSG_CODE @'h0 {
                bits 8;
                access rw;
                hard_reset 'h0;
                doc {
                    MSG TLPs: (Message Code). When the TYPE field of an inbound Msg/MsgD TLP is matched to this value, then address translation proceeds (when all other enabled field-matches are successful). This check is only performed if the "Message Code Match Enable" bit of the "iATU Control 2 Register" is set.

Memory TLPs: (ST;Steering Tag). When the ST field of an inbound TLP is matched to this value, then address translation proceeds. This check is only performed if the "ST Match Enable" bit of the "iATU Control2 Register" is set. The setting is independent of the setting of the TH field. Only Valid when the CX_TPH_ENABLE configuration parameter is 1.

Note: This register field is sticky.
                }
            }
            field BAR_NUM @'h8 {
                bits 3;
                access rw;
                hard_reset 'h0;
                doc {
                    BAR Number. When the BAR number of an inbound MEM or IO TLP " that is matched by the normal internal BAR address matching mechanism " is the same as this field, address translation proceeds (when all other enabled field-matches are successful). This check is only performed if the "Match Mode" bit of the "iATU Control 2 Register" is set.
 - 000b - BAR0
 - 001b - BAR1
 - 010b - BAR2
 - 011b - BAR3
 - 100b - BAR4
 - 101b - BAR5
 - 110b - ROM
 - 111b - reserved
 - IO translation would require either 00100b or 00101b in the inbound TLP TYPE; the BAR Number set in the range 000b - 101b and that BAR configured as an IO BAR.
Note: This register field is sticky.
                }
            }
            field MSG_TYPE_MATCH_MODE @'hd {
                access rw;
                hard_reset 'h0;
                doc {
                    Message Type Match Mode.

When enabled, and if single address location translate enable is set, then inbound TLPs of type MSG/MSGd which match the type field of the iatu_region_ctrl_1_OFF_inbound register (=>TYPE[4:3]=2'b10) will be translated.
Message type match mode overrides any value of MATCH_MODE field in this register. Usage scenarios for this are translation of VDM or ATS messages when AXI bridge is configured on client interface.

Note: This register field is sticky.
                }
            }
            field TC_MATCH_EN @'he {
                access rw;
                hard_reset 'h0;
                doc {
                    TC Match Enable. Ensures that a successful TC TLP field comparison match (see TC field of the "iATU Control 1 Register") occurs for address translation to proceed.

Note: This register field is sticky.
                }
            }
            field TD_MATCH_EN @'hf {
                access rw;
                hard_reset 'h0;
                doc {
                    TD Match Enable. Ensures that a successful TD TLP field comparison match (see TD field of the "iATU Control 1 Register") occurs for address translation to proceed.

Note: This register field is sticky.
                }
            }
            field ATTR_MATCH_EN @'h10 {
                access rw;
                hard_reset 'h0;
                doc {
                    ATTR Match Enable. Ensures that a successful ATTR TLP field comparison match (see ATTR field of the "iATU Control 1 Register") occurs for address translation to proceed.

Note: This register field is sticky.
                }
            }
            field FUNC_NUM_MATCH_EN @'h13 {
                access rw;
                hard_reset 'h0;
                doc {
                    Function Number Match Enable. Ensures that a successful Function Number TLP field comparison match (see Function Number field of the "iATU Control 1 Register") occurs (in MEM-I/O and CFG0/CFG1 transactions) for address translation to proceed.

Note: This register field is sticky.
                }
            }
            field MSG_CODE_MATCH_EN @'h15 {
                access rw;
                hard_reset 'h0;
                doc {
                    Message Code Match Enable (Msg TLPS). Ensures that a successful message Code TLP field comparison match (see Message Code field of the "iATU Control 2 Register") occurs (in MSG transactions) for address translation to proceed.

ST Match Enable (Mem TLPs). Ensures that a successful ST TLP field comparison match (see ST field of the "iATU Control 2 Register") occurs (in MEM transactions) for address translation to proceed. Only Valid when the CX_TPH_ENABLE configuration parameter is 1

Note: This register field is sticky.
                }
            }
            field SINGLE_ADDR_LOC_TRANS_EN @'h17 {
                access rw;
                hard_reset 'h0;
                doc {
                    Single Address Location Translate Enable.

When enabled, Rx TLPs can be translated to a single address location as determined by the target address register of the iATU region.
The main usage scenario is translation of Messages (such as Vendor Defined or ATS Messages) to MWr TLPs when the AXI bridge is enabled.

Note: This register field is sticky.
                }
            }
            field RESPONSE_CODE @'h18 {
                bits 2;
                access rw;
                hard_reset 'h0;
                doc {
                    Response Code. Defines the type of response to give for accesses matching this region. This overrides the normal RADM filter response. Note that this feature is not available for any region where Single Address Location Translate is enabled.
 - 00 - Normal RADM filter response is used.
 - 01 - Unsupported request (UR)
 - 10 - Completer abort (CA)
 - 11 - Not used / undefined / reserved.
Note: This register field is sticky.
                }
            }
            field FUZZY_TYPE_MATCH_CODE @'h1b {
                access rw;
                hard_reset 'h0;
                doc {
                    Fuzzy Type Match Mode. When enabled, the iATU relaxes the matching of the TLP TYPE field against the expected TYPE field so that
 - CfgRd0 and CfgRd1 TLPs are seen as identical. Similarly with CfgWr0 and CfgWr1.
 - MWr, MRd and MRdLk TLPs are seen as identical
 - The Routing field of Msg/MsgD TLPs is ignored
 - FetchAdd, Swap and CAS are seen as identical.
For example, CFG0 in the TYPE field in the "iATU Control 1 Register" matches against an inbound CfgRd0, CfgRd1, CfgWr0 or CfgWr1 TLP.

Note: This register field is sticky.
                }
            }
            field CFG_SHIFT_MODE @'h1c {
                access rw;
                hard_reset 'h0;
                doc {
                    CFG Shift Mode. This is useful for CFG transactions where the PCIe configuration mechanism maps bits [27:12] of the address to the bus/device and function number. This allows a CFG configuration space to be located in any 256MB window of your application memory space using a 28-bit effective address. Shifts bits [31:16] of the untranslated address to form bits [27:12] of the translated address.

Note: This register field is sticky.
                }
            }
            field INVERT_MODE @'h1d {
                access rw;
                hard_reset 'h0;
                doc {
                    Invert Mode. When set the address matching region is inverted. Therefore, an address match occurs when the untranslated address is in the region outside the defined range (Base Address to Limit Address).

Note: This register field is sticky.
                }
            }
            field MATCH_MODE @'h1e {
                access rw;
                hard_reset 'h0;
                doc {
                    Match Mode. Determines Inbound matching mode for TLPs. The mode depends on the type of TLP that is received as follows:

 For MEM-I/O TLPs, this field is interpreted as follows:
 - 0: Address Match Mode. The iATU operates using addresses as in the outbound direction. The Region Base and Limit Registers must be setup.
 - 1:BAR Match Mode. BAR matching is used. The "BAR Number" field is relevant. Not used for RC.
For CFG0 TLPs, this field is interpreted as follows:
 - 0: Routing ID Match Mode. The iATU interprets the Routing ID (Bytes 8 to 11 of TLP header) as an address. This corresponds to the upper 16 bits of the address in MEM-I/O transactions. The Routing ID of the TLP must be within the base and limit of the iATU region for matching to proceed.
 - 1: Accept Mode. The iATU accepts all CFG0 transactions as address matches. The routing ID in the CFG0 TLP is ignored. This is useful as all received CFG0 TLPs should be processed regardless of the Bus number.
For MSG/MSGD TLPs, this field is interpreted as follows:
 - 0: Address Match Mode. The iATU treats the third dword and fourth dword of the inbound MSG/MSGD TLP as an address and it is matched against the Region Base and Limit Registers.
 - 1: Vendor ID Match Mode. This mode is relevant for ID-routed Vendor Defined Messages. The iATU ignores the Routing ID (Bus, Device, Function) in bits [31:16] of the third dword of the TLP header, but matches against the Vendor ID in bits [15:0] of the third dword of the TLP header. Bits [15:0] of the Region Upper Base register should be programmed with the required Vendor ID. The lower Base and Limit Register should be programmed to translate TLPs based on vendor specific information in the fourth dword of the TLP header.
 -	If SINGLE_ADDRESS_LOCATION_TRANSLATE_EN = 1 AND MSG_TYPE_MATCH_MODE = 1, then Match Mode is ignored.
Note: This register field is sticky.
                }
            }
            field REGION_EN @'h1f {
                access rw;
                hard_reset 'h0;
                doc {
                    Region Enable. This bit must be set to '1' for address translation to take place.

Note: This register field is sticky.
                }
            }
            doc {
                iATU Region Control 2 Register.iATU Region Control 2 Register.
            }
        }
        register IATU_LWR_BASE_ADDR_OFF_INBOUND_8 @'h1108 {
            bytes 4;
            field LWR_BASE_HW @'h0 {
                bits 12;
                access ro;
                hard_reset 'h0;
                doc {
                    Forms bits [n-1:0] of the start address of the address region to be translated. The start address must be aligned to a CX_ATU_MIN_REGION_SIZE kB boundary, so these bits are always 0.
A write to this location is ignored by the PCIe controller.

n is log2(CX_ATU_MIN_REGION_SIZE)
                }
            }
            field LWR_BASE_RW @'hc {
                bits 20;
                access rw;
                hard_reset 'h0;
                doc {
                    Forms bits [31:n] of the start address of the address region to be translated. 
n is log2(CX_ATU_MIN_REGION_SIZE)

Note: This register field is sticky.
                }
            }
            doc {
                iATU Lower Base Address Register. The CX_ATU_MIN_REGION_SIZE configuration parameter (Value Range: 4 kB, 8 kB, 16 kB, 32 kB, 64 kB defaults to 64 kB) specifies the minimum size of an address translation region. For example, if set to 64 kB; the lower 16 bits of the Base, Limit and Target registers are zero and all address regions are aligned on 64 kB boundaries. More precisely, the lower log2(CX_ATU_MIN_REGION_SIZE) bits are zero.iATU Lower Base Address Register. The CX_ATU_MIN_REGION_SIZE configuration parameter (Value Range: 4 kB, 8 kB, 16 kB, 32 kB, 64 kB defaults to 64 kB) specifies the minimum size of an address translation region. For example, if set to 64 kB; the lower 16 bits of the Base, Limit and Target registers are zero and all address regions are aligned on 64 kB boundaries. More precisely, the lower log2(CX_ATU_MIN_REGION_SIZE) bits are zero.
            }
        }
        register IATU_UPPER_BASE_ADDR_OFF_INBOUND_8 @'h110c {
            bytes 4;
            field UPPER_BASE_RW @'h0 {
                bits 32;
                access rw;
                hard_reset 'h0;
                doc {
                    Forms bits [63:32] of the start (and end) address of the address region to be translated.

Note: This register field is sticky.
                }
            }
            doc {
                iATU Upper Base Address Register.iATU Upper Base Address Register.
            }
        }
        register IATU_LIMIT_ADDR_OFF_INBOUND_8 @'h1110 {
            bytes 4;
            field LIMIT_ADDR_HW @'h0 {
                bits 12;
                access ro;
                hard_reset 'h0;
                doc {
                    Forms lower bits of the end address of the address region to be translated. The end address must be aligned to a CX_ATU_MIN_REGION_SIZE kB boundary, so these bits are always all ones.
A write to this location is ignored by the PCIe controller.
                }
            }
            field LIMIT_ADDR_RW @'hc {
                bits 20;
                access rw;
                hard_reset 'h0;
                doc {
                    Forms upper bits of the end address of the address region to be translated.

Note: This register field is sticky.
                }
            }
            doc {
                iATU Limit Address Register.iATU Limit Address Register.
            }
        }
        register IATU_LWR_TARGET_ADDR_OFF_INBOUND_8 @'h1114 {
            bytes 4;
            field LWR_TARGET_HW @'h0 {
                bits 12;
                access ro;
                hard_reset 'h0;
                doc {
                    Forms the LSB's of the Lower Target part of the new address of the translated region. The start address must be aligned to a CX_ATU_MIN_REGION_SIZE kB boundary (in address match mode); and to the Bar size boundary (in BAR match mode) so that these bits are always '0'. If the BAR is smaller than the iATU region size, then the iATU target address must align to the iATU region size; otherwise it must align to the BAR size.

A write to this location is ignored by the PCIe controller.
 - Field size depends on log2(CX_ATU_MIN_REGION_SIZE) in address match mode.
 - Field size depends on log2(BAR_MASK+1) in BAR match mode.
                }
            }
            field LWR_TARGET_RW @'hc {
                bits 20;
                access rw;
                hard_reset 'h0;
                doc {
                    Forms MSB's of the Lower Target part of the new address of the translated region. These bits are always '0'.
 - Field size depends on log2(CX_ATU_MIN_REGION_SIZE) in address match mode.
 - Field size depends on log2(BAR_MASK+1) in BAR match mode.
Note: This register field is sticky.
                }
            }
            doc {
                iATU Lower Target Address Register.iATU Lower Target Address Register.
            }
        }
        register IATU_UPPER_TARGET_ADDR_OFF_INBOUND_8 @'h1118 {
            bytes 4;
            field UPPER_TARGET_RW @'h0 {
                bits 32;
                access rw;
                hard_reset 'h0;
                doc {
                    Forms bits [63:32] of the start address (Upper Target part) of the new address of the translated region. In systems with a 32-bit address space, this register is not used and therefore writing to this register has no effect.

Note: This register field is sticky.
                }
            }
            doc {
                iATU Upper Target Address Register.iATU Upper Target Address Register.
            }
        }
        register IATU_UPPR_LIMIT_ADDR_OFF_INBOUND_8 @'h1120 {
            bytes 4;
            field UPPR_LIMIT_ADDR_RW @'h0 {
                bits 4;
                access rw;
                hard_reset 'h0;
                doc {
                    Forms the LSB's of the Upper Limit part of the region "end address" to be translated. Only applies to 64-bit systems and when the INCREASE_REGION_SIZE field in IATU_REGION_CTRL_1_OFF_INBOUND_i is '1'

Note: This register field is sticky.
                }
            }
            field UPPR_LIMIT_ADDR_HW @'h4 {
                bits 28;
                access ro;
                hard_reset 'h0;
                doc {
                    Forms MSB's of the Upper Limit part of the region "end address" to be translated. Only applies to 64-bit systems and when the INCREASE_REGION_SIZE field in IATU_REGION_CTRL_1_OFF_INBOUND_i is '1'. These bits are always '0'.
                }
            }
            doc {
                iATU Upper Limit Address Register. The CX_MAX_ATU_REGION_SIZE configuration parameter (Value Range: 0->32, 8=1TB) specifies the maximum region size of an address translation region. This register is only used when the INCREASE_REGION_SIZE field in IATU_REGION_CTRL_1_OFF_INBOUND_i is '1'.iATU Upper Limit Address Register. The CX_MAX_ATU_REGION_SIZE configuration parameter (Value Range: 0->32, 8=1TB) specifies the maximum region size of an address translation region. This register is only used when the INCREASE_REGION_SIZE field in IATU_REGION_CTRL_1_OFF_INBOUND_i is '1'.
            }
        }
        register IATU_REGION_CTRL_1_OFF_OUTBOUND_9 @'h1200 {
            bytes 4;
            field TYPE @'h0 {
                bits 5;
                access rw;
                hard_reset 'h0;
                doc {
                    When the address of an outbound TLP is matched to this region, then the TYPE field of the TLP is changed to the value in this register.

Note: This register field is sticky.
                }
            }
            field TC @'h5 {
                bits 3;
                access rw;
                hard_reset 'h0;
                doc {
                    When the address of an outbound TLP is matched to this region, then the TC field of the TLP is changed to the value in this register.

Note: This register field is sticky.
                }
            }
            field TD @'h8 {
                access rw;
                hard_reset 'h0;
                doc {
                    This is a reserved field. Do not use.

Note: This register field is sticky.
                }
            }
            field ATTR @'h9 {
                bits 2;
                access rw;
                hard_reset 'h0;
                doc {
                    When the address of an outbound TLP is matched to this region, then the ATTR field of the TLP is changed to the value in this register.

Note: This register field is sticky.
                }
            }
            field INCREASE_REGION_SIZE @'hd {
                access rw;
                hard_reset 'h0;
                doc {
                    Increase the maximum ATU Region size. When set, the maximum ATU Region size is determined by CX_ATU_MAX_REGION_SIZE. When clear, the maximum ATU Region size is 4 GB (default).

Note: This register field is sticky.
                }
            }
            field CTRL_1_FUNC_NUM @'h14 {
                bits 3;
                access rw;
                hard_reset 'h0;
                doc {
                    Function Number.
 - When the address of an outbound TLP is matched to this region and the FUNC_BYPASS field in the "iATU Control 2 Register" is '0', then the function number used in generating the function part of the requester ID (RID) field of the TLP is taken from this 5-bit register. The value in this register must be 0x0 unless multifunction operation in the controller is enabled (CX_NFUNC > 1).
 - When you are using the AXI Bridge, then this field is swapped before AXI decomposition occurs so that the correct "Max_Read_Request_Size" and "Max_Payload_Size" values are used.

Note: This register field is sticky.
                }
            }
            doc {
                iATU Region Control 1 Register.iATU Region Control 1 Register.
            }
        }
        register IATU_REGION_CTRL_2_OFF_OUTBOUND_9 @'h1204 {
            bytes 4;
            field MSG_CODE @'h0 {
                bits 8;
                access rw;
                hard_reset 'h0;
                doc {
                    MSG TLPs (Message Code). When the address of an outbound TLP is matched to this region, and the translated TLP TYPE field is Msg or MsgD; then the message field of the TLP is changed to the value in this register.

Memory TLPs: (ST;Steering Tag). When the ST field of an outbound TLP is matched to this region, and the translated TLP TYPE field targets memory space; then the ST field of the TLP is changed to the value in this register. Only Valid when the CX_TPH_ENABLE configuration parameter is 1.

Note: This register field is sticky.
                }
            }
            field TAG @'h8 {
                bits 8;
                access rw;
                hard_reset 'h0;
                doc {
                    TAG.

The substituted TAG field (byte 6) in the outgoing TLP header when TAG_SUBSTITUTE_EN is set.

Note: This register field is sticky.
                }
            }
            field TAG_SUBSTITUTE_EN @'h10 {
                access rw;
                hard_reset 'h0;
                doc {
                    TAG Substitute Enable.

When enabled and region address is matched, the iATU substitutes the TAG field of the outbound TLP header with the contents of the TAG field in this register. The expected usage scenario is translation from AXI MWr to Vendor Defined Msg/MsgD.

Note (CX_TPH_ENABLE=1): TAG substitution for MWr will not occur because this field (byte 6) in the TLP header is the ST field. ST substitution can still take place using the MSG_CODE field in IATU_REGION_CTRL_2_OFF_OUTBOUND_i.

Note: This register field is sticky.
                }
            }
            field MSB2BITS_TAG @'h11 {
                bits 2;
                access rw;
                hard_reset 'h0;
                doc {
                    TAG.

Two most significant bits of the substituted TAG field in the outgoing TLP header when TAG_SUBSTITUTE_EN is set. 

Note: This register field is sticky.
                }
            }
            field FUNC_BYPASS @'h13 {
                access rw;
                hard_reset 'h0;
                doc {
                    Function Number Translation Bypass. In this mode, the function number of the translated TLP is taken from your application transmit interface and not from the CTRL_1_FUNC_NUM field of the "iATU Control 1 Register" or the VF_NUMBER field of the "iATU Control 3 Register."

Note: This register field is sticky.
                }
            }
            field SNP @'h14 {
                access rw;
                hard_reset 'h0;
                doc {
                    Serialize Non-Posted Requests. In this mode, when the AXI Bridge is populated, same AXI ID Non-Posted Read/Write Requests are transmitted on the wire if there are no other same ID Non-Posted Requests outstanding.

Note: This register field is sticky.
                }
            }
            field TLP_HEADER_FIELDS_BYPASS @'h15 {
                access rw;
                hard_reset 'h0;
                doc {
                    TLP Header Fields Translation Bypass.  In this mode header fields of the translated TLP is taken from your application transmit interface or, if AMBA is configured,  from the AMBA sideband bus (slv_awmisc_info) and not from the corresponding fields of the IATU_REGION_CTRL_1_OFF_OUTBOUND_i  or IATU_REGION_CTRL_2_OFF_OUTBOUND_i registers. The header fields are
 -	TC
 -	PH
 -	TH
 -	ST
 -	AT
 -	Attr (IDO, RO and NS).
Note: This register field is sticky. 

Note: This register field is sticky.
                }
            }
            field INHIBIT_PAYLOAD @'h16 {
                access rw;
                hard_reset 'h0;
                doc {
                    Inhibit TLP Payload Data for TLP's in Matched Region; assign iATU region to be TLP without data.
When enabled and region address is matched, the iATU marks all TLPs as having no payload data by forcing the TLP header Fmt[1] bit =0, regardless of the application inputs such as slv_wstrb.
 - 1: Fmt[1] =0 so that only TLP type without data is sent. For example, a Msg instead of MsgD will be sent.
 - 0: Fmt[1] =0/1 so that TLPs with or without data can be sent. 
Note: This register field is sticky.
                }
            }
            field HEADER_SUBSTITUTE_EN @'h17 {
                access rw;
                hard_reset 'h0;
                doc {
                    Header Substitute Enable.

When enabled and region address is matched, the iATU fully substitutes bytes 8-11 (for 3 DWORD header) or bytes 12-15 (for 4 DWORD header) of the outbound TLP header with the contents of the LWR_TARGET_RW field in IATU_LWR_TARGET_ADDR_OFF_OUTBOUND_i.
 - 1: LWR_TARGET_RW in the iATU_LWR_TARGET_ADDR_OFF_OUTBOUND_i register is used to fill bytes 8-to-11 (for 3 DWORD header) or bytes 12-to-15 (for 4 DWORD header) of the translated TLP header.
 - 0: LWR_TARGET_RW in the iATU_LWR_TARGET_ADDR_OFF_OUTBOUND_i register forms the new address of the translated region.
Note: This register field is sticky.
                }
            }
            field CFG_SHIFT_MODE @'h1c {
                access rw;
                hard_reset 'h0;
                doc {
                    CFG Shift Mode.

The iATU uses bits [27:12] of the untranslated address (on the XALI0/1/2 interface or AXI slave interface address) to form the BDF number of the outgoing CFG TLP.

This supports the Enhanced Configuration Address Mapping (ECAM) mechanism (Section 7.2.2 of the PCI Express Base 3.1 Specification, revision 1.0) by allowing all outgoing I/O and MEM TLPs (that have been translated to CFG) to be mapped from memory space into any 256 MB region of the PCIe configuration space.

Note: This register field is sticky.
                }
            }
            field INVERT_MODE @'h1d {
                access rw;
                hard_reset 'h0;
                doc {
                    Invert Mode. When set the address matching region is inverted. Therefore, an address match occurs when the untranslated address is in the region outside the defined range (Base Address to Limit Address).

Note: This register field is sticky.
                }
            }
            field REGION_EN @'h1f {
                access rw;
                hard_reset 'h0;
                doc {
                    Region Enable. This bit must be set to '1' for address translation to take place.

Note: This register field is sticky.
                }
            }
            doc {
                iATU Region Control 2 Register.iATU Region Control 2 Register.
            }
        }
        register IATU_LWR_BASE_ADDR_OFF_OUTBOUND_9 @'h1208 {
            bytes 4;
            field LWR_BASE_HW @'h0 {
                bits 12;
                access ro;
                hard_reset 'h0;
                doc {
                    Forms bits [n-1:0] of the start address of the address region to be translated. The start address must be aligned to a CX_ATU_MIN_REGION_SIZE kB boundary, so these bits are always 0.
A write to this location is ignored by the PCIe controller.

n is log2(CX_ATU_MIN_REGION_SIZE)
                }
            }
            field LWR_BASE_RW @'hc {
                bits 20;
                access rw;
                hard_reset 'h0;
                doc {
                    Forms bits [31:n] of the start address of the address region to be translated. 
n is log2(CX_ATU_MIN_REGION_SIZE)

Note: This register field is sticky.
                }
            }
            doc {
                iATU Lower Base Address Register. The CX_ATU_MIN_REGION_SIZE configuration parameter (Value Range: 4 kB, 8 kB, 16 kB, 32 kB, 64 kB defaults to 64 kB) specifies the minimum size of an address translation region. For example, if set to 64 kB; the lower 16 bits of the Base, Limit and Target registers are zero and all address regions are aligned on 64 kB boundaries. More precisely, the lower log2(CX_ATU_MIN_REGION_SIZE) bits are zero.iATU Lower Base Address Register. The CX_ATU_MIN_REGION_SIZE configuration parameter (Value Range: 4 kB, 8 kB, 16 kB, 32 kB, 64 kB defaults to 64 kB) specifies the minimum size of an address translation region. For example, if set to 64 kB; the lower 16 bits of the Base, Limit and Target registers are zero and all address regions are aligned on 64 kB boundaries. More precisely, the lower log2(CX_ATU_MIN_REGION_SIZE) bits are zero.
            }
        }
        register IATU_UPPER_BASE_ADDR_OFF_OUTBOUND_9 @'h120c {
            bytes 4;
            field UPPER_BASE_RW @'h0 {
                bits 32;
                access rw;
                hard_reset 'h0;
                doc {
                    Forms bits [63:32] of the start (and end) address of the address region to be translated. In systems with a 32-bit address space, this register is not used and therefore writing to this register has no effect.

Note: This register field is sticky.
                }
            }
            doc {
                iATU Upper Base Address Register.iATU Upper Base Address Register.
            }
        }
        register IATU_LIMIT_ADDR_OFF_OUTBOUND_9 @'h1210 {
            bytes 4;
            field LIMIT_ADDR_HW @'h0 {
                bits 12;
                access ro;
                hard_reset 'h0;
                doc {
                    Forms lower bits of the end address of the address region to be translated. The end address must be aligned to a CX_ATU_MIN_REGION_SIZE kB boundary, so these bits are always all ones.
A write to this location is ignored by the PCIe controller.
                }
            }
            field LIMIT_ADDR_RW @'hc {
                bits 20;
                access rw;
                hard_reset 'h0;
                doc {
                    Forms upper bits of the end address of the address region to be translated.

Note: This register field is sticky.
                }
            }
            doc {
                iATU Limit Address Register.iATU Limit Address Register.
            }
        }
        register IATU_LWR_TARGET_ADDR_OFF_OUTBOUND_9 @'h1214 {
            bytes 4;
            field LWR_TARGET_RW_OUTBOUND @'h0 {
                bits 32;
                access rw;
                hard_reset 'h0;
                doc {
                    When HEADER_SUBSTITUTE_EN in IATU_REGION_CTRL_2_OFF_OUTBOUND_ is '0' (normal operation):
 - LWR_TARGET_RW[31:n] forms MSB's of the Lower Target part of the new address of the translated region;
 - LWR_TARGET_RW[n-1:0] are not used. (The start address must be aligned to a CX_ATU_MIN_REGION_SIZE kB boundary, so the lower bits of the start address of the new address of the translated region (bits n-1:0) are always '0').
 - n is log2(CX_ATU_MIN_REGION_SIZE).
When HEADER_SUBSTITUTE_EN in IATU_REGION_CTRL_2_OFF_OUTBOUND_i is '1':
 - LWR_TARGET_RW[31:0] forms bytes 8-11 (for 3 dword header) or bytes 12-15 (for 4 dword header) of the outbound TLP header. Usage scenarios include the transmission of Vendor Defined Messages where the controller determines the content of bytes 12 to 15 of the TLP header.
Note: This register field is sticky.
                }
            }
            doc {
                iATU Lower Target Address Register.iATU Lower Target Address Register.
            }
        }
        register IATU_UPPER_TARGET_ADDR_OFF_OUTBOUND_9 @'h1218 {
            bytes 4;
            field UPPER_TARGET_RW @'h0 {
                bits 32;
                access rw;
                hard_reset 'h0;
                doc {
                    Forms bits [63:32] of the start address (Upper Target part) of the new address of the translated region.

Note: This register field is sticky.
                }
            }
            doc {
                iATU Upper Target Address Register.iATU Upper Target Address Register.
            }
        }
        register IATU_UPPR_LIMIT_ADDR_OFF_OUTBOUND_9 @'h1220 {
            bytes 4;
            field UPPR_LIMIT_ADDR_RW @'h0 {
                bits 4;
                access rw;
                hard_reset 'h0;
                doc {
                    Forms the LSB's of the Upper Limit part of the region "end address" to be translated. Only applies to 64-bit systems and when the INCREASE_REGION_SIZE field in IATU_REGION_CTRL_1_OFF_OUTBOUND_i is '1'

Note: This register field is sticky.
                }
            }
            field UPPR_LIMIT_ADDR_HW @'h4 {
                bits 28;
                access ro;
                hard_reset 'h0;
                doc {
                    Forms MSB's of the Upper Limit part of the region "end address" to be translated. Only applies to 64-bit systems and when the INCREASE_REGION_SIZE field in IATU_REGION_CTRL_1_OFF_OUTBOUND_i is '1'. These bits are always '0'.
                }
            }
            doc {
                iATU Upper Limit Address Register. The CX_MAX_ATU_REGION_SIZE configuration parameter (Value Range: 0->32, 8=1TB) specifies the maximum region size of an address translation region. This register is only used when the INCREASE_REGION_SIZE field in IATU_REGION_CTRL_1_OFF_OUTBOUND_i is '1'.iATU Upper Limit Address Register. The CX_MAX_ATU_REGION_SIZE configuration parameter (Value Range: 0->32, 8=1TB) specifies the maximum region size of an address translation region. This register is only used when the INCREASE_REGION_SIZE field in IATU_REGION_CTRL_1_OFF_OUTBOUND_i is '1'.
            }
        }
        register IATU_REGION_CTRL_1_OFF_INBOUND_9 @'h1300 {
            bytes 4;
            field TYPE @'h0 {
                bits 5;
                access rw;
                hard_reset 'h0;
                doc {
                    When the TYPE field of an inbound TLP is matched to this value, then address translation proceeds (when all other enabled field-matches are successful).

Note: This register field is sticky.
                }
            }
            field TC @'h5 {
                bits 3;
                access rw;
                hard_reset 'h0;
                doc {
                    When the TC field of an inbound TLP is matched to this value, then address translation proceeds (when all other enabled field-matches are successful). This check is only performed if the "TC Match Enable" bit of the "iATU Control 2 Register" is set.

Note: This register field is sticky.
                }
            }
            field TD @'h8 {
                access rw;
                hard_reset 'h0;
                doc {
                    When the TD field of an inbound TLP is matched to this value, then address translation proceeds (when all other enabled field-matches are successful). This check is only performed if the "TD Match Enable" bit of the "iATU Control 2 Register" is set.

Note: This register field is sticky.
                }
            }
            field ATTR @'h9 {
                bits 2;
                access rw;
                hard_reset 'h0;
                doc {
                    When the ATTR field of an inbound TLP is matched to this value, then address translation proceeds (when all other enabled field-matches are successful). This check is only performed if the "ATTR Match Enable" bit of the "iATU Control 2 Register" is set.

Note: This register field is sticky.
                }
            }
            field INCREASE_REGION_SIZE @'hd {
                access rw;
                hard_reset 'h0;
                doc {
                    Increase the maximum ATU Region size. When set, the maximum ATU Region size is determined by CX_ATU_MAX_REGION_SIZE. When clear, the maximum ATU Region size is 4 GB (default).

Note: This register field is sticky.
                }
            }
            field CTRL_1_FUNC_NUM @'h14 {
                bits 3;
                access rw;
                hard_reset 'h0;
                doc {
                    Function Number.
 - MEM-I/O: When the Address and BAR matching logic in the controller indicate that a MEM-I/O transaction matches a BAR in the function corresponding to this value, then address translation proceeds. This check is only performed if the "Function Number Match Enable" bit of the "iATU Control 2 Register" is set.
 - CFG0/CFG1: When the destination function number as specified in the routing ID of the TLP header matches the function, then address translation proceeds. This check is only performed if the "Function Number Match Enable" bit of the "iATU Control 2 Register" is set.
Note: This register field is sticky.
                }
            }
            doc {
                iATU Region Control 1 Register.iATU Region Control 1 Register.
            }
        }
        register IATU_REGION_CTRL_2_OFF_INBOUND_9 @'h1304 {
            bytes 4;
            field MSG_CODE @'h0 {
                bits 8;
                access rw;
                hard_reset 'h0;
                doc {
                    MSG TLPs: (Message Code). When the TYPE field of an inbound Msg/MsgD TLP is matched to this value, then address translation proceeds (when all other enabled field-matches are successful). This check is only performed if the "Message Code Match Enable" bit of the "iATU Control 2 Register" is set.

Memory TLPs: (ST;Steering Tag). When the ST field of an inbound TLP is matched to this value, then address translation proceeds. This check is only performed if the "ST Match Enable" bit of the "iATU Control2 Register" is set. The setting is independent of the setting of the TH field. Only Valid when the CX_TPH_ENABLE configuration parameter is 1.

Note: This register field is sticky.
                }
            }
            field BAR_NUM @'h8 {
                bits 3;
                access rw;
                hard_reset 'h0;
                doc {
                    BAR Number. When the BAR number of an inbound MEM or IO TLP " that is matched by the normal internal BAR address matching mechanism " is the same as this field, address translation proceeds (when all other enabled field-matches are successful). This check is only performed if the "Match Mode" bit of the "iATU Control 2 Register" is set.
 - 000b - BAR0
 - 001b - BAR1
 - 010b - BAR2
 - 011b - BAR3
 - 100b - BAR4
 - 101b - BAR5
 - 110b - ROM
 - 111b - reserved
 - IO translation would require either 00100b or 00101b in the inbound TLP TYPE; the BAR Number set in the range 000b - 101b and that BAR configured as an IO BAR.
Note: This register field is sticky.
                }
            }
            field MSG_TYPE_MATCH_MODE @'hd {
                access rw;
                hard_reset 'h0;
                doc {
                    Message Type Match Mode.

When enabled, and if single address location translate enable is set, then inbound TLPs of type MSG/MSGd which match the type field of the iatu_region_ctrl_1_OFF_inbound register (=>TYPE[4:3]=2'b10) will be translated.
Message type match mode overrides any value of MATCH_MODE field in this register. Usage scenarios for this are translation of VDM or ATS messages when AXI bridge is configured on client interface.

Note: This register field is sticky.
                }
            }
            field TC_MATCH_EN @'he {
                access rw;
                hard_reset 'h0;
                doc {
                    TC Match Enable. Ensures that a successful TC TLP field comparison match (see TC field of the "iATU Control 1 Register") occurs for address translation to proceed.

Note: This register field is sticky.
                }
            }
            field TD_MATCH_EN @'hf {
                access rw;
                hard_reset 'h0;
                doc {
                    TD Match Enable. Ensures that a successful TD TLP field comparison match (see TD field of the "iATU Control 1 Register") occurs for address translation to proceed.

Note: This register field is sticky.
                }
            }
            field ATTR_MATCH_EN @'h10 {
                access rw;
                hard_reset 'h0;
                doc {
                    ATTR Match Enable. Ensures that a successful ATTR TLP field comparison match (see ATTR field of the "iATU Control 1 Register") occurs for address translation to proceed.

Note: This register field is sticky.
                }
            }
            field FUNC_NUM_MATCH_EN @'h13 {
                access rw;
                hard_reset 'h0;
                doc {
                    Function Number Match Enable. Ensures that a successful Function Number TLP field comparison match (see Function Number field of the "iATU Control 1 Register") occurs (in MEM-I/O and CFG0/CFG1 transactions) for address translation to proceed.

Note: This register field is sticky.
                }
            }
            field MSG_CODE_MATCH_EN @'h15 {
                access rw;
                hard_reset 'h0;
                doc {
                    Message Code Match Enable (Msg TLPS). Ensures that a successful message Code TLP field comparison match (see Message Code field of the "iATU Control 2 Register") occurs (in MSG transactions) for address translation to proceed.

ST Match Enable (Mem TLPs). Ensures that a successful ST TLP field comparison match (see ST field of the "iATU Control 2 Register") occurs (in MEM transactions) for address translation to proceed. Only Valid when the CX_TPH_ENABLE configuration parameter is 1

Note: This register field is sticky.
                }
            }
            field SINGLE_ADDR_LOC_TRANS_EN @'h17 {
                access rw;
                hard_reset 'h0;
                doc {
                    Single Address Location Translate Enable.

When enabled, Rx TLPs can be translated to a single address location as determined by the target address register of the iATU region.
The main usage scenario is translation of Messages (such as Vendor Defined or ATS Messages) to MWr TLPs when the AXI bridge is enabled.

Note: This register field is sticky.
                }
            }
            field RESPONSE_CODE @'h18 {
                bits 2;
                access rw;
                hard_reset 'h0;
                doc {
                    Response Code. Defines the type of response to give for accesses matching this region. This overrides the normal RADM filter response. Note that this feature is not available for any region where Single Address Location Translate is enabled.
 - 00 - Normal RADM filter response is used.
 - 01 - Unsupported request (UR)
 - 10 - Completer abort (CA)
 - 11 - Not used / undefined / reserved.
Note: This register field is sticky.
                }
            }
            field FUZZY_TYPE_MATCH_CODE @'h1b {
                access rw;
                hard_reset 'h0;
                doc {
                    Fuzzy Type Match Mode. When enabled, the iATU relaxes the matching of the TLP TYPE field against the expected TYPE field so that
 - CfgRd0 and CfgRd1 TLPs are seen as identical. Similarly with CfgWr0 and CfgWr1.
 - MWr, MRd and MRdLk TLPs are seen as identical
 - The Routing field of Msg/MsgD TLPs is ignored
 - FetchAdd, Swap and CAS are seen as identical.
For example, CFG0 in the TYPE field in the "iATU Control 1 Register" matches against an inbound CfgRd0, CfgRd1, CfgWr0 or CfgWr1 TLP.

Note: This register field is sticky.
                }
            }
            field CFG_SHIFT_MODE @'h1c {
                access rw;
                hard_reset 'h0;
                doc {
                    CFG Shift Mode. This is useful for CFG transactions where the PCIe configuration mechanism maps bits [27:12] of the address to the bus/device and function number. This allows a CFG configuration space to be located in any 256MB window of your application memory space using a 28-bit effective address. Shifts bits [31:16] of the untranslated address to form bits [27:12] of the translated address.

Note: This register field is sticky.
                }
            }
            field INVERT_MODE @'h1d {
                access rw;
                hard_reset 'h0;
                doc {
                    Invert Mode. When set the address matching region is inverted. Therefore, an address match occurs when the untranslated address is in the region outside the defined range (Base Address to Limit Address).

Note: This register field is sticky.
                }
            }
            field MATCH_MODE @'h1e {
                access rw;
                hard_reset 'h0;
                doc {
                    Match Mode. Determines Inbound matching mode for TLPs. The mode depends on the type of TLP that is received as follows:

 For MEM-I/O TLPs, this field is interpreted as follows:
 - 0: Address Match Mode. The iATU operates using addresses as in the outbound direction. The Region Base and Limit Registers must be setup.
 - 1:BAR Match Mode. BAR matching is used. The "BAR Number" field is relevant. Not used for RC.
For CFG0 TLPs, this field is interpreted as follows:
 - 0: Routing ID Match Mode. The iATU interprets the Routing ID (Bytes 8 to 11 of TLP header) as an address. This corresponds to the upper 16 bits of the address in MEM-I/O transactions. The Routing ID of the TLP must be within the base and limit of the iATU region for matching to proceed.
 - 1: Accept Mode. The iATU accepts all CFG0 transactions as address matches. The routing ID in the CFG0 TLP is ignored. This is useful as all received CFG0 TLPs should be processed regardless of the Bus number.
For MSG/MSGD TLPs, this field is interpreted as follows:
 - 0: Address Match Mode. The iATU treats the third dword and fourth dword of the inbound MSG/MSGD TLP as an address and it is matched against the Region Base and Limit Registers.
 - 1: Vendor ID Match Mode. This mode is relevant for ID-routed Vendor Defined Messages. The iATU ignores the Routing ID (Bus, Device, Function) in bits [31:16] of the third dword of the TLP header, but matches against the Vendor ID in bits [15:0] of the third dword of the TLP header. Bits [15:0] of the Region Upper Base register should be programmed with the required Vendor ID. The lower Base and Limit Register should be programmed to translate TLPs based on vendor specific information in the fourth dword of the TLP header.
 -	If SINGLE_ADDRESS_LOCATION_TRANSLATE_EN = 1 AND MSG_TYPE_MATCH_MODE = 1, then Match Mode is ignored.
Note: This register field is sticky.
                }
            }
            field REGION_EN @'h1f {
                access rw;
                hard_reset 'h0;
                doc {
                    Region Enable. This bit must be set to '1' for address translation to take place.

Note: This register field is sticky.
                }
            }
            doc {
                iATU Region Control 2 Register.iATU Region Control 2 Register.
            }
        }
        register IATU_LWR_BASE_ADDR_OFF_INBOUND_9 @'h1308 {
            bytes 4;
            field LWR_BASE_HW @'h0 {
                bits 12;
                access ro;
                hard_reset 'h0;
                doc {
                    Forms bits [n-1:0] of the start address of the address region to be translated. The start address must be aligned to a CX_ATU_MIN_REGION_SIZE kB boundary, so these bits are always 0.
A write to this location is ignored by the PCIe controller.

n is log2(CX_ATU_MIN_REGION_SIZE)
                }
            }
            field LWR_BASE_RW @'hc {
                bits 20;
                access rw;
                hard_reset 'h0;
                doc {
                    Forms bits [31:n] of the start address of the address region to be translated. 
n is log2(CX_ATU_MIN_REGION_SIZE)

Note: This register field is sticky.
                }
            }
            doc {
                iATU Lower Base Address Register. The CX_ATU_MIN_REGION_SIZE configuration parameter (Value Range: 4 kB, 8 kB, 16 kB, 32 kB, 64 kB defaults to 64 kB) specifies the minimum size of an address translation region. For example, if set to 64 kB; the lower 16 bits of the Base, Limit and Target registers are zero and all address regions are aligned on 64 kB boundaries. More precisely, the lower log2(CX_ATU_MIN_REGION_SIZE) bits are zero.iATU Lower Base Address Register. The CX_ATU_MIN_REGION_SIZE configuration parameter (Value Range: 4 kB, 8 kB, 16 kB, 32 kB, 64 kB defaults to 64 kB) specifies the minimum size of an address translation region. For example, if set to 64 kB; the lower 16 bits of the Base, Limit and Target registers are zero and all address regions are aligned on 64 kB boundaries. More precisely, the lower log2(CX_ATU_MIN_REGION_SIZE) bits are zero.
            }
        }
        register IATU_UPPER_BASE_ADDR_OFF_INBOUND_9 @'h130c {
            bytes 4;
            field UPPER_BASE_RW @'h0 {
                bits 32;
                access rw;
                hard_reset 'h0;
                doc {
                    Forms bits [63:32] of the start (and end) address of the address region to be translated.

Note: This register field is sticky.
                }
            }
            doc {
                iATU Upper Base Address Register.iATU Upper Base Address Register.
            }
        }
        register IATU_LIMIT_ADDR_OFF_INBOUND_9 @'h1310 {
            bytes 4;
            field LIMIT_ADDR_HW @'h0 {
                bits 12;
                access ro;
                hard_reset 'h0;
                doc {
                    Forms lower bits of the end address of the address region to be translated. The end address must be aligned to a CX_ATU_MIN_REGION_SIZE kB boundary, so these bits are always all ones.
A write to this location is ignored by the PCIe controller.
                }
            }
            field LIMIT_ADDR_RW @'hc {
                bits 20;
                access rw;
                hard_reset 'h0;
                doc {
                    Forms upper bits of the end address of the address region to be translated.

Note: This register field is sticky.
                }
            }
            doc {
                iATU Limit Address Register.iATU Limit Address Register.
            }
        }
        register IATU_LWR_TARGET_ADDR_OFF_INBOUND_9 @'h1314 {
            bytes 4;
            field LWR_TARGET_HW @'h0 {
                bits 12;
                access ro;
                hard_reset 'h0;
                doc {
                    Forms the LSB's of the Lower Target part of the new address of the translated region. The start address must be aligned to a CX_ATU_MIN_REGION_SIZE kB boundary (in address match mode); and to the Bar size boundary (in BAR match mode) so that these bits are always '0'. If the BAR is smaller than the iATU region size, then the iATU target address must align to the iATU region size; otherwise it must align to the BAR size.

A write to this location is ignored by the PCIe controller.
 - Field size depends on log2(CX_ATU_MIN_REGION_SIZE) in address match mode.
 - Field size depends on log2(BAR_MASK+1) in BAR match mode.
                }
            }
            field LWR_TARGET_RW @'hc {
                bits 20;
                access rw;
                hard_reset 'h0;
                doc {
                    Forms MSB's of the Lower Target part of the new address of the translated region. These bits are always '0'.
 - Field size depends on log2(CX_ATU_MIN_REGION_SIZE) in address match mode.
 - Field size depends on log2(BAR_MASK+1) in BAR match mode.
Note: This register field is sticky.
                }
            }
            doc {
                iATU Lower Target Address Register.iATU Lower Target Address Register.
            }
        }
        register IATU_UPPER_TARGET_ADDR_OFF_INBOUND_9 @'h1318 {
            bytes 4;
            field UPPER_TARGET_RW @'h0 {
                bits 32;
                access rw;
                hard_reset 'h0;
                doc {
                    Forms bits [63:32] of the start address (Upper Target part) of the new address of the translated region. In systems with a 32-bit address space, this register is not used and therefore writing to this register has no effect.

Note: This register field is sticky.
                }
            }
            doc {
                iATU Upper Target Address Register.iATU Upper Target Address Register.
            }
        }
        register IATU_UPPR_LIMIT_ADDR_OFF_INBOUND_9 @'h1320 {
            bytes 4;
            field UPPR_LIMIT_ADDR_RW @'h0 {
                bits 4;
                access rw;
                hard_reset 'h0;
                doc {
                    Forms the LSB's of the Upper Limit part of the region "end address" to be translated. Only applies to 64-bit systems and when the INCREASE_REGION_SIZE field in IATU_REGION_CTRL_1_OFF_INBOUND_i is '1'

Note: This register field is sticky.
                }
            }
            field UPPR_LIMIT_ADDR_HW @'h4 {
                bits 28;
                access ro;
                hard_reset 'h0;
                doc {
                    Forms MSB's of the Upper Limit part of the region "end address" to be translated. Only applies to 64-bit systems and when the INCREASE_REGION_SIZE field in IATU_REGION_CTRL_1_OFF_INBOUND_i is '1'. These bits are always '0'.
                }
            }
            doc {
                iATU Upper Limit Address Register. The CX_MAX_ATU_REGION_SIZE configuration parameter (Value Range: 0->32, 8=1TB) specifies the maximum region size of an address translation region. This register is only used when the INCREASE_REGION_SIZE field in IATU_REGION_CTRL_1_OFF_INBOUND_i is '1'.iATU Upper Limit Address Register. The CX_MAX_ATU_REGION_SIZE configuration parameter (Value Range: 0->32, 8=1TB) specifies the maximum region size of an address translation region. This register is only used when the INCREASE_REGION_SIZE field in IATU_REGION_CTRL_1_OFF_INBOUND_i is '1'.
            }
        }
        register IATU_REGION_CTRL_1_OFF_OUTBOUND_10 @'h1400 {
            bytes 4;
            field TYPE @'h0 {
                bits 5;
                access rw;
                hard_reset 'h0;
                doc {
                    When the address of an outbound TLP is matched to this region, then the TYPE field of the TLP is changed to the value in this register.

Note: This register field is sticky.
                }
            }
            field TC @'h5 {
                bits 3;
                access rw;
                hard_reset 'h0;
                doc {
                    When the address of an outbound TLP is matched to this region, then the TC field of the TLP is changed to the value in this register.

Note: This register field is sticky.
                }
            }
            field TD @'h8 {
                access rw;
                hard_reset 'h0;
                doc {
                    This is a reserved field. Do not use.

Note: This register field is sticky.
                }
            }
            field ATTR @'h9 {
                bits 2;
                access rw;
                hard_reset 'h0;
                doc {
                    When the address of an outbound TLP is matched to this region, then the ATTR field of the TLP is changed to the value in this register.

Note: This register field is sticky.
                }
            }
            field INCREASE_REGION_SIZE @'hd {
                access rw;
                hard_reset 'h0;
                doc {
                    Increase the maximum ATU Region size. When set, the maximum ATU Region size is determined by CX_ATU_MAX_REGION_SIZE. When clear, the maximum ATU Region size is 4 GB (default).

Note: This register field is sticky.
                }
            }
            field CTRL_1_FUNC_NUM @'h14 {
                bits 3;
                access rw;
                hard_reset 'h0;
                doc {
                    Function Number.
 - When the address of an outbound TLP is matched to this region and the FUNC_BYPASS field in the "iATU Control 2 Register" is '0', then the function number used in generating the function part of the requester ID (RID) field of the TLP is taken from this 5-bit register. The value in this register must be 0x0 unless multifunction operation in the controller is enabled (CX_NFUNC > 1).
 - When you are using the AXI Bridge, then this field is swapped before AXI decomposition occurs so that the correct "Max_Read_Request_Size" and "Max_Payload_Size" values are used.

Note: This register field is sticky.
                }
            }
            doc {
                iATU Region Control 1 Register.iATU Region Control 1 Register.
            }
        }
        register IATU_REGION_CTRL_2_OFF_OUTBOUND_10 @'h1404 {
            bytes 4;
            field MSG_CODE @'h0 {
                bits 8;
                access rw;
                hard_reset 'h0;
                doc {
                    MSG TLPs (Message Code). When the address of an outbound TLP is matched to this region, and the translated TLP TYPE field is Msg or MsgD; then the message field of the TLP is changed to the value in this register.

Memory TLPs: (ST;Steering Tag). When the ST field of an outbound TLP is matched to this region, and the translated TLP TYPE field targets memory space; then the ST field of the TLP is changed to the value in this register. Only Valid when the CX_TPH_ENABLE configuration parameter is 1.

Note: This register field is sticky.
                }
            }
            field TAG @'h8 {
                bits 8;
                access rw;
                hard_reset 'h0;
                doc {
                    TAG.

The substituted TAG field (byte 6) in the outgoing TLP header when TAG_SUBSTITUTE_EN is set.

Note: This register field is sticky.
                }
            }
            field TAG_SUBSTITUTE_EN @'h10 {
                access rw;
                hard_reset 'h0;
                doc {
                    TAG Substitute Enable.

When enabled and region address is matched, the iATU substitutes the TAG field of the outbound TLP header with the contents of the TAG field in this register. The expected usage scenario is translation from AXI MWr to Vendor Defined Msg/MsgD.

Note (CX_TPH_ENABLE=1): TAG substitution for MWr will not occur because this field (byte 6) in the TLP header is the ST field. ST substitution can still take place using the MSG_CODE field in IATU_REGION_CTRL_2_OFF_OUTBOUND_i.

Note: This register field is sticky.
                }
            }
            field MSB2BITS_TAG @'h11 {
                bits 2;
                access rw;
                hard_reset 'h0;
                doc {
                    TAG.

Two most significant bits of the substituted TAG field in the outgoing TLP header when TAG_SUBSTITUTE_EN is set. 

Note: This register field is sticky.
                }
            }
            field FUNC_BYPASS @'h13 {
                access rw;
                hard_reset 'h0;
                doc {
                    Function Number Translation Bypass. In this mode, the function number of the translated TLP is taken from your application transmit interface and not from the CTRL_1_FUNC_NUM field of the "iATU Control 1 Register" or the VF_NUMBER field of the "iATU Control 3 Register."

Note: This register field is sticky.
                }
            }
            field SNP @'h14 {
                access rw;
                hard_reset 'h0;
                doc {
                    Serialize Non-Posted Requests. In this mode, when the AXI Bridge is populated, same AXI ID Non-Posted Read/Write Requests are transmitted on the wire if there are no other same ID Non-Posted Requests outstanding.

Note: This register field is sticky.
                }
            }
            field TLP_HEADER_FIELDS_BYPASS @'h15 {
                access rw;
                hard_reset 'h0;
                doc {
                    TLP Header Fields Translation Bypass.  In this mode header fields of the translated TLP is taken from your application transmit interface or, if AMBA is configured,  from the AMBA sideband bus (slv_awmisc_info) and not from the corresponding fields of the IATU_REGION_CTRL_1_OFF_OUTBOUND_i  or IATU_REGION_CTRL_2_OFF_OUTBOUND_i registers. The header fields are
 -	TC
 -	PH
 -	TH
 -	ST
 -	AT
 -	Attr (IDO, RO and NS).
Note: This register field is sticky. 

Note: This register field is sticky.
                }
            }
            field INHIBIT_PAYLOAD @'h16 {
                access rw;
                hard_reset 'h0;
                doc {
                    Inhibit TLP Payload Data for TLP's in Matched Region; assign iATU region to be TLP without data.
When enabled and region address is matched, the iATU marks all TLPs as having no payload data by forcing the TLP header Fmt[1] bit =0, regardless of the application inputs such as slv_wstrb.
 - 1: Fmt[1] =0 so that only TLP type without data is sent. For example, a Msg instead of MsgD will be sent.
 - 0: Fmt[1] =0/1 so that TLPs with or without data can be sent. 
Note: This register field is sticky.
                }
            }
            field HEADER_SUBSTITUTE_EN @'h17 {
                access rw;
                hard_reset 'h0;
                doc {
                    Header Substitute Enable.

When enabled and region address is matched, the iATU fully substitutes bytes 8-11 (for 3 DWORD header) or bytes 12-15 (for 4 DWORD header) of the outbound TLP header with the contents of the LWR_TARGET_RW field in IATU_LWR_TARGET_ADDR_OFF_OUTBOUND_i.
 - 1: LWR_TARGET_RW in the iATU_LWR_TARGET_ADDR_OFF_OUTBOUND_i register is used to fill bytes 8-to-11 (for 3 DWORD header) or bytes 12-to-15 (for 4 DWORD header) of the translated TLP header.
 - 0: LWR_TARGET_RW in the iATU_LWR_TARGET_ADDR_OFF_OUTBOUND_i register forms the new address of the translated region.
Note: This register field is sticky.
                }
            }
            field CFG_SHIFT_MODE @'h1c {
                access rw;
                hard_reset 'h0;
                doc {
                    CFG Shift Mode.

The iATU uses bits [27:12] of the untranslated address (on the XALI0/1/2 interface or AXI slave interface address) to form the BDF number of the outgoing CFG TLP.

This supports the Enhanced Configuration Address Mapping (ECAM) mechanism (Section 7.2.2 of the PCI Express Base 3.1 Specification, revision 1.0) by allowing all outgoing I/O and MEM TLPs (that have been translated to CFG) to be mapped from memory space into any 256 MB region of the PCIe configuration space.

Note: This register field is sticky.
                }
            }
            field INVERT_MODE @'h1d {
                access rw;
                hard_reset 'h0;
                doc {
                    Invert Mode. When set the address matching region is inverted. Therefore, an address match occurs when the untranslated address is in the region outside the defined range (Base Address to Limit Address).

Note: This register field is sticky.
                }
            }
            field REGION_EN @'h1f {
                access rw;
                hard_reset 'h0;
                doc {
                    Region Enable. This bit must be set to '1' for address translation to take place.

Note: This register field is sticky.
                }
            }
            doc {
                iATU Region Control 2 Register.iATU Region Control 2 Register.
            }
        }
        register IATU_LWR_BASE_ADDR_OFF_OUTBOUND_10 @'h1408 {
            bytes 4;
            field LWR_BASE_HW @'h0 {
                bits 12;
                access ro;
                hard_reset 'h0;
                doc {
                    Forms bits [n-1:0] of the start address of the address region to be translated. The start address must be aligned to a CX_ATU_MIN_REGION_SIZE kB boundary, so these bits are always 0.
A write to this location is ignored by the PCIe controller.

n is log2(CX_ATU_MIN_REGION_SIZE)
                }
            }
            field LWR_BASE_RW @'hc {
                bits 20;
                access rw;
                hard_reset 'h0;
                doc {
                    Forms bits [31:n] of the start address of the address region to be translated. 
n is log2(CX_ATU_MIN_REGION_SIZE)

Note: This register field is sticky.
                }
            }
            doc {
                iATU Lower Base Address Register. The CX_ATU_MIN_REGION_SIZE configuration parameter (Value Range: 4 kB, 8 kB, 16 kB, 32 kB, 64 kB defaults to 64 kB) specifies the minimum size of an address translation region. For example, if set to 64 kB; the lower 16 bits of the Base, Limit and Target registers are zero and all address regions are aligned on 64 kB boundaries. More precisely, the lower log2(CX_ATU_MIN_REGION_SIZE) bits are zero.iATU Lower Base Address Register. The CX_ATU_MIN_REGION_SIZE configuration parameter (Value Range: 4 kB, 8 kB, 16 kB, 32 kB, 64 kB defaults to 64 kB) specifies the minimum size of an address translation region. For example, if set to 64 kB; the lower 16 bits of the Base, Limit and Target registers are zero and all address regions are aligned on 64 kB boundaries. More precisely, the lower log2(CX_ATU_MIN_REGION_SIZE) bits are zero.
            }
        }
        register IATU_UPPER_BASE_ADDR_OFF_OUTBOUND_10 @'h140c {
            bytes 4;
            field UPPER_BASE_RW @'h0 {
                bits 32;
                access rw;
                hard_reset 'h0;
                doc {
                    Forms bits [63:32] of the start (and end) address of the address region to be translated. In systems with a 32-bit address space, this register is not used and therefore writing to this register has no effect.

Note: This register field is sticky.
                }
            }
            doc {
                iATU Upper Base Address Register.iATU Upper Base Address Register.
            }
        }
        register IATU_LIMIT_ADDR_OFF_OUTBOUND_10 @'h1410 {
            bytes 4;
            field LIMIT_ADDR_HW @'h0 {
                bits 12;
                access ro;
                hard_reset 'h0;
                doc {
                    Forms lower bits of the end address of the address region to be translated. The end address must be aligned to a CX_ATU_MIN_REGION_SIZE kB boundary, so these bits are always all ones.
A write to this location is ignored by the PCIe controller.
                }
            }
            field LIMIT_ADDR_RW @'hc {
                bits 20;
                access rw;
                hard_reset 'h0;
                doc {
                    Forms upper bits of the end address of the address region to be translated.

Note: This register field is sticky.
                }
            }
            doc {
                iATU Limit Address Register.iATU Limit Address Register.
            }
        }
        register IATU_LWR_TARGET_ADDR_OFF_OUTBOUND_10 @'h1414 {
            bytes 4;
            field LWR_TARGET_RW_OUTBOUND @'h0 {
                bits 32;
                access rw;
                hard_reset 'h0;
                doc {
                    When HEADER_SUBSTITUTE_EN in IATU_REGION_CTRL_2_OFF_OUTBOUND_ is '0' (normal operation):
 - LWR_TARGET_RW[31:n] forms MSB's of the Lower Target part of the new address of the translated region;
 - LWR_TARGET_RW[n-1:0] are not used. (The start address must be aligned to a CX_ATU_MIN_REGION_SIZE kB boundary, so the lower bits of the start address of the new address of the translated region (bits n-1:0) are always '0').
 - n is log2(CX_ATU_MIN_REGION_SIZE).
When HEADER_SUBSTITUTE_EN in IATU_REGION_CTRL_2_OFF_OUTBOUND_i is '1':
 - LWR_TARGET_RW[31:0] forms bytes 8-11 (for 3 dword header) or bytes 12-15 (for 4 dword header) of the outbound TLP header. Usage scenarios include the transmission of Vendor Defined Messages where the controller determines the content of bytes 12 to 15 of the TLP header.
Note: This register field is sticky.
                }
            }
            doc {
                iATU Lower Target Address Register.iATU Lower Target Address Register.
            }
        }
        register IATU_UPPER_TARGET_ADDR_OFF_OUTBOUND_10 @'h1418 {
            bytes 4;
            field UPPER_TARGET_RW @'h0 {
                bits 32;
                access rw;
                hard_reset 'h0;
                doc {
                    Forms bits [63:32] of the start address (Upper Target part) of the new address of the translated region.

Note: This register field is sticky.
                }
            }
            doc {
                iATU Upper Target Address Register.iATU Upper Target Address Register.
            }
        }
        register IATU_UPPR_LIMIT_ADDR_OFF_OUTBOUND_10 @'h1420 {
            bytes 4;
            field UPPR_LIMIT_ADDR_RW @'h0 {
                bits 4;
                access rw;
                hard_reset 'h0;
                doc {
                    Forms the LSB's of the Upper Limit part of the region "end address" to be translated. Only applies to 64-bit systems and when the INCREASE_REGION_SIZE field in IATU_REGION_CTRL_1_OFF_OUTBOUND_i is '1'

Note: This register field is sticky.
                }
            }
            field UPPR_LIMIT_ADDR_HW @'h4 {
                bits 28;
                access ro;
                hard_reset 'h0;
                doc {
                    Forms MSB's of the Upper Limit part of the region "end address" to be translated. Only applies to 64-bit systems and when the INCREASE_REGION_SIZE field in IATU_REGION_CTRL_1_OFF_OUTBOUND_i is '1'. These bits are always '0'.
                }
            }
            doc {
                iATU Upper Limit Address Register. The CX_MAX_ATU_REGION_SIZE configuration parameter (Value Range: 0->32, 8=1TB) specifies the maximum region size of an address translation region. This register is only used when the INCREASE_REGION_SIZE field in IATU_REGION_CTRL_1_OFF_OUTBOUND_i is '1'.iATU Upper Limit Address Register. The CX_MAX_ATU_REGION_SIZE configuration parameter (Value Range: 0->32, 8=1TB) specifies the maximum region size of an address translation region. This register is only used when the INCREASE_REGION_SIZE field in IATU_REGION_CTRL_1_OFF_OUTBOUND_i is '1'.
            }
        }
        register IATU_REGION_CTRL_1_OFF_INBOUND_10 @'h1500 {
            bytes 4;
            field TYPE @'h0 {
                bits 5;
                access rw;
                hard_reset 'h0;
                doc {
                    When the TYPE field of an inbound TLP is matched to this value, then address translation proceeds (when all other enabled field-matches are successful).

Note: This register field is sticky.
                }
            }
            field TC @'h5 {
                bits 3;
                access rw;
                hard_reset 'h0;
                doc {
                    When the TC field of an inbound TLP is matched to this value, then address translation proceeds (when all other enabled field-matches are successful). This check is only performed if the "TC Match Enable" bit of the "iATU Control 2 Register" is set.

Note: This register field is sticky.
                }
            }
            field TD @'h8 {
                access rw;
                hard_reset 'h0;
                doc {
                    When the TD field of an inbound TLP is matched to this value, then address translation proceeds (when all other enabled field-matches are successful). This check is only performed if the "TD Match Enable" bit of the "iATU Control 2 Register" is set.

Note: This register field is sticky.
                }
            }
            field ATTR @'h9 {
                bits 2;
                access rw;
                hard_reset 'h0;
                doc {
                    When the ATTR field of an inbound TLP is matched to this value, then address translation proceeds (when all other enabled field-matches are successful). This check is only performed if the "ATTR Match Enable" bit of the "iATU Control 2 Register" is set.

Note: This register field is sticky.
                }
            }
            field INCREASE_REGION_SIZE @'hd {
                access rw;
                hard_reset 'h0;
                doc {
                    Increase the maximum ATU Region size. When set, the maximum ATU Region size is determined by CX_ATU_MAX_REGION_SIZE. When clear, the maximum ATU Region size is 4 GB (default).

Note: This register field is sticky.
                }
            }
            field CTRL_1_FUNC_NUM @'h14 {
                bits 3;
                access rw;
                hard_reset 'h0;
                doc {
                    Function Number.
 - MEM-I/O: When the Address and BAR matching logic in the controller indicate that a MEM-I/O transaction matches a BAR in the function corresponding to this value, then address translation proceeds. This check is only performed if the "Function Number Match Enable" bit of the "iATU Control 2 Register" is set.
 - CFG0/CFG1: When the destination function number as specified in the routing ID of the TLP header matches the function, then address translation proceeds. This check is only performed if the "Function Number Match Enable" bit of the "iATU Control 2 Register" is set.
Note: This register field is sticky.
                }
            }
            doc {
                iATU Region Control 1 Register.iATU Region Control 1 Register.
            }
        }
        register IATU_REGION_CTRL_2_OFF_INBOUND_10 @'h1504 {
            bytes 4;
            field MSG_CODE @'h0 {
                bits 8;
                access rw;
                hard_reset 'h0;
                doc {
                    MSG TLPs: (Message Code). When the TYPE field of an inbound Msg/MsgD TLP is matched to this value, then address translation proceeds (when all other enabled field-matches are successful). This check is only performed if the "Message Code Match Enable" bit of the "iATU Control 2 Register" is set.

Memory TLPs: (ST;Steering Tag). When the ST field of an inbound TLP is matched to this value, then address translation proceeds. This check is only performed if the "ST Match Enable" bit of the "iATU Control2 Register" is set. The setting is independent of the setting of the TH field. Only Valid when the CX_TPH_ENABLE configuration parameter is 1.

Note: This register field is sticky.
                }
            }
            field BAR_NUM @'h8 {
                bits 3;
                access rw;
                hard_reset 'h0;
                doc {
                    BAR Number. When the BAR number of an inbound MEM or IO TLP " that is matched by the normal internal BAR address matching mechanism " is the same as this field, address translation proceeds (when all other enabled field-matches are successful). This check is only performed if the "Match Mode" bit of the "iATU Control 2 Register" is set.
 - 000b - BAR0
 - 001b - BAR1
 - 010b - BAR2
 - 011b - BAR3
 - 100b - BAR4
 - 101b - BAR5
 - 110b - ROM
 - 111b - reserved
 - IO translation would require either 00100b or 00101b in the inbound TLP TYPE; the BAR Number set in the range 000b - 101b and that BAR configured as an IO BAR.
Note: This register field is sticky.
                }
            }
            field MSG_TYPE_MATCH_MODE @'hd {
                access rw;
                hard_reset 'h0;
                doc {
                    Message Type Match Mode.

When enabled, and if single address location translate enable is set, then inbound TLPs of type MSG/MSGd which match the type field of the iatu_region_ctrl_1_OFF_inbound register (=>TYPE[4:3]=2'b10) will be translated.
Message type match mode overrides any value of MATCH_MODE field in this register. Usage scenarios for this are translation of VDM or ATS messages when AXI bridge is configured on client interface.

Note: This register field is sticky.
                }
            }
            field TC_MATCH_EN @'he {
                access rw;
                hard_reset 'h0;
                doc {
                    TC Match Enable. Ensures that a successful TC TLP field comparison match (see TC field of the "iATU Control 1 Register") occurs for address translation to proceed.

Note: This register field is sticky.
                }
            }
            field TD_MATCH_EN @'hf {
                access rw;
                hard_reset 'h0;
                doc {
                    TD Match Enable. Ensures that a successful TD TLP field comparison match (see TD field of the "iATU Control 1 Register") occurs for address translation to proceed.

Note: This register field is sticky.
                }
            }
            field ATTR_MATCH_EN @'h10 {
                access rw;
                hard_reset 'h0;
                doc {
                    ATTR Match Enable. Ensures that a successful ATTR TLP field comparison match (see ATTR field of the "iATU Control 1 Register") occurs for address translation to proceed.

Note: This register field is sticky.
                }
            }
            field FUNC_NUM_MATCH_EN @'h13 {
                access rw;
                hard_reset 'h0;
                doc {
                    Function Number Match Enable. Ensures that a successful Function Number TLP field comparison match (see Function Number field of the "iATU Control 1 Register") occurs (in MEM-I/O and CFG0/CFG1 transactions) for address translation to proceed.

Note: This register field is sticky.
                }
            }
            field MSG_CODE_MATCH_EN @'h15 {
                access rw;
                hard_reset 'h0;
                doc {
                    Message Code Match Enable (Msg TLPS). Ensures that a successful message Code TLP field comparison match (see Message Code field of the "iATU Control 2 Register") occurs (in MSG transactions) for address translation to proceed.

ST Match Enable (Mem TLPs). Ensures that a successful ST TLP field comparison match (see ST field of the "iATU Control 2 Register") occurs (in MEM transactions) for address translation to proceed. Only Valid when the CX_TPH_ENABLE configuration parameter is 1

Note: This register field is sticky.
                }
            }
            field SINGLE_ADDR_LOC_TRANS_EN @'h17 {
                access rw;
                hard_reset 'h0;
                doc {
                    Single Address Location Translate Enable.

When enabled, Rx TLPs can be translated to a single address location as determined by the target address register of the iATU region.
The main usage scenario is translation of Messages (such as Vendor Defined or ATS Messages) to MWr TLPs when the AXI bridge is enabled.

Note: This register field is sticky.
                }
            }
            field RESPONSE_CODE @'h18 {
                bits 2;
                access rw;
                hard_reset 'h0;
                doc {
                    Response Code. Defines the type of response to give for accesses matching this region. This overrides the normal RADM filter response. Note that this feature is not available for any region where Single Address Location Translate is enabled.
 - 00 - Normal RADM filter response is used.
 - 01 - Unsupported request (UR)
 - 10 - Completer abort (CA)
 - 11 - Not used / undefined / reserved.
Note: This register field is sticky.
                }
            }
            field FUZZY_TYPE_MATCH_CODE @'h1b {
                access rw;
                hard_reset 'h0;
                doc {
                    Fuzzy Type Match Mode. When enabled, the iATU relaxes the matching of the TLP TYPE field against the expected TYPE field so that
 - CfgRd0 and CfgRd1 TLPs are seen as identical. Similarly with CfgWr0 and CfgWr1.
 - MWr, MRd and MRdLk TLPs are seen as identical
 - The Routing field of Msg/MsgD TLPs is ignored
 - FetchAdd, Swap and CAS are seen as identical.
For example, CFG0 in the TYPE field in the "iATU Control 1 Register" matches against an inbound CfgRd0, CfgRd1, CfgWr0 or CfgWr1 TLP.

Note: This register field is sticky.
                }
            }
            field CFG_SHIFT_MODE @'h1c {
                access rw;
                hard_reset 'h0;
                doc {
                    CFG Shift Mode. This is useful for CFG transactions where the PCIe configuration mechanism maps bits [27:12] of the address to the bus/device and function number. This allows a CFG configuration space to be located in any 256MB window of your application memory space using a 28-bit effective address. Shifts bits [31:16] of the untranslated address to form bits [27:12] of the translated address.

Note: This register field is sticky.
                }
            }
            field INVERT_MODE @'h1d {
                access rw;
                hard_reset 'h0;
                doc {
                    Invert Mode. When set the address matching region is inverted. Therefore, an address match occurs when the untranslated address is in the region outside the defined range (Base Address to Limit Address).

Note: This register field is sticky.
                }
            }
            field MATCH_MODE @'h1e {
                access rw;
                hard_reset 'h0;
                doc {
                    Match Mode. Determines Inbound matching mode for TLPs. The mode depends on the type of TLP that is received as follows:

 For MEM-I/O TLPs, this field is interpreted as follows:
 - 0: Address Match Mode. The iATU operates using addresses as in the outbound direction. The Region Base and Limit Registers must be setup.
 - 1:BAR Match Mode. BAR matching is used. The "BAR Number" field is relevant. Not used for RC.
For CFG0 TLPs, this field is interpreted as follows:
 - 0: Routing ID Match Mode. The iATU interprets the Routing ID (Bytes 8 to 11 of TLP header) as an address. This corresponds to the upper 16 bits of the address in MEM-I/O transactions. The Routing ID of the TLP must be within the base and limit of the iATU region for matching to proceed.
 - 1: Accept Mode. The iATU accepts all CFG0 transactions as address matches. The routing ID in the CFG0 TLP is ignored. This is useful as all received CFG0 TLPs should be processed regardless of the Bus number.
For MSG/MSGD TLPs, this field is interpreted as follows:
 - 0: Address Match Mode. The iATU treats the third dword and fourth dword of the inbound MSG/MSGD TLP as an address and it is matched against the Region Base and Limit Registers.
 - 1: Vendor ID Match Mode. This mode is relevant for ID-routed Vendor Defined Messages. The iATU ignores the Routing ID (Bus, Device, Function) in bits [31:16] of the third dword of the TLP header, but matches against the Vendor ID in bits [15:0] of the third dword of the TLP header. Bits [15:0] of the Region Upper Base register should be programmed with the required Vendor ID. The lower Base and Limit Register should be programmed to translate TLPs based on vendor specific information in the fourth dword of the TLP header.
 -	If SINGLE_ADDRESS_LOCATION_TRANSLATE_EN = 1 AND MSG_TYPE_MATCH_MODE = 1, then Match Mode is ignored.
Note: This register field is sticky.
                }
            }
            field REGION_EN @'h1f {
                access rw;
                hard_reset 'h0;
                doc {
                    Region Enable. This bit must be set to '1' for address translation to take place.

Note: This register field is sticky.
                }
            }
            doc {
                iATU Region Control 2 Register.iATU Region Control 2 Register.
            }
        }
        register IATU_LWR_BASE_ADDR_OFF_INBOUND_10 @'h1508 {
            bytes 4;
            field LWR_BASE_HW @'h0 {
                bits 12;
                access ro;
                hard_reset 'h0;
                doc {
                    Forms bits [n-1:0] of the start address of the address region to be translated. The start address must be aligned to a CX_ATU_MIN_REGION_SIZE kB boundary, so these bits are always 0.
A write to this location is ignored by the PCIe controller.

n is log2(CX_ATU_MIN_REGION_SIZE)
                }
            }
            field LWR_BASE_RW @'hc {
                bits 20;
                access rw;
                hard_reset 'h0;
                doc {
                    Forms bits [31:n] of the start address of the address region to be translated. 
n is log2(CX_ATU_MIN_REGION_SIZE)

Note: This register field is sticky.
                }
            }
            doc {
                iATU Lower Base Address Register. The CX_ATU_MIN_REGION_SIZE configuration parameter (Value Range: 4 kB, 8 kB, 16 kB, 32 kB, 64 kB defaults to 64 kB) specifies the minimum size of an address translation region. For example, if set to 64 kB; the lower 16 bits of the Base, Limit and Target registers are zero and all address regions are aligned on 64 kB boundaries. More precisely, the lower log2(CX_ATU_MIN_REGION_SIZE) bits are zero.iATU Lower Base Address Register. The CX_ATU_MIN_REGION_SIZE configuration parameter (Value Range: 4 kB, 8 kB, 16 kB, 32 kB, 64 kB defaults to 64 kB) specifies the minimum size of an address translation region. For example, if set to 64 kB; the lower 16 bits of the Base, Limit and Target registers are zero and all address regions are aligned on 64 kB boundaries. More precisely, the lower log2(CX_ATU_MIN_REGION_SIZE) bits are zero.
            }
        }
        register IATU_UPPER_BASE_ADDR_OFF_INBOUND_10 @'h150c {
            bytes 4;
            field UPPER_BASE_RW @'h0 {
                bits 32;
                access rw;
                hard_reset 'h0;
                doc {
                    Forms bits [63:32] of the start (and end) address of the address region to be translated.

Note: This register field is sticky.
                }
            }
            doc {
                iATU Upper Base Address Register.iATU Upper Base Address Register.
            }
        }
        register IATU_LIMIT_ADDR_OFF_INBOUND_10 @'h1510 {
            bytes 4;
            field LIMIT_ADDR_HW @'h0 {
                bits 12;
                access ro;
                hard_reset 'h0;
                doc {
                    Forms lower bits of the end address of the address region to be translated. The end address must be aligned to a CX_ATU_MIN_REGION_SIZE kB boundary, so these bits are always all ones.
A write to this location is ignored by the PCIe controller.
                }
            }
            field LIMIT_ADDR_RW @'hc {
                bits 20;
                access rw;
                hard_reset 'h0;
                doc {
                    Forms upper bits of the end address of the address region to be translated.

Note: This register field is sticky.
                }
            }
            doc {
                iATU Limit Address Register.iATU Limit Address Register.
            }
        }
        register IATU_LWR_TARGET_ADDR_OFF_INBOUND_10 @'h1514 {
            bytes 4;
            field LWR_TARGET_HW @'h0 {
                bits 12;
                access ro;
                hard_reset 'h0;
                doc {
                    Forms the LSB's of the Lower Target part of the new address of the translated region. The start address must be aligned to a CX_ATU_MIN_REGION_SIZE kB boundary (in address match mode); and to the Bar size boundary (in BAR match mode) so that these bits are always '0'. If the BAR is smaller than the iATU region size, then the iATU target address must align to the iATU region size; otherwise it must align to the BAR size.

A write to this location is ignored by the PCIe controller.
 - Field size depends on log2(CX_ATU_MIN_REGION_SIZE) in address match mode.
 - Field size depends on log2(BAR_MASK+1) in BAR match mode.
                }
            }
            field LWR_TARGET_RW @'hc {
                bits 20;
                access rw;
                hard_reset 'h0;
                doc {
                    Forms MSB's of the Lower Target part of the new address of the translated region. These bits are always '0'.
 - Field size depends on log2(CX_ATU_MIN_REGION_SIZE) in address match mode.
 - Field size depends on log2(BAR_MASK+1) in BAR match mode.
Note: This register field is sticky.
                }
            }
            doc {
                iATU Lower Target Address Register.iATU Lower Target Address Register.
            }
        }
        register IATU_UPPER_TARGET_ADDR_OFF_INBOUND_10 @'h1518 {
            bytes 4;
            field UPPER_TARGET_RW @'h0 {
                bits 32;
                access rw;
                hard_reset 'h0;
                doc {
                    Forms bits [63:32] of the start address (Upper Target part) of the new address of the translated region. In systems with a 32-bit address space, this register is not used and therefore writing to this register has no effect.

Note: This register field is sticky.
                }
            }
            doc {
                iATU Upper Target Address Register.iATU Upper Target Address Register.
            }
        }
        register IATU_UPPR_LIMIT_ADDR_OFF_INBOUND_10 @'h1520 {
            bytes 4;
            field UPPR_LIMIT_ADDR_RW @'h0 {
                bits 4;
                access rw;
                hard_reset 'h0;
                doc {
                    Forms the LSB's of the Upper Limit part of the region "end address" to be translated. Only applies to 64-bit systems and when the INCREASE_REGION_SIZE field in IATU_REGION_CTRL_1_OFF_INBOUND_i is '1'

Note: This register field is sticky.
                }
            }
            field UPPR_LIMIT_ADDR_HW @'h4 {
                bits 28;
                access ro;
                hard_reset 'h0;
                doc {
                    Forms MSB's of the Upper Limit part of the region "end address" to be translated. Only applies to 64-bit systems and when the INCREASE_REGION_SIZE field in IATU_REGION_CTRL_1_OFF_INBOUND_i is '1'. These bits are always '0'.
                }
            }
            doc {
                iATU Upper Limit Address Register. The CX_MAX_ATU_REGION_SIZE configuration parameter (Value Range: 0->32, 8=1TB) specifies the maximum region size of an address translation region. This register is only used when the INCREASE_REGION_SIZE field in IATU_REGION_CTRL_1_OFF_INBOUND_i is '1'.iATU Upper Limit Address Register. The CX_MAX_ATU_REGION_SIZE configuration parameter (Value Range: 0->32, 8=1TB) specifies the maximum region size of an address translation region. This register is only used when the INCREASE_REGION_SIZE field in IATU_REGION_CTRL_1_OFF_INBOUND_i is '1'.
            }
        }
        register IATU_REGION_CTRL_1_OFF_OUTBOUND_11 @'h1600 {
            bytes 4;
            field TYPE @'h0 {
                bits 5;
                access rw;
                hard_reset 'h0;
                doc {
                    When the address of an outbound TLP is matched to this region, then the TYPE field of the TLP is changed to the value in this register.

Note: This register field is sticky.
                }
            }
            field TC @'h5 {
                bits 3;
                access rw;
                hard_reset 'h0;
                doc {
                    When the address of an outbound TLP is matched to this region, then the TC field of the TLP is changed to the value in this register.

Note: This register field is sticky.
                }
            }
            field TD @'h8 {
                access rw;
                hard_reset 'h0;
                doc {
                    This is a reserved field. Do not use.

Note: This register field is sticky.
                }
            }
            field ATTR @'h9 {
                bits 2;
                access rw;
                hard_reset 'h0;
                doc {
                    When the address of an outbound TLP is matched to this region, then the ATTR field of the TLP is changed to the value in this register.

Note: This register field is sticky.
                }
            }
            field INCREASE_REGION_SIZE @'hd {
                access rw;
                hard_reset 'h0;
                doc {
                    Increase the maximum ATU Region size. When set, the maximum ATU Region size is determined by CX_ATU_MAX_REGION_SIZE. When clear, the maximum ATU Region size is 4 GB (default).

Note: This register field is sticky.
                }
            }
            field CTRL_1_FUNC_NUM @'h14 {
                bits 3;
                access rw;
                hard_reset 'h0;
                doc {
                    Function Number.
 - When the address of an outbound TLP is matched to this region and the FUNC_BYPASS field in the "iATU Control 2 Register" is '0', then the function number used in generating the function part of the requester ID (RID) field of the TLP is taken from this 5-bit register. The value in this register must be 0x0 unless multifunction operation in the controller is enabled (CX_NFUNC > 1).
 - When you are using the AXI Bridge, then this field is swapped before AXI decomposition occurs so that the correct "Max_Read_Request_Size" and "Max_Payload_Size" values are used.

Note: This register field is sticky.
                }
            }
            doc {
                iATU Region Control 1 Register.iATU Region Control 1 Register.
            }
        }
        register IATU_REGION_CTRL_2_OFF_OUTBOUND_11 @'h1604 {
            bytes 4;
            field MSG_CODE @'h0 {
                bits 8;
                access rw;
                hard_reset 'h0;
                doc {
                    MSG TLPs (Message Code). When the address of an outbound TLP is matched to this region, and the translated TLP TYPE field is Msg or MsgD; then the message field of the TLP is changed to the value in this register.

Memory TLPs: (ST;Steering Tag). When the ST field of an outbound TLP is matched to this region, and the translated TLP TYPE field targets memory space; then the ST field of the TLP is changed to the value in this register. Only Valid when the CX_TPH_ENABLE configuration parameter is 1.

Note: This register field is sticky.
                }
            }
            field TAG @'h8 {
                bits 8;
                access rw;
                hard_reset 'h0;
                doc {
                    TAG.

The substituted TAG field (byte 6) in the outgoing TLP header when TAG_SUBSTITUTE_EN is set.

Note: This register field is sticky.
                }
            }
            field TAG_SUBSTITUTE_EN @'h10 {
                access rw;
                hard_reset 'h0;
                doc {
                    TAG Substitute Enable.

When enabled and region address is matched, the iATU substitutes the TAG field of the outbound TLP header with the contents of the TAG field in this register. The expected usage scenario is translation from AXI MWr to Vendor Defined Msg/MsgD.

Note (CX_TPH_ENABLE=1): TAG substitution for MWr will not occur because this field (byte 6) in the TLP header is the ST field. ST substitution can still take place using the MSG_CODE field in IATU_REGION_CTRL_2_OFF_OUTBOUND_i.

Note: This register field is sticky.
                }
            }
            field MSB2BITS_TAG @'h11 {
                bits 2;
                access rw;
                hard_reset 'h0;
                doc {
                    TAG.

Two most significant bits of the substituted TAG field in the outgoing TLP header when TAG_SUBSTITUTE_EN is set. 

Note: This register field is sticky.
                }
            }
            field FUNC_BYPASS @'h13 {
                access rw;
                hard_reset 'h0;
                doc {
                    Function Number Translation Bypass. In this mode, the function number of the translated TLP is taken from your application transmit interface and not from the CTRL_1_FUNC_NUM field of the "iATU Control 1 Register" or the VF_NUMBER field of the "iATU Control 3 Register."

Note: This register field is sticky.
                }
            }
            field SNP @'h14 {
                access rw;
                hard_reset 'h0;
                doc {
                    Serialize Non-Posted Requests. In this mode, when the AXI Bridge is populated, same AXI ID Non-Posted Read/Write Requests are transmitted on the wire if there are no other same ID Non-Posted Requests outstanding.

Note: This register field is sticky.
                }
            }
            field TLP_HEADER_FIELDS_BYPASS @'h15 {
                access rw;
                hard_reset 'h0;
                doc {
                    TLP Header Fields Translation Bypass.  In this mode header fields of the translated TLP is taken from your application transmit interface or, if AMBA is configured,  from the AMBA sideband bus (slv_awmisc_info) and not from the corresponding fields of the IATU_REGION_CTRL_1_OFF_OUTBOUND_i  or IATU_REGION_CTRL_2_OFF_OUTBOUND_i registers. The header fields are
 -	TC
 -	PH
 -	TH
 -	ST
 -	AT
 -	Attr (IDO, RO and NS).
Note: This register field is sticky. 

Note: This register field is sticky.
                }
            }
            field INHIBIT_PAYLOAD @'h16 {
                access rw;
                hard_reset 'h0;
                doc {
                    Inhibit TLP Payload Data for TLP's in Matched Region; assign iATU region to be TLP without data.
When enabled and region address is matched, the iATU marks all TLPs as having no payload data by forcing the TLP header Fmt[1] bit =0, regardless of the application inputs such as slv_wstrb.
 - 1: Fmt[1] =0 so that only TLP type without data is sent. For example, a Msg instead of MsgD will be sent.
 - 0: Fmt[1] =0/1 so that TLPs with or without data can be sent. 
Note: This register field is sticky.
                }
            }
            field HEADER_SUBSTITUTE_EN @'h17 {
                access rw;
                hard_reset 'h0;
                doc {
                    Header Substitute Enable.

When enabled and region address is matched, the iATU fully substitutes bytes 8-11 (for 3 DWORD header) or bytes 12-15 (for 4 DWORD header) of the outbound TLP header with the contents of the LWR_TARGET_RW field in IATU_LWR_TARGET_ADDR_OFF_OUTBOUND_i.
 - 1: LWR_TARGET_RW in the iATU_LWR_TARGET_ADDR_OFF_OUTBOUND_i register is used to fill bytes 8-to-11 (for 3 DWORD header) or bytes 12-to-15 (for 4 DWORD header) of the translated TLP header.
 - 0: LWR_TARGET_RW in the iATU_LWR_TARGET_ADDR_OFF_OUTBOUND_i register forms the new address of the translated region.
Note: This register field is sticky.
                }
            }
            field CFG_SHIFT_MODE @'h1c {
                access rw;
                hard_reset 'h0;
                doc {
                    CFG Shift Mode.

The iATU uses bits [27:12] of the untranslated address (on the XALI0/1/2 interface or AXI slave interface address) to form the BDF number of the outgoing CFG TLP.

This supports the Enhanced Configuration Address Mapping (ECAM) mechanism (Section 7.2.2 of the PCI Express Base 3.1 Specification, revision 1.0) by allowing all outgoing I/O and MEM TLPs (that have been translated to CFG) to be mapped from memory space into any 256 MB region of the PCIe configuration space.

Note: This register field is sticky.
                }
            }
            field INVERT_MODE @'h1d {
                access rw;
                hard_reset 'h0;
                doc {
                    Invert Mode. When set the address matching region is inverted. Therefore, an address match occurs when the untranslated address is in the region outside the defined range (Base Address to Limit Address).

Note: This register field is sticky.
                }
            }
            field REGION_EN @'h1f {
                access rw;
                hard_reset 'h0;
                doc {
                    Region Enable. This bit must be set to '1' for address translation to take place.

Note: This register field is sticky.
                }
            }
            doc {
                iATU Region Control 2 Register.iATU Region Control 2 Register.
            }
        }
        register IATU_LWR_BASE_ADDR_OFF_OUTBOUND_11 @'h1608 {
            bytes 4;
            field LWR_BASE_HW @'h0 {
                bits 12;
                access ro;
                hard_reset 'h0;
                doc {
                    Forms bits [n-1:0] of the start address of the address region to be translated. The start address must be aligned to a CX_ATU_MIN_REGION_SIZE kB boundary, so these bits are always 0.
A write to this location is ignored by the PCIe controller.

n is log2(CX_ATU_MIN_REGION_SIZE)
                }
            }
            field LWR_BASE_RW @'hc {
                bits 20;
                access rw;
                hard_reset 'h0;
                doc {
                    Forms bits [31:n] of the start address of the address region to be translated. 
n is log2(CX_ATU_MIN_REGION_SIZE)

Note: This register field is sticky.
                }
            }
            doc {
                iATU Lower Base Address Register. The CX_ATU_MIN_REGION_SIZE configuration parameter (Value Range: 4 kB, 8 kB, 16 kB, 32 kB, 64 kB defaults to 64 kB) specifies the minimum size of an address translation region. For example, if set to 64 kB; the lower 16 bits of the Base, Limit and Target registers are zero and all address regions are aligned on 64 kB boundaries. More precisely, the lower log2(CX_ATU_MIN_REGION_SIZE) bits are zero.iATU Lower Base Address Register. The CX_ATU_MIN_REGION_SIZE configuration parameter (Value Range: 4 kB, 8 kB, 16 kB, 32 kB, 64 kB defaults to 64 kB) specifies the minimum size of an address translation region. For example, if set to 64 kB; the lower 16 bits of the Base, Limit and Target registers are zero and all address regions are aligned on 64 kB boundaries. More precisely, the lower log2(CX_ATU_MIN_REGION_SIZE) bits are zero.
            }
        }
        register IATU_UPPER_BASE_ADDR_OFF_OUTBOUND_11 @'h160c {
            bytes 4;
            field UPPER_BASE_RW @'h0 {
                bits 32;
                access rw;
                hard_reset 'h0;
                doc {
                    Forms bits [63:32] of the start (and end) address of the address region to be translated. In systems with a 32-bit address space, this register is not used and therefore writing to this register has no effect.

Note: This register field is sticky.
                }
            }
            doc {
                iATU Upper Base Address Register.iATU Upper Base Address Register.
            }
        }
        register IATU_LIMIT_ADDR_OFF_OUTBOUND_11 @'h1610 {
            bytes 4;
            field LIMIT_ADDR_HW @'h0 {
                bits 12;
                access ro;
                hard_reset 'h0;
                doc {
                    Forms lower bits of the end address of the address region to be translated. The end address must be aligned to a CX_ATU_MIN_REGION_SIZE kB boundary, so these bits are always all ones.
A write to this location is ignored by the PCIe controller.
                }
            }
            field LIMIT_ADDR_RW @'hc {
                bits 20;
                access rw;
                hard_reset 'h0;
                doc {
                    Forms upper bits of the end address of the address region to be translated.

Note: This register field is sticky.
                }
            }
            doc {
                iATU Limit Address Register.iATU Limit Address Register.
            }
        }
        register IATU_LWR_TARGET_ADDR_OFF_OUTBOUND_11 @'h1614 {
            bytes 4;
            field LWR_TARGET_RW_OUTBOUND @'h0 {
                bits 32;
                access rw;
                hard_reset 'h0;
                doc {
                    When HEADER_SUBSTITUTE_EN in IATU_REGION_CTRL_2_OFF_OUTBOUND_ is '0' (normal operation):
 - LWR_TARGET_RW[31:n] forms MSB's of the Lower Target part of the new address of the translated region;
 - LWR_TARGET_RW[n-1:0] are not used. (The start address must be aligned to a CX_ATU_MIN_REGION_SIZE kB boundary, so the lower bits of the start address of the new address of the translated region (bits n-1:0) are always '0').
 - n is log2(CX_ATU_MIN_REGION_SIZE).
When HEADER_SUBSTITUTE_EN in IATU_REGION_CTRL_2_OFF_OUTBOUND_i is '1':
 - LWR_TARGET_RW[31:0] forms bytes 8-11 (for 3 dword header) or bytes 12-15 (for 4 dword header) of the outbound TLP header. Usage scenarios include the transmission of Vendor Defined Messages where the controller determines the content of bytes 12 to 15 of the TLP header.
Note: This register field is sticky.
                }
            }
            doc {
                iATU Lower Target Address Register.iATU Lower Target Address Register.
            }
        }
        register IATU_UPPER_TARGET_ADDR_OFF_OUTBOUND_11 @'h1618 {
            bytes 4;
            field UPPER_TARGET_RW @'h0 {
                bits 32;
                access rw;
                hard_reset 'h0;
                doc {
                    Forms bits [63:32] of the start address (Upper Target part) of the new address of the translated region.

Note: This register field is sticky.
                }
            }
            doc {
                iATU Upper Target Address Register.iATU Upper Target Address Register.
            }
        }
        register IATU_UPPR_LIMIT_ADDR_OFF_OUTBOUND_11 @'h1620 {
            bytes 4;
            field UPPR_LIMIT_ADDR_RW @'h0 {
                bits 4;
                access rw;
                hard_reset 'h0;
                doc {
                    Forms the LSB's of the Upper Limit part of the region "end address" to be translated. Only applies to 64-bit systems and when the INCREASE_REGION_SIZE field in IATU_REGION_CTRL_1_OFF_OUTBOUND_i is '1'

Note: This register field is sticky.
                }
            }
            field UPPR_LIMIT_ADDR_HW @'h4 {
                bits 28;
                access ro;
                hard_reset 'h0;
                doc {
                    Forms MSB's of the Upper Limit part of the region "end address" to be translated. Only applies to 64-bit systems and when the INCREASE_REGION_SIZE field in IATU_REGION_CTRL_1_OFF_OUTBOUND_i is '1'. These bits are always '0'.
                }
            }
            doc {
                iATU Upper Limit Address Register. The CX_MAX_ATU_REGION_SIZE configuration parameter (Value Range: 0->32, 8=1TB) specifies the maximum region size of an address translation region. This register is only used when the INCREASE_REGION_SIZE field in IATU_REGION_CTRL_1_OFF_OUTBOUND_i is '1'.iATU Upper Limit Address Register. The CX_MAX_ATU_REGION_SIZE configuration parameter (Value Range: 0->32, 8=1TB) specifies the maximum region size of an address translation region. This register is only used when the INCREASE_REGION_SIZE field in IATU_REGION_CTRL_1_OFF_OUTBOUND_i is '1'.
            }
        }
        register IATU_REGION_CTRL_1_OFF_INBOUND_11 @'h1700 {
            bytes 4;
            field TYPE @'h0 {
                bits 5;
                access rw;
                hard_reset 'h0;
                doc {
                    When the TYPE field of an inbound TLP is matched to this value, then address translation proceeds (when all other enabled field-matches are successful).

Note: This register field is sticky.
                }
            }
            field TC @'h5 {
                bits 3;
                access rw;
                hard_reset 'h0;
                doc {
                    When the TC field of an inbound TLP is matched to this value, then address translation proceeds (when all other enabled field-matches are successful). This check is only performed if the "TC Match Enable" bit of the "iATU Control 2 Register" is set.

Note: This register field is sticky.
                }
            }
            field TD @'h8 {
                access rw;
                hard_reset 'h0;
                doc {
                    When the TD field of an inbound TLP is matched to this value, then address translation proceeds (when all other enabled field-matches are successful). This check is only performed if the "TD Match Enable" bit of the "iATU Control 2 Register" is set.

Note: This register field is sticky.
                }
            }
            field ATTR @'h9 {
                bits 2;
                access rw;
                hard_reset 'h0;
                doc {
                    When the ATTR field of an inbound TLP is matched to this value, then address translation proceeds (when all other enabled field-matches are successful). This check is only performed if the "ATTR Match Enable" bit of the "iATU Control 2 Register" is set.

Note: This register field is sticky.
                }
            }
            field INCREASE_REGION_SIZE @'hd {
                access rw;
                hard_reset 'h0;
                doc {
                    Increase the maximum ATU Region size. When set, the maximum ATU Region size is determined by CX_ATU_MAX_REGION_SIZE. When clear, the maximum ATU Region size is 4 GB (default).

Note: This register field is sticky.
                }
            }
            field CTRL_1_FUNC_NUM @'h14 {
                bits 3;
                access rw;
                hard_reset 'h0;
                doc {
                    Function Number.
 - MEM-I/O: When the Address and BAR matching logic in the controller indicate that a MEM-I/O transaction matches a BAR in the function corresponding to this value, then address translation proceeds. This check is only performed if the "Function Number Match Enable" bit of the "iATU Control 2 Register" is set.
 - CFG0/CFG1: When the destination function number as specified in the routing ID of the TLP header matches the function, then address translation proceeds. This check is only performed if the "Function Number Match Enable" bit of the "iATU Control 2 Register" is set.
Note: This register field is sticky.
                }
            }
            doc {
                iATU Region Control 1 Register.iATU Region Control 1 Register.
            }
        }
        register IATU_REGION_CTRL_2_OFF_INBOUND_11 @'h1704 {
            bytes 4;
            field MSG_CODE @'h0 {
                bits 8;
                access rw;
                hard_reset 'h0;
                doc {
                    MSG TLPs: (Message Code). When the TYPE field of an inbound Msg/MsgD TLP is matched to this value, then address translation proceeds (when all other enabled field-matches are successful). This check is only performed if the "Message Code Match Enable" bit of the "iATU Control 2 Register" is set.

Memory TLPs: (ST;Steering Tag). When the ST field of an inbound TLP is matched to this value, then address translation proceeds. This check is only performed if the "ST Match Enable" bit of the "iATU Control2 Register" is set. The setting is independent of the setting of the TH field. Only Valid when the CX_TPH_ENABLE configuration parameter is 1.

Note: This register field is sticky.
                }
            }
            field BAR_NUM @'h8 {
                bits 3;
                access rw;
                hard_reset 'h0;
                doc {
                    BAR Number. When the BAR number of an inbound MEM or IO TLP " that is matched by the normal internal BAR address matching mechanism " is the same as this field, address translation proceeds (when all other enabled field-matches are successful). This check is only performed if the "Match Mode" bit of the "iATU Control 2 Register" is set.
 - 000b - BAR0
 - 001b - BAR1
 - 010b - BAR2
 - 011b - BAR3
 - 100b - BAR4
 - 101b - BAR5
 - 110b - ROM
 - 111b - reserved
 - IO translation would require either 00100b or 00101b in the inbound TLP TYPE; the BAR Number set in the range 000b - 101b and that BAR configured as an IO BAR.
Note: This register field is sticky.
                }
            }
            field MSG_TYPE_MATCH_MODE @'hd {
                access rw;
                hard_reset 'h0;
                doc {
                    Message Type Match Mode.

When enabled, and if single address location translate enable is set, then inbound TLPs of type MSG/MSGd which match the type field of the iatu_region_ctrl_1_OFF_inbound register (=>TYPE[4:3]=2'b10) will be translated.
Message type match mode overrides any value of MATCH_MODE field in this register. Usage scenarios for this are translation of VDM or ATS messages when AXI bridge is configured on client interface.

Note: This register field is sticky.
                }
            }
            field TC_MATCH_EN @'he {
                access rw;
                hard_reset 'h0;
                doc {
                    TC Match Enable. Ensures that a successful TC TLP field comparison match (see TC field of the "iATU Control 1 Register") occurs for address translation to proceed.

Note: This register field is sticky.
                }
            }
            field TD_MATCH_EN @'hf {
                access rw;
                hard_reset 'h0;
                doc {
                    TD Match Enable. Ensures that a successful TD TLP field comparison match (see TD field of the "iATU Control 1 Register") occurs for address translation to proceed.

Note: This register field is sticky.
                }
            }
            field ATTR_MATCH_EN @'h10 {
                access rw;
                hard_reset 'h0;
                doc {
                    ATTR Match Enable. Ensures that a successful ATTR TLP field comparison match (see ATTR field of the "iATU Control 1 Register") occurs for address translation to proceed.

Note: This register field is sticky.
                }
            }
            field FUNC_NUM_MATCH_EN @'h13 {
                access rw;
                hard_reset 'h0;
                doc {
                    Function Number Match Enable. Ensures that a successful Function Number TLP field comparison match (see Function Number field of the "iATU Control 1 Register") occurs (in MEM-I/O and CFG0/CFG1 transactions) for address translation to proceed.

Note: This register field is sticky.
                }
            }
            field MSG_CODE_MATCH_EN @'h15 {
                access rw;
                hard_reset 'h0;
                doc {
                    Message Code Match Enable (Msg TLPS). Ensures that a successful message Code TLP field comparison match (see Message Code field of the "iATU Control 2 Register") occurs (in MSG transactions) for address translation to proceed.

ST Match Enable (Mem TLPs). Ensures that a successful ST TLP field comparison match (see ST field of the "iATU Control 2 Register") occurs (in MEM transactions) for address translation to proceed. Only Valid when the CX_TPH_ENABLE configuration parameter is 1

Note: This register field is sticky.
                }
            }
            field SINGLE_ADDR_LOC_TRANS_EN @'h17 {
                access rw;
                hard_reset 'h0;
                doc {
                    Single Address Location Translate Enable.

When enabled, Rx TLPs can be translated to a single address location as determined by the target address register of the iATU region.
The main usage scenario is translation of Messages (such as Vendor Defined or ATS Messages) to MWr TLPs when the AXI bridge is enabled.

Note: This register field is sticky.
                }
            }
            field RESPONSE_CODE @'h18 {
                bits 2;
                access rw;
                hard_reset 'h0;
                doc {
                    Response Code. Defines the type of response to give for accesses matching this region. This overrides the normal RADM filter response. Note that this feature is not available for any region where Single Address Location Translate is enabled.
 - 00 - Normal RADM filter response is used.
 - 01 - Unsupported request (UR)
 - 10 - Completer abort (CA)
 - 11 - Not used / undefined / reserved.
Note: This register field is sticky.
                }
            }
            field FUZZY_TYPE_MATCH_CODE @'h1b {
                access rw;
                hard_reset 'h0;
                doc {
                    Fuzzy Type Match Mode. When enabled, the iATU relaxes the matching of the TLP TYPE field against the expected TYPE field so that
 - CfgRd0 and CfgRd1 TLPs are seen as identical. Similarly with CfgWr0 and CfgWr1.
 - MWr, MRd and MRdLk TLPs are seen as identical
 - The Routing field of Msg/MsgD TLPs is ignored
 - FetchAdd, Swap and CAS are seen as identical.
For example, CFG0 in the TYPE field in the "iATU Control 1 Register" matches against an inbound CfgRd0, CfgRd1, CfgWr0 or CfgWr1 TLP.

Note: This register field is sticky.
                }
            }
            field CFG_SHIFT_MODE @'h1c {
                access rw;
                hard_reset 'h0;
                doc {
                    CFG Shift Mode. This is useful for CFG transactions where the PCIe configuration mechanism maps bits [27:12] of the address to the bus/device and function number. This allows a CFG configuration space to be located in any 256MB window of your application memory space using a 28-bit effective address. Shifts bits [31:16] of the untranslated address to form bits [27:12] of the translated address.

Note: This register field is sticky.
                }
            }
            field INVERT_MODE @'h1d {
                access rw;
                hard_reset 'h0;
                doc {
                    Invert Mode. When set the address matching region is inverted. Therefore, an address match occurs when the untranslated address is in the region outside the defined range (Base Address to Limit Address).

Note: This register field is sticky.
                }
            }
            field MATCH_MODE @'h1e {
                access rw;
                hard_reset 'h0;
                doc {
                    Match Mode. Determines Inbound matching mode for TLPs. The mode depends on the type of TLP that is received as follows:

 For MEM-I/O TLPs, this field is interpreted as follows:
 - 0: Address Match Mode. The iATU operates using addresses as in the outbound direction. The Region Base and Limit Registers must be setup.
 - 1:BAR Match Mode. BAR matching is used. The "BAR Number" field is relevant. Not used for RC.
For CFG0 TLPs, this field is interpreted as follows:
 - 0: Routing ID Match Mode. The iATU interprets the Routing ID (Bytes 8 to 11 of TLP header) as an address. This corresponds to the upper 16 bits of the address in MEM-I/O transactions. The Routing ID of the TLP must be within the base and limit of the iATU region for matching to proceed.
 - 1: Accept Mode. The iATU accepts all CFG0 transactions as address matches. The routing ID in the CFG0 TLP is ignored. This is useful as all received CFG0 TLPs should be processed regardless of the Bus number.
For MSG/MSGD TLPs, this field is interpreted as follows:
 - 0: Address Match Mode. The iATU treats the third dword and fourth dword of the inbound MSG/MSGD TLP as an address and it is matched against the Region Base and Limit Registers.
 - 1: Vendor ID Match Mode. This mode is relevant for ID-routed Vendor Defined Messages. The iATU ignores the Routing ID (Bus, Device, Function) in bits [31:16] of the third dword of the TLP header, but matches against the Vendor ID in bits [15:0] of the third dword of the TLP header. Bits [15:0] of the Region Upper Base register should be programmed with the required Vendor ID. The lower Base and Limit Register should be programmed to translate TLPs based on vendor specific information in the fourth dword of the TLP header.
 -	If SINGLE_ADDRESS_LOCATION_TRANSLATE_EN = 1 AND MSG_TYPE_MATCH_MODE = 1, then Match Mode is ignored.
Note: This register field is sticky.
                }
            }
            field REGION_EN @'h1f {
                access rw;
                hard_reset 'h0;
                doc {
                    Region Enable. This bit must be set to '1' for address translation to take place.

Note: This register field is sticky.
                }
            }
            doc {
                iATU Region Control 2 Register.iATU Region Control 2 Register.
            }
        }
        register IATU_LWR_BASE_ADDR_OFF_INBOUND_11 @'h1708 {
            bytes 4;
            field LWR_BASE_HW @'h0 {
                bits 12;
                access ro;
                hard_reset 'h0;
                doc {
                    Forms bits [n-1:0] of the start address of the address region to be translated. The start address must be aligned to a CX_ATU_MIN_REGION_SIZE kB boundary, so these bits are always 0.
A write to this location is ignored by the PCIe controller.

n is log2(CX_ATU_MIN_REGION_SIZE)
                }
            }
            field LWR_BASE_RW @'hc {
                bits 20;
                access rw;
                hard_reset 'h0;
                doc {
                    Forms bits [31:n] of the start address of the address region to be translated. 
n is log2(CX_ATU_MIN_REGION_SIZE)

Note: This register field is sticky.
                }
            }
            doc {
                iATU Lower Base Address Register. The CX_ATU_MIN_REGION_SIZE configuration parameter (Value Range: 4 kB, 8 kB, 16 kB, 32 kB, 64 kB defaults to 64 kB) specifies the minimum size of an address translation region. For example, if set to 64 kB; the lower 16 bits of the Base, Limit and Target registers are zero and all address regions are aligned on 64 kB boundaries. More precisely, the lower log2(CX_ATU_MIN_REGION_SIZE) bits are zero.iATU Lower Base Address Register. The CX_ATU_MIN_REGION_SIZE configuration parameter (Value Range: 4 kB, 8 kB, 16 kB, 32 kB, 64 kB defaults to 64 kB) specifies the minimum size of an address translation region. For example, if set to 64 kB; the lower 16 bits of the Base, Limit and Target registers are zero and all address regions are aligned on 64 kB boundaries. More precisely, the lower log2(CX_ATU_MIN_REGION_SIZE) bits are zero.
            }
        }
        register IATU_UPPER_BASE_ADDR_OFF_INBOUND_11 @'h170c {
            bytes 4;
            field UPPER_BASE_RW @'h0 {
                bits 32;
                access rw;
                hard_reset 'h0;
                doc {
                    Forms bits [63:32] of the start (and end) address of the address region to be translated.

Note: This register field is sticky.
                }
            }
            doc {
                iATU Upper Base Address Register.iATU Upper Base Address Register.
            }
        }
        register IATU_LIMIT_ADDR_OFF_INBOUND_11 @'h1710 {
            bytes 4;
            field LIMIT_ADDR_HW @'h0 {
                bits 12;
                access ro;
                hard_reset 'h0;
                doc {
                    Forms lower bits of the end address of the address region to be translated. The end address must be aligned to a CX_ATU_MIN_REGION_SIZE kB boundary, so these bits are always all ones.
A write to this location is ignored by the PCIe controller.
                }
            }
            field LIMIT_ADDR_RW @'hc {
                bits 20;
                access rw;
                hard_reset 'h0;
                doc {
                    Forms upper bits of the end address of the address region to be translated.

Note: This register field is sticky.
                }
            }
            doc {
                iATU Limit Address Register.iATU Limit Address Register.
            }
        }
        register IATU_LWR_TARGET_ADDR_OFF_INBOUND_11 @'h1714 {
            bytes 4;
            field LWR_TARGET_HW @'h0 {
                bits 12;
                access ro;
                hard_reset 'h0;
                doc {
                    Forms the LSB's of the Lower Target part of the new address of the translated region. The start address must be aligned to a CX_ATU_MIN_REGION_SIZE kB boundary (in address match mode); and to the Bar size boundary (in BAR match mode) so that these bits are always '0'. If the BAR is smaller than the iATU region size, then the iATU target address must align to the iATU region size; otherwise it must align to the BAR size.

A write to this location is ignored by the PCIe controller.
 - Field size depends on log2(CX_ATU_MIN_REGION_SIZE) in address match mode.
 - Field size depends on log2(BAR_MASK+1) in BAR match mode.
                }
            }
            field LWR_TARGET_RW @'hc {
                bits 20;
                access rw;
                hard_reset 'h0;
                doc {
                    Forms MSB's of the Lower Target part of the new address of the translated region. These bits are always '0'.
 - Field size depends on log2(CX_ATU_MIN_REGION_SIZE) in address match mode.
 - Field size depends on log2(BAR_MASK+1) in BAR match mode.
Note: This register field is sticky.
                }
            }
            doc {
                iATU Lower Target Address Register.iATU Lower Target Address Register.
            }
        }
        register IATU_UPPER_TARGET_ADDR_OFF_INBOUND_11 @'h1718 {
            bytes 4;
            field UPPER_TARGET_RW @'h0 {
                bits 32;
                access rw;
                hard_reset 'h0;
                doc {
                    Forms bits [63:32] of the start address (Upper Target part) of the new address of the translated region. In systems with a 32-bit address space, this register is not used and therefore writing to this register has no effect.

Note: This register field is sticky.
                }
            }
            doc {
                iATU Upper Target Address Register.iATU Upper Target Address Register.
            }
        }
        register IATU_UPPR_LIMIT_ADDR_OFF_INBOUND_11 @'h1720 {
            bytes 4;
            field UPPR_LIMIT_ADDR_RW @'h0 {
                bits 4;
                access rw;
                hard_reset 'h0;
                doc {
                    Forms the LSB's of the Upper Limit part of the region "end address" to be translated. Only applies to 64-bit systems and when the INCREASE_REGION_SIZE field in IATU_REGION_CTRL_1_OFF_INBOUND_i is '1'

Note: This register field is sticky.
                }
            }
            field UPPR_LIMIT_ADDR_HW @'h4 {
                bits 28;
                access ro;
                hard_reset 'h0;
                doc {
                    Forms MSB's of the Upper Limit part of the region "end address" to be translated. Only applies to 64-bit systems and when the INCREASE_REGION_SIZE field in IATU_REGION_CTRL_1_OFF_INBOUND_i is '1'. These bits are always '0'.
                }
            }
            doc {
                iATU Upper Limit Address Register. The CX_MAX_ATU_REGION_SIZE configuration parameter (Value Range: 0->32, 8=1TB) specifies the maximum region size of an address translation region. This register is only used when the INCREASE_REGION_SIZE field in IATU_REGION_CTRL_1_OFF_INBOUND_i is '1'.iATU Upper Limit Address Register. The CX_MAX_ATU_REGION_SIZE configuration parameter (Value Range: 0->32, 8=1TB) specifies the maximum region size of an address translation region. This register is only used when the INCREASE_REGION_SIZE field in IATU_REGION_CTRL_1_OFF_INBOUND_i is '1'.
            }
        }
        register IATU_REGION_CTRL_1_OFF_OUTBOUND_12 @'h1800 {
            bytes 4;
            field TYPE @'h0 {
                bits 5;
                access rw;
                hard_reset 'h0;
                doc {
                    When the address of an outbound TLP is matched to this region, then the TYPE field of the TLP is changed to the value in this register.

Note: This register field is sticky.
                }
            }
            field TC @'h5 {
                bits 3;
                access rw;
                hard_reset 'h0;
                doc {
                    When the address of an outbound TLP is matched to this region, then the TC field of the TLP is changed to the value in this register.

Note: This register field is sticky.
                }
            }
            field TD @'h8 {
                access rw;
                hard_reset 'h0;
                doc {
                    This is a reserved field. Do not use.

Note: This register field is sticky.
                }
            }
            field ATTR @'h9 {
                bits 2;
                access rw;
                hard_reset 'h0;
                doc {
                    When the address of an outbound TLP is matched to this region, then the ATTR field of the TLP is changed to the value in this register.

Note: This register field is sticky.
                }
            }
            field INCREASE_REGION_SIZE @'hd {
                access rw;
                hard_reset 'h0;
                doc {
                    Increase the maximum ATU Region size. When set, the maximum ATU Region size is determined by CX_ATU_MAX_REGION_SIZE. When clear, the maximum ATU Region size is 4 GB (default).

Note: This register field is sticky.
                }
            }
            field CTRL_1_FUNC_NUM @'h14 {
                bits 3;
                access rw;
                hard_reset 'h0;
                doc {
                    Function Number.
 - When the address of an outbound TLP is matched to this region and the FUNC_BYPASS field in the "iATU Control 2 Register" is '0', then the function number used in generating the function part of the requester ID (RID) field of the TLP is taken from this 5-bit register. The value in this register must be 0x0 unless multifunction operation in the controller is enabled (CX_NFUNC > 1).
 - When you are using the AXI Bridge, then this field is swapped before AXI decomposition occurs so that the correct "Max_Read_Request_Size" and "Max_Payload_Size" values are used.

Note: This register field is sticky.
                }
            }
            doc {
                iATU Region Control 1 Register.iATU Region Control 1 Register.
            }
        }
        register IATU_REGION_CTRL_2_OFF_OUTBOUND_12 @'h1804 {
            bytes 4;
            field MSG_CODE @'h0 {
                bits 8;
                access rw;
                hard_reset 'h0;
                doc {
                    MSG TLPs (Message Code). When the address of an outbound TLP is matched to this region, and the translated TLP TYPE field is Msg or MsgD; then the message field of the TLP is changed to the value in this register.

Memory TLPs: (ST;Steering Tag). When the ST field of an outbound TLP is matched to this region, and the translated TLP TYPE field targets memory space; then the ST field of the TLP is changed to the value in this register. Only Valid when the CX_TPH_ENABLE configuration parameter is 1.

Note: This register field is sticky.
                }
            }
            field TAG @'h8 {
                bits 8;
                access rw;
                hard_reset 'h0;
                doc {
                    TAG.

The substituted TAG field (byte 6) in the outgoing TLP header when TAG_SUBSTITUTE_EN is set.

Note: This register field is sticky.
                }
            }
            field TAG_SUBSTITUTE_EN @'h10 {
                access rw;
                hard_reset 'h0;
                doc {
                    TAG Substitute Enable.

When enabled and region address is matched, the iATU substitutes the TAG field of the outbound TLP header with the contents of the TAG field in this register. The expected usage scenario is translation from AXI MWr to Vendor Defined Msg/MsgD.

Note (CX_TPH_ENABLE=1): TAG substitution for MWr will not occur because this field (byte 6) in the TLP header is the ST field. ST substitution can still take place using the MSG_CODE field in IATU_REGION_CTRL_2_OFF_OUTBOUND_i.

Note: This register field is sticky.
                }
            }
            field MSB2BITS_TAG @'h11 {
                bits 2;
                access rw;
                hard_reset 'h0;
                doc {
                    TAG.

Two most significant bits of the substituted TAG field in the outgoing TLP header when TAG_SUBSTITUTE_EN is set. 

Note: This register field is sticky.
                }
            }
            field FUNC_BYPASS @'h13 {
                access rw;
                hard_reset 'h0;
                doc {
                    Function Number Translation Bypass. In this mode, the function number of the translated TLP is taken from your application transmit interface and not from the CTRL_1_FUNC_NUM field of the "iATU Control 1 Register" or the VF_NUMBER field of the "iATU Control 3 Register."

Note: This register field is sticky.
                }
            }
            field SNP @'h14 {
                access rw;
                hard_reset 'h0;
                doc {
                    Serialize Non-Posted Requests. In this mode, when the AXI Bridge is populated, same AXI ID Non-Posted Read/Write Requests are transmitted on the wire if there are no other same ID Non-Posted Requests outstanding.

Note: This register field is sticky.
                }
            }
            field TLP_HEADER_FIELDS_BYPASS @'h15 {
                access rw;
                hard_reset 'h0;
                doc {
                    TLP Header Fields Translation Bypass.  In this mode header fields of the translated TLP is taken from your application transmit interface or, if AMBA is configured,  from the AMBA sideband bus (slv_awmisc_info) and not from the corresponding fields of the IATU_REGION_CTRL_1_OFF_OUTBOUND_i  or IATU_REGION_CTRL_2_OFF_OUTBOUND_i registers. The header fields are
 -	TC
 -	PH
 -	TH
 -	ST
 -	AT
 -	Attr (IDO, RO and NS).
Note: This register field is sticky. 

Note: This register field is sticky.
                }
            }
            field INHIBIT_PAYLOAD @'h16 {
                access rw;
                hard_reset 'h0;
                doc {
                    Inhibit TLP Payload Data for TLP's in Matched Region; assign iATU region to be TLP without data.
When enabled and region address is matched, the iATU marks all TLPs as having no payload data by forcing the TLP header Fmt[1] bit =0, regardless of the application inputs such as slv_wstrb.
 - 1: Fmt[1] =0 so that only TLP type without data is sent. For example, a Msg instead of MsgD will be sent.
 - 0: Fmt[1] =0/1 so that TLPs with or without data can be sent. 
Note: This register field is sticky.
                }
            }
            field HEADER_SUBSTITUTE_EN @'h17 {
                access rw;
                hard_reset 'h0;
                doc {
                    Header Substitute Enable.

When enabled and region address is matched, the iATU fully substitutes bytes 8-11 (for 3 DWORD header) or bytes 12-15 (for 4 DWORD header) of the outbound TLP header with the contents of the LWR_TARGET_RW field in IATU_LWR_TARGET_ADDR_OFF_OUTBOUND_i.
 - 1: LWR_TARGET_RW in the iATU_LWR_TARGET_ADDR_OFF_OUTBOUND_i register is used to fill bytes 8-to-11 (for 3 DWORD header) or bytes 12-to-15 (for 4 DWORD header) of the translated TLP header.
 - 0: LWR_TARGET_RW in the iATU_LWR_TARGET_ADDR_OFF_OUTBOUND_i register forms the new address of the translated region.
Note: This register field is sticky.
                }
            }
            field CFG_SHIFT_MODE @'h1c {
                access rw;
                hard_reset 'h0;
                doc {
                    CFG Shift Mode.

The iATU uses bits [27:12] of the untranslated address (on the XALI0/1/2 interface or AXI slave interface address) to form the BDF number of the outgoing CFG TLP.

This supports the Enhanced Configuration Address Mapping (ECAM) mechanism (Section 7.2.2 of the PCI Express Base 3.1 Specification, revision 1.0) by allowing all outgoing I/O and MEM TLPs (that have been translated to CFG) to be mapped from memory space into any 256 MB region of the PCIe configuration space.

Note: This register field is sticky.
                }
            }
            field INVERT_MODE @'h1d {
                access rw;
                hard_reset 'h0;
                doc {
                    Invert Mode. When set the address matching region is inverted. Therefore, an address match occurs when the untranslated address is in the region outside the defined range (Base Address to Limit Address).

Note: This register field is sticky.
                }
            }
            field REGION_EN @'h1f {
                access rw;
                hard_reset 'h0;
                doc {
                    Region Enable. This bit must be set to '1' for address translation to take place.

Note: This register field is sticky.
                }
            }
            doc {
                iATU Region Control 2 Register.iATU Region Control 2 Register.
            }
        }
        register IATU_LWR_BASE_ADDR_OFF_OUTBOUND_12 @'h1808 {
            bytes 4;
            field LWR_BASE_HW @'h0 {
                bits 12;
                access ro;
                hard_reset 'h0;
                doc {
                    Forms bits [n-1:0] of the start address of the address region to be translated. The start address must be aligned to a CX_ATU_MIN_REGION_SIZE kB boundary, so these bits are always 0.
A write to this location is ignored by the PCIe controller.

n is log2(CX_ATU_MIN_REGION_SIZE)
                }
            }
            field LWR_BASE_RW @'hc {
                bits 20;
                access rw;
                hard_reset 'h0;
                doc {
                    Forms bits [31:n] of the start address of the address region to be translated. 
n is log2(CX_ATU_MIN_REGION_SIZE)

Note: This register field is sticky.
                }
            }
            doc {
                iATU Lower Base Address Register. The CX_ATU_MIN_REGION_SIZE configuration parameter (Value Range: 4 kB, 8 kB, 16 kB, 32 kB, 64 kB defaults to 64 kB) specifies the minimum size of an address translation region. For example, if set to 64 kB; the lower 16 bits of the Base, Limit and Target registers are zero and all address regions are aligned on 64 kB boundaries. More precisely, the lower log2(CX_ATU_MIN_REGION_SIZE) bits are zero.iATU Lower Base Address Register. The CX_ATU_MIN_REGION_SIZE configuration parameter (Value Range: 4 kB, 8 kB, 16 kB, 32 kB, 64 kB defaults to 64 kB) specifies the minimum size of an address translation region. For example, if set to 64 kB; the lower 16 bits of the Base, Limit and Target registers are zero and all address regions are aligned on 64 kB boundaries. More precisely, the lower log2(CX_ATU_MIN_REGION_SIZE) bits are zero.
            }
        }
        register IATU_UPPER_BASE_ADDR_OFF_OUTBOUND_12 @'h180c {
            bytes 4;
            field UPPER_BASE_RW @'h0 {
                bits 32;
                access rw;
                hard_reset 'h0;
                doc {
                    Forms bits [63:32] of the start (and end) address of the address region to be translated. In systems with a 32-bit address space, this register is not used and therefore writing to this register has no effect.

Note: This register field is sticky.
                }
            }
            doc {
                iATU Upper Base Address Register.iATU Upper Base Address Register.
            }
        }
        register IATU_LIMIT_ADDR_OFF_OUTBOUND_12 @'h1810 {
            bytes 4;
            field LIMIT_ADDR_HW @'h0 {
                bits 12;
                access ro;
                hard_reset 'h0;
                doc {
                    Forms lower bits of the end address of the address region to be translated. The end address must be aligned to a CX_ATU_MIN_REGION_SIZE kB boundary, so these bits are always all ones.
A write to this location is ignored by the PCIe controller.
                }
            }
            field LIMIT_ADDR_RW @'hc {
                bits 20;
                access rw;
                hard_reset 'h0;
                doc {
                    Forms upper bits of the end address of the address region to be translated.

Note: This register field is sticky.
                }
            }
            doc {
                iATU Limit Address Register.iATU Limit Address Register.
            }
        }
        register IATU_LWR_TARGET_ADDR_OFF_OUTBOUND_12 @'h1814 {
            bytes 4;
            field LWR_TARGET_RW_OUTBOUND @'h0 {
                bits 32;
                access rw;
                hard_reset 'h0;
                doc {
                    When HEADER_SUBSTITUTE_EN in IATU_REGION_CTRL_2_OFF_OUTBOUND_ is '0' (normal operation):
 - LWR_TARGET_RW[31:n] forms MSB's of the Lower Target part of the new address of the translated region;
 - LWR_TARGET_RW[n-1:0] are not used. (The start address must be aligned to a CX_ATU_MIN_REGION_SIZE kB boundary, so the lower bits of the start address of the new address of the translated region (bits n-1:0) are always '0').
 - n is log2(CX_ATU_MIN_REGION_SIZE).
When HEADER_SUBSTITUTE_EN in IATU_REGION_CTRL_2_OFF_OUTBOUND_i is '1':
 - LWR_TARGET_RW[31:0] forms bytes 8-11 (for 3 dword header) or bytes 12-15 (for 4 dword header) of the outbound TLP header. Usage scenarios include the transmission of Vendor Defined Messages where the controller determines the content of bytes 12 to 15 of the TLP header.
Note: This register field is sticky.
                }
            }
            doc {
                iATU Lower Target Address Register.iATU Lower Target Address Register.
            }
        }
        register IATU_UPPER_TARGET_ADDR_OFF_OUTBOUND_12 @'h1818 {
            bytes 4;
            field UPPER_TARGET_RW @'h0 {
                bits 32;
                access rw;
                hard_reset 'h0;
                doc {
                    Forms bits [63:32] of the start address (Upper Target part) of the new address of the translated region.

Note: This register field is sticky.
                }
            }
            doc {
                iATU Upper Target Address Register.iATU Upper Target Address Register.
            }
        }
        register IATU_UPPR_LIMIT_ADDR_OFF_OUTBOUND_12 @'h1820 {
            bytes 4;
            field UPPR_LIMIT_ADDR_RW @'h0 {
                bits 4;
                access rw;
                hard_reset 'h0;
                doc {
                    Forms the LSB's of the Upper Limit part of the region "end address" to be translated. Only applies to 64-bit systems and when the INCREASE_REGION_SIZE field in IATU_REGION_CTRL_1_OFF_OUTBOUND_i is '1'

Note: This register field is sticky.
                }
            }
            field UPPR_LIMIT_ADDR_HW @'h4 {
                bits 28;
                access ro;
                hard_reset 'h0;
                doc {
                    Forms MSB's of the Upper Limit part of the region "end address" to be translated. Only applies to 64-bit systems and when the INCREASE_REGION_SIZE field in IATU_REGION_CTRL_1_OFF_OUTBOUND_i is '1'. These bits are always '0'.
                }
            }
            doc {
                iATU Upper Limit Address Register. The CX_MAX_ATU_REGION_SIZE configuration parameter (Value Range: 0->32, 8=1TB) specifies the maximum region size of an address translation region. This register is only used when the INCREASE_REGION_SIZE field in IATU_REGION_CTRL_1_OFF_OUTBOUND_i is '1'.iATU Upper Limit Address Register. The CX_MAX_ATU_REGION_SIZE configuration parameter (Value Range: 0->32, 8=1TB) specifies the maximum region size of an address translation region. This register is only used when the INCREASE_REGION_SIZE field in IATU_REGION_CTRL_1_OFF_OUTBOUND_i is '1'.
            }
        }
        register IATU_REGION_CTRL_1_OFF_INBOUND_12 @'h1900 {
            bytes 4;
            field TYPE @'h0 {
                bits 5;
                access rw;
                hard_reset 'h0;
                doc {
                    When the TYPE field of an inbound TLP is matched to this value, then address translation proceeds (when all other enabled field-matches are successful).

Note: This register field is sticky.
                }
            }
            field TC @'h5 {
                bits 3;
                access rw;
                hard_reset 'h0;
                doc {
                    When the TC field of an inbound TLP is matched to this value, then address translation proceeds (when all other enabled field-matches are successful). This check is only performed if the "TC Match Enable" bit of the "iATU Control 2 Register" is set.

Note: This register field is sticky.
                }
            }
            field TD @'h8 {
                access rw;
                hard_reset 'h0;
                doc {
                    When the TD field of an inbound TLP is matched to this value, then address translation proceeds (when all other enabled field-matches are successful). This check is only performed if the "TD Match Enable" bit of the "iATU Control 2 Register" is set.

Note: This register field is sticky.
                }
            }
            field ATTR @'h9 {
                bits 2;
                access rw;
                hard_reset 'h0;
                doc {
                    When the ATTR field of an inbound TLP is matched to this value, then address translation proceeds (when all other enabled field-matches are successful). This check is only performed if the "ATTR Match Enable" bit of the "iATU Control 2 Register" is set.

Note: This register field is sticky.
                }
            }
            field INCREASE_REGION_SIZE @'hd {
                access rw;
                hard_reset 'h0;
                doc {
                    Increase the maximum ATU Region size. When set, the maximum ATU Region size is determined by CX_ATU_MAX_REGION_SIZE. When clear, the maximum ATU Region size is 4 GB (default).

Note: This register field is sticky.
                }
            }
            field CTRL_1_FUNC_NUM @'h14 {
                bits 3;
                access rw;
                hard_reset 'h0;
                doc {
                    Function Number.
 - MEM-I/O: When the Address and BAR matching logic in the controller indicate that a MEM-I/O transaction matches a BAR in the function corresponding to this value, then address translation proceeds. This check is only performed if the "Function Number Match Enable" bit of the "iATU Control 2 Register" is set.
 - CFG0/CFG1: When the destination function number as specified in the routing ID of the TLP header matches the function, then address translation proceeds. This check is only performed if the "Function Number Match Enable" bit of the "iATU Control 2 Register" is set.
Note: This register field is sticky.
                }
            }
            doc {
                iATU Region Control 1 Register.iATU Region Control 1 Register.
            }
        }
        register IATU_REGION_CTRL_2_OFF_INBOUND_12 @'h1904 {
            bytes 4;
            field MSG_CODE @'h0 {
                bits 8;
                access rw;
                hard_reset 'h0;
                doc {
                    MSG TLPs: (Message Code). When the TYPE field of an inbound Msg/MsgD TLP is matched to this value, then address translation proceeds (when all other enabled field-matches are successful). This check is only performed if the "Message Code Match Enable" bit of the "iATU Control 2 Register" is set.

Memory TLPs: (ST;Steering Tag). When the ST field of an inbound TLP is matched to this value, then address translation proceeds. This check is only performed if the "ST Match Enable" bit of the "iATU Control2 Register" is set. The setting is independent of the setting of the TH field. Only Valid when the CX_TPH_ENABLE configuration parameter is 1.

Note: This register field is sticky.
                }
            }
            field BAR_NUM @'h8 {
                bits 3;
                access rw;
                hard_reset 'h0;
                doc {
                    BAR Number. When the BAR number of an inbound MEM or IO TLP " that is matched by the normal internal BAR address matching mechanism " is the same as this field, address translation proceeds (when all other enabled field-matches are successful). This check is only performed if the "Match Mode" bit of the "iATU Control 2 Register" is set.
 - 000b - BAR0
 - 001b - BAR1
 - 010b - BAR2
 - 011b - BAR3
 - 100b - BAR4
 - 101b - BAR5
 - 110b - ROM
 - 111b - reserved
 - IO translation would require either 00100b or 00101b in the inbound TLP TYPE; the BAR Number set in the range 000b - 101b and that BAR configured as an IO BAR.
Note: This register field is sticky.
                }
            }
            field MSG_TYPE_MATCH_MODE @'hd {
                access rw;
                hard_reset 'h0;
                doc {
                    Message Type Match Mode.

When enabled, and if single address location translate enable is set, then inbound TLPs of type MSG/MSGd which match the type field of the iatu_region_ctrl_1_OFF_inbound register (=>TYPE[4:3]=2'b10) will be translated.
Message type match mode overrides any value of MATCH_MODE field in this register. Usage scenarios for this are translation of VDM or ATS messages when AXI bridge is configured on client interface.

Note: This register field is sticky.
                }
            }
            field TC_MATCH_EN @'he {
                access rw;
                hard_reset 'h0;
                doc {
                    TC Match Enable. Ensures that a successful TC TLP field comparison match (see TC field of the "iATU Control 1 Register") occurs for address translation to proceed.

Note: This register field is sticky.
                }
            }
            field TD_MATCH_EN @'hf {
                access rw;
                hard_reset 'h0;
                doc {
                    TD Match Enable. Ensures that a successful TD TLP field comparison match (see TD field of the "iATU Control 1 Register") occurs for address translation to proceed.

Note: This register field is sticky.
                }
            }
            field ATTR_MATCH_EN @'h10 {
                access rw;
                hard_reset 'h0;
                doc {
                    ATTR Match Enable. Ensures that a successful ATTR TLP field comparison match (see ATTR field of the "iATU Control 1 Register") occurs for address translation to proceed.

Note: This register field is sticky.
                }
            }
            field FUNC_NUM_MATCH_EN @'h13 {
                access rw;
                hard_reset 'h0;
                doc {
                    Function Number Match Enable. Ensures that a successful Function Number TLP field comparison match (see Function Number field of the "iATU Control 1 Register") occurs (in MEM-I/O and CFG0/CFG1 transactions) for address translation to proceed.

Note: This register field is sticky.
                }
            }
            field MSG_CODE_MATCH_EN @'h15 {
                access rw;
                hard_reset 'h0;
                doc {
                    Message Code Match Enable (Msg TLPS). Ensures that a successful message Code TLP field comparison match (see Message Code field of the "iATU Control 2 Register") occurs (in MSG transactions) for address translation to proceed.

ST Match Enable (Mem TLPs). Ensures that a successful ST TLP field comparison match (see ST field of the "iATU Control 2 Register") occurs (in MEM transactions) for address translation to proceed. Only Valid when the CX_TPH_ENABLE configuration parameter is 1

Note: This register field is sticky.
                }
            }
            field SINGLE_ADDR_LOC_TRANS_EN @'h17 {
                access rw;
                hard_reset 'h0;
                doc {
                    Single Address Location Translate Enable.

When enabled, Rx TLPs can be translated to a single address location as determined by the target address register of the iATU region.
The main usage scenario is translation of Messages (such as Vendor Defined or ATS Messages) to MWr TLPs when the AXI bridge is enabled.

Note: This register field is sticky.
                }
            }
            field RESPONSE_CODE @'h18 {
                bits 2;
                access rw;
                hard_reset 'h0;
                doc {
                    Response Code. Defines the type of response to give for accesses matching this region. This overrides the normal RADM filter response. Note that this feature is not available for any region where Single Address Location Translate is enabled.
 - 00 - Normal RADM filter response is used.
 - 01 - Unsupported request (UR)
 - 10 - Completer abort (CA)
 - 11 - Not used / undefined / reserved.
Note: This register field is sticky.
                }
            }
            field FUZZY_TYPE_MATCH_CODE @'h1b {
                access rw;
                hard_reset 'h0;
                doc {
                    Fuzzy Type Match Mode. When enabled, the iATU relaxes the matching of the TLP TYPE field against the expected TYPE field so that
 - CfgRd0 and CfgRd1 TLPs are seen as identical. Similarly with CfgWr0 and CfgWr1.
 - MWr, MRd and MRdLk TLPs are seen as identical
 - The Routing field of Msg/MsgD TLPs is ignored
 - FetchAdd, Swap and CAS are seen as identical.
For example, CFG0 in the TYPE field in the "iATU Control 1 Register" matches against an inbound CfgRd0, CfgRd1, CfgWr0 or CfgWr1 TLP.

Note: This register field is sticky.
                }
            }
            field CFG_SHIFT_MODE @'h1c {
                access rw;
                hard_reset 'h0;
                doc {
                    CFG Shift Mode. This is useful for CFG transactions where the PCIe configuration mechanism maps bits [27:12] of the address to the bus/device and function number. This allows a CFG configuration space to be located in any 256MB window of your application memory space using a 28-bit effective address. Shifts bits [31:16] of the untranslated address to form bits [27:12] of the translated address.

Note: This register field is sticky.
                }
            }
            field INVERT_MODE @'h1d {
                access rw;
                hard_reset 'h0;
                doc {
                    Invert Mode. When set the address matching region is inverted. Therefore, an address match occurs when the untranslated address is in the region outside the defined range (Base Address to Limit Address).

Note: This register field is sticky.
                }
            }
            field MATCH_MODE @'h1e {
                access rw;
                hard_reset 'h0;
                doc {
                    Match Mode. Determines Inbound matching mode for TLPs. The mode depends on the type of TLP that is received as follows:

 For MEM-I/O TLPs, this field is interpreted as follows:
 - 0: Address Match Mode. The iATU operates using addresses as in the outbound direction. The Region Base and Limit Registers must be setup.
 - 1:BAR Match Mode. BAR matching is used. The "BAR Number" field is relevant. Not used for RC.
For CFG0 TLPs, this field is interpreted as follows:
 - 0: Routing ID Match Mode. The iATU interprets the Routing ID (Bytes 8 to 11 of TLP header) as an address. This corresponds to the upper 16 bits of the address in MEM-I/O transactions. The Routing ID of the TLP must be within the base and limit of the iATU region for matching to proceed.
 - 1: Accept Mode. The iATU accepts all CFG0 transactions as address matches. The routing ID in the CFG0 TLP is ignored. This is useful as all received CFG0 TLPs should be processed regardless of the Bus number.
For MSG/MSGD TLPs, this field is interpreted as follows:
 - 0: Address Match Mode. The iATU treats the third dword and fourth dword of the inbound MSG/MSGD TLP as an address and it is matched against the Region Base and Limit Registers.
 - 1: Vendor ID Match Mode. This mode is relevant for ID-routed Vendor Defined Messages. The iATU ignores the Routing ID (Bus, Device, Function) in bits [31:16] of the third dword of the TLP header, but matches against the Vendor ID in bits [15:0] of the third dword of the TLP header. Bits [15:0] of the Region Upper Base register should be programmed with the required Vendor ID. The lower Base and Limit Register should be programmed to translate TLPs based on vendor specific information in the fourth dword of the TLP header.
 -	If SINGLE_ADDRESS_LOCATION_TRANSLATE_EN = 1 AND MSG_TYPE_MATCH_MODE = 1, then Match Mode is ignored.
Note: This register field is sticky.
                }
            }
            field REGION_EN @'h1f {
                access rw;
                hard_reset 'h0;
                doc {
                    Region Enable. This bit must be set to '1' for address translation to take place.

Note: This register field is sticky.
                }
            }
            doc {
                iATU Region Control 2 Register.iATU Region Control 2 Register.
            }
        }
        register IATU_LWR_BASE_ADDR_OFF_INBOUND_12 @'h1908 {
            bytes 4;
            field LWR_BASE_HW @'h0 {
                bits 12;
                access ro;
                hard_reset 'h0;
                doc {
                    Forms bits [n-1:0] of the start address of the address region to be translated. The start address must be aligned to a CX_ATU_MIN_REGION_SIZE kB boundary, so these bits are always 0.
A write to this location is ignored by the PCIe controller.

n is log2(CX_ATU_MIN_REGION_SIZE)
                }
            }
            field LWR_BASE_RW @'hc {
                bits 20;
                access rw;
                hard_reset 'h0;
                doc {
                    Forms bits [31:n] of the start address of the address region to be translated. 
n is log2(CX_ATU_MIN_REGION_SIZE)

Note: This register field is sticky.
                }
            }
            doc {
                iATU Lower Base Address Register. The CX_ATU_MIN_REGION_SIZE configuration parameter (Value Range: 4 kB, 8 kB, 16 kB, 32 kB, 64 kB defaults to 64 kB) specifies the minimum size of an address translation region. For example, if set to 64 kB; the lower 16 bits of the Base, Limit and Target registers are zero and all address regions are aligned on 64 kB boundaries. More precisely, the lower log2(CX_ATU_MIN_REGION_SIZE) bits are zero.iATU Lower Base Address Register. The CX_ATU_MIN_REGION_SIZE configuration parameter (Value Range: 4 kB, 8 kB, 16 kB, 32 kB, 64 kB defaults to 64 kB) specifies the minimum size of an address translation region. For example, if set to 64 kB; the lower 16 bits of the Base, Limit and Target registers are zero and all address regions are aligned on 64 kB boundaries. More precisely, the lower log2(CX_ATU_MIN_REGION_SIZE) bits are zero.
            }
        }
        register IATU_UPPER_BASE_ADDR_OFF_INBOUND_12 @'h190c {
            bytes 4;
            field UPPER_BASE_RW @'h0 {
                bits 32;
                access rw;
                hard_reset 'h0;
                doc {
                    Forms bits [63:32] of the start (and end) address of the address region to be translated.

Note: This register field is sticky.
                }
            }
            doc {
                iATU Upper Base Address Register.iATU Upper Base Address Register.
            }
        }
        register IATU_LIMIT_ADDR_OFF_INBOUND_12 @'h1910 {
            bytes 4;
            field LIMIT_ADDR_HW @'h0 {
                bits 12;
                access ro;
                hard_reset 'h0;
                doc {
                    Forms lower bits of the end address of the address region to be translated. The end address must be aligned to a CX_ATU_MIN_REGION_SIZE kB boundary, so these bits are always all ones.
A write to this location is ignored by the PCIe controller.
                }
            }
            field LIMIT_ADDR_RW @'hc {
                bits 20;
                access rw;
                hard_reset 'h0;
                doc {
                    Forms upper bits of the end address of the address region to be translated.

Note: This register field is sticky.
                }
            }
            doc {
                iATU Limit Address Register.iATU Limit Address Register.
            }
        }
        register IATU_LWR_TARGET_ADDR_OFF_INBOUND_12 @'h1914 {
            bytes 4;
            field LWR_TARGET_HW @'h0 {
                bits 12;
                access ro;
                hard_reset 'h0;
                doc {
                    Forms the LSB's of the Lower Target part of the new address of the translated region. The start address must be aligned to a CX_ATU_MIN_REGION_SIZE kB boundary (in address match mode); and to the Bar size boundary (in BAR match mode) so that these bits are always '0'. If the BAR is smaller than the iATU region size, then the iATU target address must align to the iATU region size; otherwise it must align to the BAR size.

A write to this location is ignored by the PCIe controller.
 - Field size depends on log2(CX_ATU_MIN_REGION_SIZE) in address match mode.
 - Field size depends on log2(BAR_MASK+1) in BAR match mode.
                }
            }
            field LWR_TARGET_RW @'hc {
                bits 20;
                access rw;
                hard_reset 'h0;
                doc {
                    Forms MSB's of the Lower Target part of the new address of the translated region. These bits are always '0'.
 - Field size depends on log2(CX_ATU_MIN_REGION_SIZE) in address match mode.
 - Field size depends on log2(BAR_MASK+1) in BAR match mode.
Note: This register field is sticky.
                }
            }
            doc {
                iATU Lower Target Address Register.iATU Lower Target Address Register.
            }
        }
        register IATU_UPPER_TARGET_ADDR_OFF_INBOUND_12 @'h1918 {
            bytes 4;
            field UPPER_TARGET_RW @'h0 {
                bits 32;
                access rw;
                hard_reset 'h0;
                doc {
                    Forms bits [63:32] of the start address (Upper Target part) of the new address of the translated region. In systems with a 32-bit address space, this register is not used and therefore writing to this register has no effect.

Note: This register field is sticky.
                }
            }
            doc {
                iATU Upper Target Address Register.iATU Upper Target Address Register.
            }
        }
        register IATU_UPPR_LIMIT_ADDR_OFF_INBOUND_12 @'h1920 {
            bytes 4;
            field UPPR_LIMIT_ADDR_RW @'h0 {
                bits 4;
                access rw;
                hard_reset 'h0;
                doc {
                    Forms the LSB's of the Upper Limit part of the region "end address" to be translated. Only applies to 64-bit systems and when the INCREASE_REGION_SIZE field in IATU_REGION_CTRL_1_OFF_INBOUND_i is '1'

Note: This register field is sticky.
                }
            }
            field UPPR_LIMIT_ADDR_HW @'h4 {
                bits 28;
                access ro;
                hard_reset 'h0;
                doc {
                    Forms MSB's of the Upper Limit part of the region "end address" to be translated. Only applies to 64-bit systems and when the INCREASE_REGION_SIZE field in IATU_REGION_CTRL_1_OFF_INBOUND_i is '1'. These bits are always '0'.
                }
            }
            doc {
                iATU Upper Limit Address Register. The CX_MAX_ATU_REGION_SIZE configuration parameter (Value Range: 0->32, 8=1TB) specifies the maximum region size of an address translation region. This register is only used when the INCREASE_REGION_SIZE field in IATU_REGION_CTRL_1_OFF_INBOUND_i is '1'.iATU Upper Limit Address Register. The CX_MAX_ATU_REGION_SIZE configuration parameter (Value Range: 0->32, 8=1TB) specifies the maximum region size of an address translation region. This register is only used when the INCREASE_REGION_SIZE field in IATU_REGION_CTRL_1_OFF_INBOUND_i is '1'.
            }
        }
        register IATU_REGION_CTRL_1_OFF_OUTBOUND_13 @'h1a00 {
            bytes 4;
            field TYPE @'h0 {
                bits 5;
                access rw;
                hard_reset 'h0;
                doc {
                    When the address of an outbound TLP is matched to this region, then the TYPE field of the TLP is changed to the value in this register.

Note: This register field is sticky.
                }
            }
            field TC @'h5 {
                bits 3;
                access rw;
                hard_reset 'h0;
                doc {
                    When the address of an outbound TLP is matched to this region, then the TC field of the TLP is changed to the value in this register.

Note: This register field is sticky.
                }
            }
            field TD @'h8 {
                access rw;
                hard_reset 'h0;
                doc {
                    This is a reserved field. Do not use.

Note: This register field is sticky.
                }
            }
            field ATTR @'h9 {
                bits 2;
                access rw;
                hard_reset 'h0;
                doc {
                    When the address of an outbound TLP is matched to this region, then the ATTR field of the TLP is changed to the value in this register.

Note: This register field is sticky.
                }
            }
            field INCREASE_REGION_SIZE @'hd {
                access rw;
                hard_reset 'h0;
                doc {
                    Increase the maximum ATU Region size. When set, the maximum ATU Region size is determined by CX_ATU_MAX_REGION_SIZE. When clear, the maximum ATU Region size is 4 GB (default).

Note: This register field is sticky.
                }
            }
            field CTRL_1_FUNC_NUM @'h14 {
                bits 3;
                access rw;
                hard_reset 'h0;
                doc {
                    Function Number.
 - When the address of an outbound TLP is matched to this region and the FUNC_BYPASS field in the "iATU Control 2 Register" is '0', then the function number used in generating the function part of the requester ID (RID) field of the TLP is taken from this 5-bit register. The value in this register must be 0x0 unless multifunction operation in the controller is enabled (CX_NFUNC > 1).
 - When you are using the AXI Bridge, then this field is swapped before AXI decomposition occurs so that the correct "Max_Read_Request_Size" and "Max_Payload_Size" values are used.

Note: This register field is sticky.
                }
            }
            doc {
                iATU Region Control 1 Register.iATU Region Control 1 Register.
            }
        }
        register IATU_REGION_CTRL_2_OFF_OUTBOUND_13 @'h1a04 {
            bytes 4;
            field MSG_CODE @'h0 {
                bits 8;
                access rw;
                hard_reset 'h0;
                doc {
                    MSG TLPs (Message Code). When the address of an outbound TLP is matched to this region, and the translated TLP TYPE field is Msg or MsgD; then the message field of the TLP is changed to the value in this register.

Memory TLPs: (ST;Steering Tag). When the ST field of an outbound TLP is matched to this region, and the translated TLP TYPE field targets memory space; then the ST field of the TLP is changed to the value in this register. Only Valid when the CX_TPH_ENABLE configuration parameter is 1.

Note: This register field is sticky.
                }
            }
            field TAG @'h8 {
                bits 8;
                access rw;
                hard_reset 'h0;
                doc {
                    TAG.

The substituted TAG field (byte 6) in the outgoing TLP header when TAG_SUBSTITUTE_EN is set.

Note: This register field is sticky.
                }
            }
            field TAG_SUBSTITUTE_EN @'h10 {
                access rw;
                hard_reset 'h0;
                doc {
                    TAG Substitute Enable.

When enabled and region address is matched, the iATU substitutes the TAG field of the outbound TLP header with the contents of the TAG field in this register. The expected usage scenario is translation from AXI MWr to Vendor Defined Msg/MsgD.

Note (CX_TPH_ENABLE=1): TAG substitution for MWr will not occur because this field (byte 6) in the TLP header is the ST field. ST substitution can still take place using the MSG_CODE field in IATU_REGION_CTRL_2_OFF_OUTBOUND_i.

Note: This register field is sticky.
                }
            }
            field MSB2BITS_TAG @'h11 {
                bits 2;
                access rw;
                hard_reset 'h0;
                doc {
                    TAG.

Two most significant bits of the substituted TAG field in the outgoing TLP header when TAG_SUBSTITUTE_EN is set. 

Note: This register field is sticky.
                }
            }
            field FUNC_BYPASS @'h13 {
                access rw;
                hard_reset 'h0;
                doc {
                    Function Number Translation Bypass. In this mode, the function number of the translated TLP is taken from your application transmit interface and not from the CTRL_1_FUNC_NUM field of the "iATU Control 1 Register" or the VF_NUMBER field of the "iATU Control 3 Register."

Note: This register field is sticky.
                }
            }
            field SNP @'h14 {
                access rw;
                hard_reset 'h0;
                doc {
                    Serialize Non-Posted Requests. In this mode, when the AXI Bridge is populated, same AXI ID Non-Posted Read/Write Requests are transmitted on the wire if there are no other same ID Non-Posted Requests outstanding.

Note: This register field is sticky.
                }
            }
            field TLP_HEADER_FIELDS_BYPASS @'h15 {
                access rw;
                hard_reset 'h0;
                doc {
                    TLP Header Fields Translation Bypass.  In this mode header fields of the translated TLP is taken from your application transmit interface or, if AMBA is configured,  from the AMBA sideband bus (slv_awmisc_info) and not from the corresponding fields of the IATU_REGION_CTRL_1_OFF_OUTBOUND_i  or IATU_REGION_CTRL_2_OFF_OUTBOUND_i registers. The header fields are
 -	TC
 -	PH
 -	TH
 -	ST
 -	AT
 -	Attr (IDO, RO and NS).
Note: This register field is sticky. 

Note: This register field is sticky.
                }
            }
            field INHIBIT_PAYLOAD @'h16 {
                access rw;
                hard_reset 'h0;
                doc {
                    Inhibit TLP Payload Data for TLP's in Matched Region; assign iATU region to be TLP without data.
When enabled and region address is matched, the iATU marks all TLPs as having no payload data by forcing the TLP header Fmt[1] bit =0, regardless of the application inputs such as slv_wstrb.
 - 1: Fmt[1] =0 so that only TLP type without data is sent. For example, a Msg instead of MsgD will be sent.
 - 0: Fmt[1] =0/1 so that TLPs with or without data can be sent. 
Note: This register field is sticky.
                }
            }
            field HEADER_SUBSTITUTE_EN @'h17 {
                access rw;
                hard_reset 'h0;
                doc {
                    Header Substitute Enable.

When enabled and region address is matched, the iATU fully substitutes bytes 8-11 (for 3 DWORD header) or bytes 12-15 (for 4 DWORD header) of the outbound TLP header with the contents of the LWR_TARGET_RW field in IATU_LWR_TARGET_ADDR_OFF_OUTBOUND_i.
 - 1: LWR_TARGET_RW in the iATU_LWR_TARGET_ADDR_OFF_OUTBOUND_i register is used to fill bytes 8-to-11 (for 3 DWORD header) or bytes 12-to-15 (for 4 DWORD header) of the translated TLP header.
 - 0: LWR_TARGET_RW in the iATU_LWR_TARGET_ADDR_OFF_OUTBOUND_i register forms the new address of the translated region.
Note: This register field is sticky.
                }
            }
            field CFG_SHIFT_MODE @'h1c {
                access rw;
                hard_reset 'h0;
                doc {
                    CFG Shift Mode.

The iATU uses bits [27:12] of the untranslated address (on the XALI0/1/2 interface or AXI slave interface address) to form the BDF number of the outgoing CFG TLP.

This supports the Enhanced Configuration Address Mapping (ECAM) mechanism (Section 7.2.2 of the PCI Express Base 3.1 Specification, revision 1.0) by allowing all outgoing I/O and MEM TLPs (that have been translated to CFG) to be mapped from memory space into any 256 MB region of the PCIe configuration space.

Note: This register field is sticky.
                }
            }
            field INVERT_MODE @'h1d {
                access rw;
                hard_reset 'h0;
                doc {
                    Invert Mode. When set the address matching region is inverted. Therefore, an address match occurs when the untranslated address is in the region outside the defined range (Base Address to Limit Address).

Note: This register field is sticky.
                }
            }
            field REGION_EN @'h1f {
                access rw;
                hard_reset 'h0;
                doc {
                    Region Enable. This bit must be set to '1' for address translation to take place.

Note: This register field is sticky.
                }
            }
            doc {
                iATU Region Control 2 Register.iATU Region Control 2 Register.
            }
        }
        register IATU_LWR_BASE_ADDR_OFF_OUTBOUND_13 @'h1a08 {
            bytes 4;
            field LWR_BASE_HW @'h0 {
                bits 12;
                access ro;
                hard_reset 'h0;
                doc {
                    Forms bits [n-1:0] of the start address of the address region to be translated. The start address must be aligned to a CX_ATU_MIN_REGION_SIZE kB boundary, so these bits are always 0.
A write to this location is ignored by the PCIe controller.

n is log2(CX_ATU_MIN_REGION_SIZE)
                }
            }
            field LWR_BASE_RW @'hc {
                bits 20;
                access rw;
                hard_reset 'h0;
                doc {
                    Forms bits [31:n] of the start address of the address region to be translated. 
n is log2(CX_ATU_MIN_REGION_SIZE)

Note: This register field is sticky.
                }
            }
            doc {
                iATU Lower Base Address Register. The CX_ATU_MIN_REGION_SIZE configuration parameter (Value Range: 4 kB, 8 kB, 16 kB, 32 kB, 64 kB defaults to 64 kB) specifies the minimum size of an address translation region. For example, if set to 64 kB; the lower 16 bits of the Base, Limit and Target registers are zero and all address regions are aligned on 64 kB boundaries. More precisely, the lower log2(CX_ATU_MIN_REGION_SIZE) bits are zero.iATU Lower Base Address Register. The CX_ATU_MIN_REGION_SIZE configuration parameter (Value Range: 4 kB, 8 kB, 16 kB, 32 kB, 64 kB defaults to 64 kB) specifies the minimum size of an address translation region. For example, if set to 64 kB; the lower 16 bits of the Base, Limit and Target registers are zero and all address regions are aligned on 64 kB boundaries. More precisely, the lower log2(CX_ATU_MIN_REGION_SIZE) bits are zero.
            }
        }
        register IATU_UPPER_BASE_ADDR_OFF_OUTBOUND_13 @'h1a0c {
            bytes 4;
            field UPPER_BASE_RW @'h0 {
                bits 32;
                access rw;
                hard_reset 'h0;
                doc {
                    Forms bits [63:32] of the start (and end) address of the address region to be translated. In systems with a 32-bit address space, this register is not used and therefore writing to this register has no effect.

Note: This register field is sticky.
                }
            }
            doc {
                iATU Upper Base Address Register.iATU Upper Base Address Register.
            }
        }
        register IATU_LIMIT_ADDR_OFF_OUTBOUND_13 @'h1a10 {
            bytes 4;
            field LIMIT_ADDR_HW @'h0 {
                bits 12;
                access ro;
                hard_reset 'h0;
                doc {
                    Forms lower bits of the end address of the address region to be translated. The end address must be aligned to a CX_ATU_MIN_REGION_SIZE kB boundary, so these bits are always all ones.
A write to this location is ignored by the PCIe controller.
                }
            }
            field LIMIT_ADDR_RW @'hc {
                bits 20;
                access rw;
                hard_reset 'h0;
                doc {
                    Forms upper bits of the end address of the address region to be translated.

Note: This register field is sticky.
                }
            }
            doc {
                iATU Limit Address Register.iATU Limit Address Register.
            }
        }
        register IATU_LWR_TARGET_ADDR_OFF_OUTBOUND_13 @'h1a14 {
            bytes 4;
            field LWR_TARGET_RW_OUTBOUND @'h0 {
                bits 32;
                access rw;
                hard_reset 'h0;
                doc {
                    When HEADER_SUBSTITUTE_EN in IATU_REGION_CTRL_2_OFF_OUTBOUND_ is '0' (normal operation):
 - LWR_TARGET_RW[31:n] forms MSB's of the Lower Target part of the new address of the translated region;
 - LWR_TARGET_RW[n-1:0] are not used. (The start address must be aligned to a CX_ATU_MIN_REGION_SIZE kB boundary, so the lower bits of the start address of the new address of the translated region (bits n-1:0) are always '0').
 - n is log2(CX_ATU_MIN_REGION_SIZE).
When HEADER_SUBSTITUTE_EN in IATU_REGION_CTRL_2_OFF_OUTBOUND_i is '1':
 - LWR_TARGET_RW[31:0] forms bytes 8-11 (for 3 dword header) or bytes 12-15 (for 4 dword header) of the outbound TLP header. Usage scenarios include the transmission of Vendor Defined Messages where the controller determines the content of bytes 12 to 15 of the TLP header.
Note: This register field is sticky.
                }
            }
            doc {
                iATU Lower Target Address Register.iATU Lower Target Address Register.
            }
        }
        register IATU_UPPER_TARGET_ADDR_OFF_OUTBOUND_13 @'h1a18 {
            bytes 4;
            field UPPER_TARGET_RW @'h0 {
                bits 32;
                access rw;
                hard_reset 'h0;
                doc {
                    Forms bits [63:32] of the start address (Upper Target part) of the new address of the translated region.

Note: This register field is sticky.
                }
            }
            doc {
                iATU Upper Target Address Register.iATU Upper Target Address Register.
            }
        }
        register IATU_UPPR_LIMIT_ADDR_OFF_OUTBOUND_13 @'h1a20 {
            bytes 4;
            field UPPR_LIMIT_ADDR_RW @'h0 {
                bits 4;
                access rw;
                hard_reset 'h0;
                doc {
                    Forms the LSB's of the Upper Limit part of the region "end address" to be translated. Only applies to 64-bit systems and when the INCREASE_REGION_SIZE field in IATU_REGION_CTRL_1_OFF_OUTBOUND_i is '1'

Note: This register field is sticky.
                }
            }
            field UPPR_LIMIT_ADDR_HW @'h4 {
                bits 28;
                access ro;
                hard_reset 'h0;
                doc {
                    Forms MSB's of the Upper Limit part of the region "end address" to be translated. Only applies to 64-bit systems and when the INCREASE_REGION_SIZE field in IATU_REGION_CTRL_1_OFF_OUTBOUND_i is '1'. These bits are always '0'.
                }
            }
            doc {
                iATU Upper Limit Address Register. The CX_MAX_ATU_REGION_SIZE configuration parameter (Value Range: 0->32, 8=1TB) specifies the maximum region size of an address translation region. This register is only used when the INCREASE_REGION_SIZE field in IATU_REGION_CTRL_1_OFF_OUTBOUND_i is '1'.iATU Upper Limit Address Register. The CX_MAX_ATU_REGION_SIZE configuration parameter (Value Range: 0->32, 8=1TB) specifies the maximum region size of an address translation region. This register is only used when the INCREASE_REGION_SIZE field in IATU_REGION_CTRL_1_OFF_OUTBOUND_i is '1'.
            }
        }
        register IATU_REGION_CTRL_1_OFF_INBOUND_13 @'h1b00 {
            bytes 4;
            field TYPE @'h0 {
                bits 5;
                access rw;
                hard_reset 'h0;
                doc {
                    When the TYPE field of an inbound TLP is matched to this value, then address translation proceeds (when all other enabled field-matches are successful).

Note: This register field is sticky.
                }
            }
            field TC @'h5 {
                bits 3;
                access rw;
                hard_reset 'h0;
                doc {
                    When the TC field of an inbound TLP is matched to this value, then address translation proceeds (when all other enabled field-matches are successful). This check is only performed if the "TC Match Enable" bit of the "iATU Control 2 Register" is set.

Note: This register field is sticky.
                }
            }
            field TD @'h8 {
                access rw;
                hard_reset 'h0;
                doc {
                    When the TD field of an inbound TLP is matched to this value, then address translation proceeds (when all other enabled field-matches are successful). This check is only performed if the "TD Match Enable" bit of the "iATU Control 2 Register" is set.

Note: This register field is sticky.
                }
            }
            field ATTR @'h9 {
                bits 2;
                access rw;
                hard_reset 'h0;
                doc {
                    When the ATTR field of an inbound TLP is matched to this value, then address translation proceeds (when all other enabled field-matches are successful). This check is only performed if the "ATTR Match Enable" bit of the "iATU Control 2 Register" is set.

Note: This register field is sticky.
                }
            }
            field INCREASE_REGION_SIZE @'hd {
                access rw;
                hard_reset 'h0;
                doc {
                    Increase the maximum ATU Region size. When set, the maximum ATU Region size is determined by CX_ATU_MAX_REGION_SIZE. When clear, the maximum ATU Region size is 4 GB (default).

Note: This register field is sticky.
                }
            }
            field CTRL_1_FUNC_NUM @'h14 {
                bits 3;
                access rw;
                hard_reset 'h0;
                doc {
                    Function Number.
 - MEM-I/O: When the Address and BAR matching logic in the controller indicate that a MEM-I/O transaction matches a BAR in the function corresponding to this value, then address translation proceeds. This check is only performed if the "Function Number Match Enable" bit of the "iATU Control 2 Register" is set.
 - CFG0/CFG1: When the destination function number as specified in the routing ID of the TLP header matches the function, then address translation proceeds. This check is only performed if the "Function Number Match Enable" bit of the "iATU Control 2 Register" is set.
Note: This register field is sticky.
                }
            }
            doc {
                iATU Region Control 1 Register.iATU Region Control 1 Register.
            }
        }
        register IATU_REGION_CTRL_2_OFF_INBOUND_13 @'h1b04 {
            bytes 4;
            field MSG_CODE @'h0 {
                bits 8;
                access rw;
                hard_reset 'h0;
                doc {
                    MSG TLPs: (Message Code). When the TYPE field of an inbound Msg/MsgD TLP is matched to this value, then address translation proceeds (when all other enabled field-matches are successful). This check is only performed if the "Message Code Match Enable" bit of the "iATU Control 2 Register" is set.

Memory TLPs: (ST;Steering Tag). When the ST field of an inbound TLP is matched to this value, then address translation proceeds. This check is only performed if the "ST Match Enable" bit of the "iATU Control2 Register" is set. The setting is independent of the setting of the TH field. Only Valid when the CX_TPH_ENABLE configuration parameter is 1.

Note: This register field is sticky.
                }
            }
            field BAR_NUM @'h8 {
                bits 3;
                access rw;
                hard_reset 'h0;
                doc {
                    BAR Number. When the BAR number of an inbound MEM or IO TLP " that is matched by the normal internal BAR address matching mechanism " is the same as this field, address translation proceeds (when all other enabled field-matches are successful). This check is only performed if the "Match Mode" bit of the "iATU Control 2 Register" is set.
 - 000b - BAR0
 - 001b - BAR1
 - 010b - BAR2
 - 011b - BAR3
 - 100b - BAR4
 - 101b - BAR5
 - 110b - ROM
 - 111b - reserved
 - IO translation would require either 00100b or 00101b in the inbound TLP TYPE; the BAR Number set in the range 000b - 101b and that BAR configured as an IO BAR.
Note: This register field is sticky.
                }
            }
            field MSG_TYPE_MATCH_MODE @'hd {
                access rw;
                hard_reset 'h0;
                doc {
                    Message Type Match Mode.

When enabled, and if single address location translate enable is set, then inbound TLPs of type MSG/MSGd which match the type field of the iatu_region_ctrl_1_OFF_inbound register (=>TYPE[4:3]=2'b10) will be translated.
Message type match mode overrides any value of MATCH_MODE field in this register. Usage scenarios for this are translation of VDM or ATS messages when AXI bridge is configured on client interface.

Note: This register field is sticky.
                }
            }
            field TC_MATCH_EN @'he {
                access rw;
                hard_reset 'h0;
                doc {
                    TC Match Enable. Ensures that a successful TC TLP field comparison match (see TC field of the "iATU Control 1 Register") occurs for address translation to proceed.

Note: This register field is sticky.
                }
            }
            field TD_MATCH_EN @'hf {
                access rw;
                hard_reset 'h0;
                doc {
                    TD Match Enable. Ensures that a successful TD TLP field comparison match (see TD field of the "iATU Control 1 Register") occurs for address translation to proceed.

Note: This register field is sticky.
                }
            }
            field ATTR_MATCH_EN @'h10 {
                access rw;
                hard_reset 'h0;
                doc {
                    ATTR Match Enable. Ensures that a successful ATTR TLP field comparison match (see ATTR field of the "iATU Control 1 Register") occurs for address translation to proceed.

Note: This register field is sticky.
                }
            }
            field FUNC_NUM_MATCH_EN @'h13 {
                access rw;
                hard_reset 'h0;
                doc {
                    Function Number Match Enable. Ensures that a successful Function Number TLP field comparison match (see Function Number field of the "iATU Control 1 Register") occurs (in MEM-I/O and CFG0/CFG1 transactions) for address translation to proceed.

Note: This register field is sticky.
                }
            }
            field MSG_CODE_MATCH_EN @'h15 {
                access rw;
                hard_reset 'h0;
                doc {
                    Message Code Match Enable (Msg TLPS). Ensures that a successful message Code TLP field comparison match (see Message Code field of the "iATU Control 2 Register") occurs (in MSG transactions) for address translation to proceed.

ST Match Enable (Mem TLPs). Ensures that a successful ST TLP field comparison match (see ST field of the "iATU Control 2 Register") occurs (in MEM transactions) for address translation to proceed. Only Valid when the CX_TPH_ENABLE configuration parameter is 1

Note: This register field is sticky.
                }
            }
            field SINGLE_ADDR_LOC_TRANS_EN @'h17 {
                access rw;
                hard_reset 'h0;
                doc {
                    Single Address Location Translate Enable.

When enabled, Rx TLPs can be translated to a single address location as determined by the target address register of the iATU region.
The main usage scenario is translation of Messages (such as Vendor Defined or ATS Messages) to MWr TLPs when the AXI bridge is enabled.

Note: This register field is sticky.
                }
            }
            field RESPONSE_CODE @'h18 {
                bits 2;
                access rw;
                hard_reset 'h0;
                doc {
                    Response Code. Defines the type of response to give for accesses matching this region. This overrides the normal RADM filter response. Note that this feature is not available for any region where Single Address Location Translate is enabled.
 - 00 - Normal RADM filter response is used.
 - 01 - Unsupported request (UR)
 - 10 - Completer abort (CA)
 - 11 - Not used / undefined / reserved.
Note: This register field is sticky.
                }
            }
            field FUZZY_TYPE_MATCH_CODE @'h1b {
                access rw;
                hard_reset 'h0;
                doc {
                    Fuzzy Type Match Mode. When enabled, the iATU relaxes the matching of the TLP TYPE field against the expected TYPE field so that
 - CfgRd0 and CfgRd1 TLPs are seen as identical. Similarly with CfgWr0 and CfgWr1.
 - MWr, MRd and MRdLk TLPs are seen as identical
 - The Routing field of Msg/MsgD TLPs is ignored
 - FetchAdd, Swap and CAS are seen as identical.
For example, CFG0 in the TYPE field in the "iATU Control 1 Register" matches against an inbound CfgRd0, CfgRd1, CfgWr0 or CfgWr1 TLP.

Note: This register field is sticky.
                }
            }
            field CFG_SHIFT_MODE @'h1c {
                access rw;
                hard_reset 'h0;
                doc {
                    CFG Shift Mode. This is useful for CFG transactions where the PCIe configuration mechanism maps bits [27:12] of the address to the bus/device and function number. This allows a CFG configuration space to be located in any 256MB window of your application memory space using a 28-bit effective address. Shifts bits [31:16] of the untranslated address to form bits [27:12] of the translated address.

Note: This register field is sticky.
                }
            }
            field INVERT_MODE @'h1d {
                access rw;
                hard_reset 'h0;
                doc {
                    Invert Mode. When set the address matching region is inverted. Therefore, an address match occurs when the untranslated address is in the region outside the defined range (Base Address to Limit Address).

Note: This register field is sticky.
                }
            }
            field MATCH_MODE @'h1e {
                access rw;
                hard_reset 'h0;
                doc {
                    Match Mode. Determines Inbound matching mode for TLPs. The mode depends on the type of TLP that is received as follows:

 For MEM-I/O TLPs, this field is interpreted as follows:
 - 0: Address Match Mode. The iATU operates using addresses as in the outbound direction. The Region Base and Limit Registers must be setup.
 - 1:BAR Match Mode. BAR matching is used. The "BAR Number" field is relevant. Not used for RC.
For CFG0 TLPs, this field is interpreted as follows:
 - 0: Routing ID Match Mode. The iATU interprets the Routing ID (Bytes 8 to 11 of TLP header) as an address. This corresponds to the upper 16 bits of the address in MEM-I/O transactions. The Routing ID of the TLP must be within the base and limit of the iATU region for matching to proceed.
 - 1: Accept Mode. The iATU accepts all CFG0 transactions as address matches. The routing ID in the CFG0 TLP is ignored. This is useful as all received CFG0 TLPs should be processed regardless of the Bus number.
For MSG/MSGD TLPs, this field is interpreted as follows:
 - 0: Address Match Mode. The iATU treats the third dword and fourth dword of the inbound MSG/MSGD TLP as an address and it is matched against the Region Base and Limit Registers.
 - 1: Vendor ID Match Mode. This mode is relevant for ID-routed Vendor Defined Messages. The iATU ignores the Routing ID (Bus, Device, Function) in bits [31:16] of the third dword of the TLP header, but matches against the Vendor ID in bits [15:0] of the third dword of the TLP header. Bits [15:0] of the Region Upper Base register should be programmed with the required Vendor ID. The lower Base and Limit Register should be programmed to translate TLPs based on vendor specific information in the fourth dword of the TLP header.
 -	If SINGLE_ADDRESS_LOCATION_TRANSLATE_EN = 1 AND MSG_TYPE_MATCH_MODE = 1, then Match Mode is ignored.
Note: This register field is sticky.
                }
            }
            field REGION_EN @'h1f {
                access rw;
                hard_reset 'h0;
                doc {
                    Region Enable. This bit must be set to '1' for address translation to take place.

Note: This register field is sticky.
                }
            }
            doc {
                iATU Region Control 2 Register.iATU Region Control 2 Register.
            }
        }
        register IATU_LWR_BASE_ADDR_OFF_INBOUND_13 @'h1b08 {
            bytes 4;
            field LWR_BASE_HW @'h0 {
                bits 12;
                access ro;
                hard_reset 'h0;
                doc {
                    Forms bits [n-1:0] of the start address of the address region to be translated. The start address must be aligned to a CX_ATU_MIN_REGION_SIZE kB boundary, so these bits are always 0.
A write to this location is ignored by the PCIe controller.

n is log2(CX_ATU_MIN_REGION_SIZE)
                }
            }
            field LWR_BASE_RW @'hc {
                bits 20;
                access rw;
                hard_reset 'h0;
                doc {
                    Forms bits [31:n] of the start address of the address region to be translated. 
n is log2(CX_ATU_MIN_REGION_SIZE)

Note: This register field is sticky.
                }
            }
            doc {
                iATU Lower Base Address Register. The CX_ATU_MIN_REGION_SIZE configuration parameter (Value Range: 4 kB, 8 kB, 16 kB, 32 kB, 64 kB defaults to 64 kB) specifies the minimum size of an address translation region. For example, if set to 64 kB; the lower 16 bits of the Base, Limit and Target registers are zero and all address regions are aligned on 64 kB boundaries. More precisely, the lower log2(CX_ATU_MIN_REGION_SIZE) bits are zero.iATU Lower Base Address Register. The CX_ATU_MIN_REGION_SIZE configuration parameter (Value Range: 4 kB, 8 kB, 16 kB, 32 kB, 64 kB defaults to 64 kB) specifies the minimum size of an address translation region. For example, if set to 64 kB; the lower 16 bits of the Base, Limit and Target registers are zero and all address regions are aligned on 64 kB boundaries. More precisely, the lower log2(CX_ATU_MIN_REGION_SIZE) bits are zero.
            }
        }
        register IATU_UPPER_BASE_ADDR_OFF_INBOUND_13 @'h1b0c {
            bytes 4;
            field UPPER_BASE_RW @'h0 {
                bits 32;
                access rw;
                hard_reset 'h0;
                doc {
                    Forms bits [63:32] of the start (and end) address of the address region to be translated.

Note: This register field is sticky.
                }
            }
            doc {
                iATU Upper Base Address Register.iATU Upper Base Address Register.
            }
        }
        register IATU_LIMIT_ADDR_OFF_INBOUND_13 @'h1b10 {
            bytes 4;
            field LIMIT_ADDR_HW @'h0 {
                bits 12;
                access ro;
                hard_reset 'h0;
                doc {
                    Forms lower bits of the end address of the address region to be translated. The end address must be aligned to a CX_ATU_MIN_REGION_SIZE kB boundary, so these bits are always all ones.
A write to this location is ignored by the PCIe controller.
                }
            }
            field LIMIT_ADDR_RW @'hc {
                bits 20;
                access rw;
                hard_reset 'h0;
                doc {
                    Forms upper bits of the end address of the address region to be translated.

Note: This register field is sticky.
                }
            }
            doc {
                iATU Limit Address Register.iATU Limit Address Register.
            }
        }
        register IATU_LWR_TARGET_ADDR_OFF_INBOUND_13 @'h1b14 {
            bytes 4;
            field LWR_TARGET_HW @'h0 {
                bits 12;
                access ro;
                hard_reset 'h0;
                doc {
                    Forms the LSB's of the Lower Target part of the new address of the translated region. The start address must be aligned to a CX_ATU_MIN_REGION_SIZE kB boundary (in address match mode); and to the Bar size boundary (in BAR match mode) so that these bits are always '0'. If the BAR is smaller than the iATU region size, then the iATU target address must align to the iATU region size; otherwise it must align to the BAR size.

A write to this location is ignored by the PCIe controller.
 - Field size depends on log2(CX_ATU_MIN_REGION_SIZE) in address match mode.
 - Field size depends on log2(BAR_MASK+1) in BAR match mode.
                }
            }
            field LWR_TARGET_RW @'hc {
                bits 20;
                access rw;
                hard_reset 'h0;
                doc {
                    Forms MSB's of the Lower Target part of the new address of the translated region. These bits are always '0'.
 - Field size depends on log2(CX_ATU_MIN_REGION_SIZE) in address match mode.
 - Field size depends on log2(BAR_MASK+1) in BAR match mode.
Note: This register field is sticky.
                }
            }
            doc {
                iATU Lower Target Address Register.iATU Lower Target Address Register.
            }
        }
        register IATU_UPPER_TARGET_ADDR_OFF_INBOUND_13 @'h1b18 {
            bytes 4;
            field UPPER_TARGET_RW @'h0 {
                bits 32;
                access rw;
                hard_reset 'h0;
                doc {
                    Forms bits [63:32] of the start address (Upper Target part) of the new address of the translated region. In systems with a 32-bit address space, this register is not used and therefore writing to this register has no effect.

Note: This register field is sticky.
                }
            }
            doc {
                iATU Upper Target Address Register.iATU Upper Target Address Register.
            }
        }
        register IATU_UPPR_LIMIT_ADDR_OFF_INBOUND_13 @'h1b20 {
            bytes 4;
            field UPPR_LIMIT_ADDR_RW @'h0 {
                bits 4;
                access rw;
                hard_reset 'h0;
                doc {
                    Forms the LSB's of the Upper Limit part of the region "end address" to be translated. Only applies to 64-bit systems and when the INCREASE_REGION_SIZE field in IATU_REGION_CTRL_1_OFF_INBOUND_i is '1'

Note: This register field is sticky.
                }
            }
            field UPPR_LIMIT_ADDR_HW @'h4 {
                bits 28;
                access ro;
                hard_reset 'h0;
                doc {
                    Forms MSB's of the Upper Limit part of the region "end address" to be translated. Only applies to 64-bit systems and when the INCREASE_REGION_SIZE field in IATU_REGION_CTRL_1_OFF_INBOUND_i is '1'. These bits are always '0'.
                }
            }
            doc {
                iATU Upper Limit Address Register. The CX_MAX_ATU_REGION_SIZE configuration parameter (Value Range: 0->32, 8=1TB) specifies the maximum region size of an address translation region. This register is only used when the INCREASE_REGION_SIZE field in IATU_REGION_CTRL_1_OFF_INBOUND_i is '1'.iATU Upper Limit Address Register. The CX_MAX_ATU_REGION_SIZE configuration parameter (Value Range: 0->32, 8=1TB) specifies the maximum region size of an address translation region. This register is only used when the INCREASE_REGION_SIZE field in IATU_REGION_CTRL_1_OFF_INBOUND_i is '1'.
            }
        }
        register IATU_REGION_CTRL_1_OFF_OUTBOUND_14 @'h1c00 {
            bytes 4;
            field TYPE @'h0 {
                bits 5;
                access rw;
                hard_reset 'h0;
                doc {
                    When the address of an outbound TLP is matched to this region, then the TYPE field of the TLP is changed to the value in this register.

Note: This register field is sticky.
                }
            }
            field TC @'h5 {
                bits 3;
                access rw;
                hard_reset 'h0;
                doc {
                    When the address of an outbound TLP is matched to this region, then the TC field of the TLP is changed to the value in this register.

Note: This register field is sticky.
                }
            }
            field TD @'h8 {
                access rw;
                hard_reset 'h0;
                doc {
                    This is a reserved field. Do not use.

Note: This register field is sticky.
                }
            }
            field ATTR @'h9 {
                bits 2;
                access rw;
                hard_reset 'h0;
                doc {
                    When the address of an outbound TLP is matched to this region, then the ATTR field of the TLP is changed to the value in this register.

Note: This register field is sticky.
                }
            }
            field INCREASE_REGION_SIZE @'hd {
                access rw;
                hard_reset 'h0;
                doc {
                    Increase the maximum ATU Region size. When set, the maximum ATU Region size is determined by CX_ATU_MAX_REGION_SIZE. When clear, the maximum ATU Region size is 4 GB (default).

Note: This register field is sticky.
                }
            }
            field CTRL_1_FUNC_NUM @'h14 {
                bits 3;
                access rw;
                hard_reset 'h0;
                doc {
                    Function Number.
 - When the address of an outbound TLP is matched to this region and the FUNC_BYPASS field in the "iATU Control 2 Register" is '0', then the function number used in generating the function part of the requester ID (RID) field of the TLP is taken from this 5-bit register. The value in this register must be 0x0 unless multifunction operation in the controller is enabled (CX_NFUNC > 1).
 - When you are using the AXI Bridge, then this field is swapped before AXI decomposition occurs so that the correct "Max_Read_Request_Size" and "Max_Payload_Size" values are used.

Note: This register field is sticky.
                }
            }
            doc {
                iATU Region Control 1 Register.iATU Region Control 1 Register.
            }
        }
        register IATU_REGION_CTRL_2_OFF_OUTBOUND_14 @'h1c04 {
            bytes 4;
            field MSG_CODE @'h0 {
                bits 8;
                access rw;
                hard_reset 'h0;
                doc {
                    MSG TLPs (Message Code). When the address of an outbound TLP is matched to this region, and the translated TLP TYPE field is Msg or MsgD; then the message field of the TLP is changed to the value in this register.

Memory TLPs: (ST;Steering Tag). When the ST field of an outbound TLP is matched to this region, and the translated TLP TYPE field targets memory space; then the ST field of the TLP is changed to the value in this register. Only Valid when the CX_TPH_ENABLE configuration parameter is 1.

Note: This register field is sticky.
                }
            }
            field TAG @'h8 {
                bits 8;
                access rw;
                hard_reset 'h0;
                doc {
                    TAG.

The substituted TAG field (byte 6) in the outgoing TLP header when TAG_SUBSTITUTE_EN is set.

Note: This register field is sticky.
                }
            }
            field TAG_SUBSTITUTE_EN @'h10 {
                access rw;
                hard_reset 'h0;
                doc {
                    TAG Substitute Enable.

When enabled and region address is matched, the iATU substitutes the TAG field of the outbound TLP header with the contents of the TAG field in this register. The expected usage scenario is translation from AXI MWr to Vendor Defined Msg/MsgD.

Note (CX_TPH_ENABLE=1): TAG substitution for MWr will not occur because this field (byte 6) in the TLP header is the ST field. ST substitution can still take place using the MSG_CODE field in IATU_REGION_CTRL_2_OFF_OUTBOUND_i.

Note: This register field is sticky.
                }
            }
            field MSB2BITS_TAG @'h11 {
                bits 2;
                access rw;
                hard_reset 'h0;
                doc {
                    TAG.

Two most significant bits of the substituted TAG field in the outgoing TLP header when TAG_SUBSTITUTE_EN is set. 

Note: This register field is sticky.
                }
            }
            field FUNC_BYPASS @'h13 {
                access rw;
                hard_reset 'h0;
                doc {
                    Function Number Translation Bypass. In this mode, the function number of the translated TLP is taken from your application transmit interface and not from the CTRL_1_FUNC_NUM field of the "iATU Control 1 Register" or the VF_NUMBER field of the "iATU Control 3 Register."

Note: This register field is sticky.
                }
            }
            field SNP @'h14 {
                access rw;
                hard_reset 'h0;
                doc {
                    Serialize Non-Posted Requests. In this mode, when the AXI Bridge is populated, same AXI ID Non-Posted Read/Write Requests are transmitted on the wire if there are no other same ID Non-Posted Requests outstanding.

Note: This register field is sticky.
                }
            }
            field TLP_HEADER_FIELDS_BYPASS @'h15 {
                access rw;
                hard_reset 'h0;
                doc {
                    TLP Header Fields Translation Bypass.  In this mode header fields of the translated TLP is taken from your application transmit interface or, if AMBA is configured,  from the AMBA sideband bus (slv_awmisc_info) and not from the corresponding fields of the IATU_REGION_CTRL_1_OFF_OUTBOUND_i  or IATU_REGION_CTRL_2_OFF_OUTBOUND_i registers. The header fields are
 -	TC
 -	PH
 -	TH
 -	ST
 -	AT
 -	Attr (IDO, RO and NS).
Note: This register field is sticky. 

Note: This register field is sticky.
                }
            }
            field INHIBIT_PAYLOAD @'h16 {
                access rw;
                hard_reset 'h0;
                doc {
                    Inhibit TLP Payload Data for TLP's in Matched Region; assign iATU region to be TLP without data.
When enabled and region address is matched, the iATU marks all TLPs as having no payload data by forcing the TLP header Fmt[1] bit =0, regardless of the application inputs such as slv_wstrb.
 - 1: Fmt[1] =0 so that only TLP type without data is sent. For example, a Msg instead of MsgD will be sent.
 - 0: Fmt[1] =0/1 so that TLPs with or without data can be sent. 
Note: This register field is sticky.
                }
            }
            field HEADER_SUBSTITUTE_EN @'h17 {
                access rw;
                hard_reset 'h0;
                doc {
                    Header Substitute Enable.

When enabled and region address is matched, the iATU fully substitutes bytes 8-11 (for 3 DWORD header) or bytes 12-15 (for 4 DWORD header) of the outbound TLP header with the contents of the LWR_TARGET_RW field in IATU_LWR_TARGET_ADDR_OFF_OUTBOUND_i.
 - 1: LWR_TARGET_RW in the iATU_LWR_TARGET_ADDR_OFF_OUTBOUND_i register is used to fill bytes 8-to-11 (for 3 DWORD header) or bytes 12-to-15 (for 4 DWORD header) of the translated TLP header.
 - 0: LWR_TARGET_RW in the iATU_LWR_TARGET_ADDR_OFF_OUTBOUND_i register forms the new address of the translated region.
Note: This register field is sticky.
                }
            }
            field CFG_SHIFT_MODE @'h1c {
                access rw;
                hard_reset 'h0;
                doc {
                    CFG Shift Mode.

The iATU uses bits [27:12] of the untranslated address (on the XALI0/1/2 interface or AXI slave interface address) to form the BDF number of the outgoing CFG TLP.

This supports the Enhanced Configuration Address Mapping (ECAM) mechanism (Section 7.2.2 of the PCI Express Base 3.1 Specification, revision 1.0) by allowing all outgoing I/O and MEM TLPs (that have been translated to CFG) to be mapped from memory space into any 256 MB region of the PCIe configuration space.

Note: This register field is sticky.
                }
            }
            field INVERT_MODE @'h1d {
                access rw;
                hard_reset 'h0;
                doc {
                    Invert Mode. When set the address matching region is inverted. Therefore, an address match occurs when the untranslated address is in the region outside the defined range (Base Address to Limit Address).

Note: This register field is sticky.
                }
            }
            field REGION_EN @'h1f {
                access rw;
                hard_reset 'h0;
                doc {
                    Region Enable. This bit must be set to '1' for address translation to take place.

Note: This register field is sticky.
                }
            }
            doc {
                iATU Region Control 2 Register.iATU Region Control 2 Register.
            }
        }
        register IATU_LWR_BASE_ADDR_OFF_OUTBOUND_14 @'h1c08 {
            bytes 4;
            field LWR_BASE_HW @'h0 {
                bits 12;
                access ro;
                hard_reset 'h0;
                doc {
                    Forms bits [n-1:0] of the start address of the address region to be translated. The start address must be aligned to a CX_ATU_MIN_REGION_SIZE kB boundary, so these bits are always 0.
A write to this location is ignored by the PCIe controller.

n is log2(CX_ATU_MIN_REGION_SIZE)
                }
            }
            field LWR_BASE_RW @'hc {
                bits 20;
                access rw;
                hard_reset 'h0;
                doc {
                    Forms bits [31:n] of the start address of the address region to be translated. 
n is log2(CX_ATU_MIN_REGION_SIZE)

Note: This register field is sticky.
                }
            }
            doc {
                iATU Lower Base Address Register. The CX_ATU_MIN_REGION_SIZE configuration parameter (Value Range: 4 kB, 8 kB, 16 kB, 32 kB, 64 kB defaults to 64 kB) specifies the minimum size of an address translation region. For example, if set to 64 kB; the lower 16 bits of the Base, Limit and Target registers are zero and all address regions are aligned on 64 kB boundaries. More precisely, the lower log2(CX_ATU_MIN_REGION_SIZE) bits are zero.iATU Lower Base Address Register. The CX_ATU_MIN_REGION_SIZE configuration parameter (Value Range: 4 kB, 8 kB, 16 kB, 32 kB, 64 kB defaults to 64 kB) specifies the minimum size of an address translation region. For example, if set to 64 kB; the lower 16 bits of the Base, Limit and Target registers are zero and all address regions are aligned on 64 kB boundaries. More precisely, the lower log2(CX_ATU_MIN_REGION_SIZE) bits are zero.
            }
        }
        register IATU_UPPER_BASE_ADDR_OFF_OUTBOUND_14 @'h1c0c {
            bytes 4;
            field UPPER_BASE_RW @'h0 {
                bits 32;
                access rw;
                hard_reset 'h0;
                doc {
                    Forms bits [63:32] of the start (and end) address of the address region to be translated. In systems with a 32-bit address space, this register is not used and therefore writing to this register has no effect.

Note: This register field is sticky.
                }
            }
            doc {
                iATU Upper Base Address Register.iATU Upper Base Address Register.
            }
        }
        register IATU_LIMIT_ADDR_OFF_OUTBOUND_14 @'h1c10 {
            bytes 4;
            field LIMIT_ADDR_HW @'h0 {
                bits 12;
                access ro;
                hard_reset 'h0;
                doc {
                    Forms lower bits of the end address of the address region to be translated. The end address must be aligned to a CX_ATU_MIN_REGION_SIZE kB boundary, so these bits are always all ones.
A write to this location is ignored by the PCIe controller.
                }
            }
            field LIMIT_ADDR_RW @'hc {
                bits 20;
                access rw;
                hard_reset 'h0;
                doc {
                    Forms upper bits of the end address of the address region to be translated.

Note: This register field is sticky.
                }
            }
            doc {
                iATU Limit Address Register.iATU Limit Address Register.
            }
        }
        register IATU_LWR_TARGET_ADDR_OFF_OUTBOUND_14 @'h1c14 {
            bytes 4;
            field LWR_TARGET_RW_OUTBOUND @'h0 {
                bits 32;
                access rw;
                hard_reset 'h0;
                doc {
                    When HEADER_SUBSTITUTE_EN in IATU_REGION_CTRL_2_OFF_OUTBOUND_ is '0' (normal operation):
 - LWR_TARGET_RW[31:n] forms MSB's of the Lower Target part of the new address of the translated region;
 - LWR_TARGET_RW[n-1:0] are not used. (The start address must be aligned to a CX_ATU_MIN_REGION_SIZE kB boundary, so the lower bits of the start address of the new address of the translated region (bits n-1:0) are always '0').
 - n is log2(CX_ATU_MIN_REGION_SIZE).
When HEADER_SUBSTITUTE_EN in IATU_REGION_CTRL_2_OFF_OUTBOUND_i is '1':
 - LWR_TARGET_RW[31:0] forms bytes 8-11 (for 3 dword header) or bytes 12-15 (for 4 dword header) of the outbound TLP header. Usage scenarios include the transmission of Vendor Defined Messages where the controller determines the content of bytes 12 to 15 of the TLP header.
Note: This register field is sticky.
                }
            }
            doc {
                iATU Lower Target Address Register.iATU Lower Target Address Register.
            }
        }
        register IATU_UPPER_TARGET_ADDR_OFF_OUTBOUND_14 @'h1c18 {
            bytes 4;
            field UPPER_TARGET_RW @'h0 {
                bits 32;
                access rw;
                hard_reset 'h0;
                doc {
                    Forms bits [63:32] of the start address (Upper Target part) of the new address of the translated region.

Note: This register field is sticky.
                }
            }
            doc {
                iATU Upper Target Address Register.iATU Upper Target Address Register.
            }
        }
        register IATU_UPPR_LIMIT_ADDR_OFF_OUTBOUND_14 @'h1c20 {
            bytes 4;
            field UPPR_LIMIT_ADDR_RW @'h0 {
                bits 4;
                access rw;
                hard_reset 'h0;
                doc {
                    Forms the LSB's of the Upper Limit part of the region "end address" to be translated. Only applies to 64-bit systems and when the INCREASE_REGION_SIZE field in IATU_REGION_CTRL_1_OFF_OUTBOUND_i is '1'

Note: This register field is sticky.
                }
            }
            field UPPR_LIMIT_ADDR_HW @'h4 {
                bits 28;
                access ro;
                hard_reset 'h0;
                doc {
                    Forms MSB's of the Upper Limit part of the region "end address" to be translated. Only applies to 64-bit systems and when the INCREASE_REGION_SIZE field in IATU_REGION_CTRL_1_OFF_OUTBOUND_i is '1'. These bits are always '0'.
                }
            }
            doc {
                iATU Upper Limit Address Register. The CX_MAX_ATU_REGION_SIZE configuration parameter (Value Range: 0->32, 8=1TB) specifies the maximum region size of an address translation region. This register is only used when the INCREASE_REGION_SIZE field in IATU_REGION_CTRL_1_OFF_OUTBOUND_i is '1'.iATU Upper Limit Address Register. The CX_MAX_ATU_REGION_SIZE configuration parameter (Value Range: 0->32, 8=1TB) specifies the maximum region size of an address translation region. This register is only used when the INCREASE_REGION_SIZE field in IATU_REGION_CTRL_1_OFF_OUTBOUND_i is '1'.
            }
        }
        register IATU_REGION_CTRL_1_OFF_INBOUND_14 @'h1d00 {
            bytes 4;
            field TYPE @'h0 {
                bits 5;
                access rw;
                hard_reset 'h0;
                doc {
                    When the TYPE field of an inbound TLP is matched to this value, then address translation proceeds (when all other enabled field-matches are successful).

Note: This register field is sticky.
                }
            }
            field TC @'h5 {
                bits 3;
                access rw;
                hard_reset 'h0;
                doc {
                    When the TC field of an inbound TLP is matched to this value, then address translation proceeds (when all other enabled field-matches are successful). This check is only performed if the "TC Match Enable" bit of the "iATU Control 2 Register" is set.

Note: This register field is sticky.
                }
            }
            field TD @'h8 {
                access rw;
                hard_reset 'h0;
                doc {
                    When the TD field of an inbound TLP is matched to this value, then address translation proceeds (when all other enabled field-matches are successful). This check is only performed if the "TD Match Enable" bit of the "iATU Control 2 Register" is set.

Note: This register field is sticky.
                }
            }
            field ATTR @'h9 {
                bits 2;
                access rw;
                hard_reset 'h0;
                doc {
                    When the ATTR field of an inbound TLP is matched to this value, then address translation proceeds (when all other enabled field-matches are successful). This check is only performed if the "ATTR Match Enable" bit of the "iATU Control 2 Register" is set.

Note: This register field is sticky.
                }
            }
            field INCREASE_REGION_SIZE @'hd {
                access rw;
                hard_reset 'h0;
                doc {
                    Increase the maximum ATU Region size. When set, the maximum ATU Region size is determined by CX_ATU_MAX_REGION_SIZE. When clear, the maximum ATU Region size is 4 GB (default).

Note: This register field is sticky.
                }
            }
            field CTRL_1_FUNC_NUM @'h14 {
                bits 3;
                access rw;
                hard_reset 'h0;
                doc {
                    Function Number.
 - MEM-I/O: When the Address and BAR matching logic in the controller indicate that a MEM-I/O transaction matches a BAR in the function corresponding to this value, then address translation proceeds. This check is only performed if the "Function Number Match Enable" bit of the "iATU Control 2 Register" is set.
 - CFG0/CFG1: When the destination function number as specified in the routing ID of the TLP header matches the function, then address translation proceeds. This check is only performed if the "Function Number Match Enable" bit of the "iATU Control 2 Register" is set.
Note: This register field is sticky.
                }
            }
            doc {
                iATU Region Control 1 Register.iATU Region Control 1 Register.
            }
        }
        register IATU_REGION_CTRL_2_OFF_INBOUND_14 @'h1d04 {
            bytes 4;
            field MSG_CODE @'h0 {
                bits 8;
                access rw;
                hard_reset 'h0;
                doc {
                    MSG TLPs: (Message Code). When the TYPE field of an inbound Msg/MsgD TLP is matched to this value, then address translation proceeds (when all other enabled field-matches are successful). This check is only performed if the "Message Code Match Enable" bit of the "iATU Control 2 Register" is set.

Memory TLPs: (ST;Steering Tag). When the ST field of an inbound TLP is matched to this value, then address translation proceeds. This check is only performed if the "ST Match Enable" bit of the "iATU Control2 Register" is set. The setting is independent of the setting of the TH field. Only Valid when the CX_TPH_ENABLE configuration parameter is 1.

Note: This register field is sticky.
                }
            }
            field BAR_NUM @'h8 {
                bits 3;
                access rw;
                hard_reset 'h0;
                doc {
                    BAR Number. When the BAR number of an inbound MEM or IO TLP " that is matched by the normal internal BAR address matching mechanism " is the same as this field, address translation proceeds (when all other enabled field-matches are successful). This check is only performed if the "Match Mode" bit of the "iATU Control 2 Register" is set.
 - 000b - BAR0
 - 001b - BAR1
 - 010b - BAR2
 - 011b - BAR3
 - 100b - BAR4
 - 101b - BAR5
 - 110b - ROM
 - 111b - reserved
 - IO translation would require either 00100b or 00101b in the inbound TLP TYPE; the BAR Number set in the range 000b - 101b and that BAR configured as an IO BAR.
Note: This register field is sticky.
                }
            }
            field MSG_TYPE_MATCH_MODE @'hd {
                access rw;
                hard_reset 'h0;
                doc {
                    Message Type Match Mode.

When enabled, and if single address location translate enable is set, then inbound TLPs of type MSG/MSGd which match the type field of the iatu_region_ctrl_1_OFF_inbound register (=>TYPE[4:3]=2'b10) will be translated.
Message type match mode overrides any value of MATCH_MODE field in this register. Usage scenarios for this are translation of VDM or ATS messages when AXI bridge is configured on client interface.

Note: This register field is sticky.
                }
            }
            field TC_MATCH_EN @'he {
                access rw;
                hard_reset 'h0;
                doc {
                    TC Match Enable. Ensures that a successful TC TLP field comparison match (see TC field of the "iATU Control 1 Register") occurs for address translation to proceed.

Note: This register field is sticky.
                }
            }
            field TD_MATCH_EN @'hf {
                access rw;
                hard_reset 'h0;
                doc {
                    TD Match Enable. Ensures that a successful TD TLP field comparison match (see TD field of the "iATU Control 1 Register") occurs for address translation to proceed.

Note: This register field is sticky.
                }
            }
            field ATTR_MATCH_EN @'h10 {
                access rw;
                hard_reset 'h0;
                doc {
                    ATTR Match Enable. Ensures that a successful ATTR TLP field comparison match (see ATTR field of the "iATU Control 1 Register") occurs for address translation to proceed.

Note: This register field is sticky.
                }
            }
            field FUNC_NUM_MATCH_EN @'h13 {
                access rw;
                hard_reset 'h0;
                doc {
                    Function Number Match Enable. Ensures that a successful Function Number TLP field comparison match (see Function Number field of the "iATU Control 1 Register") occurs (in MEM-I/O and CFG0/CFG1 transactions) for address translation to proceed.

Note: This register field is sticky.
                }
            }
            field MSG_CODE_MATCH_EN @'h15 {
                access rw;
                hard_reset 'h0;
                doc {
                    Message Code Match Enable (Msg TLPS). Ensures that a successful message Code TLP field comparison match (see Message Code field of the "iATU Control 2 Register") occurs (in MSG transactions) for address translation to proceed.

ST Match Enable (Mem TLPs). Ensures that a successful ST TLP field comparison match (see ST field of the "iATU Control 2 Register") occurs (in MEM transactions) for address translation to proceed. Only Valid when the CX_TPH_ENABLE configuration parameter is 1

Note: This register field is sticky.
                }
            }
            field SINGLE_ADDR_LOC_TRANS_EN @'h17 {
                access rw;
                hard_reset 'h0;
                doc {
                    Single Address Location Translate Enable.

When enabled, Rx TLPs can be translated to a single address location as determined by the target address register of the iATU region.
The main usage scenario is translation of Messages (such as Vendor Defined or ATS Messages) to MWr TLPs when the AXI bridge is enabled.

Note: This register field is sticky.
                }
            }
            field RESPONSE_CODE @'h18 {
                bits 2;
                access rw;
                hard_reset 'h0;
                doc {
                    Response Code. Defines the type of response to give for accesses matching this region. This overrides the normal RADM filter response. Note that this feature is not available for any region where Single Address Location Translate is enabled.
 - 00 - Normal RADM filter response is used.
 - 01 - Unsupported request (UR)
 - 10 - Completer abort (CA)
 - 11 - Not used / undefined / reserved.
Note: This register field is sticky.
                }
            }
            field FUZZY_TYPE_MATCH_CODE @'h1b {
                access rw;
                hard_reset 'h0;
                doc {
                    Fuzzy Type Match Mode. When enabled, the iATU relaxes the matching of the TLP TYPE field against the expected TYPE field so that
 - CfgRd0 and CfgRd1 TLPs are seen as identical. Similarly with CfgWr0 and CfgWr1.
 - MWr, MRd and MRdLk TLPs are seen as identical
 - The Routing field of Msg/MsgD TLPs is ignored
 - FetchAdd, Swap and CAS are seen as identical.
For example, CFG0 in the TYPE field in the "iATU Control 1 Register" matches against an inbound CfgRd0, CfgRd1, CfgWr0 or CfgWr1 TLP.

Note: This register field is sticky.
                }
            }
            field CFG_SHIFT_MODE @'h1c {
                access rw;
                hard_reset 'h0;
                doc {
                    CFG Shift Mode. This is useful for CFG transactions where the PCIe configuration mechanism maps bits [27:12] of the address to the bus/device and function number. This allows a CFG configuration space to be located in any 256MB window of your application memory space using a 28-bit effective address. Shifts bits [31:16] of the untranslated address to form bits [27:12] of the translated address.

Note: This register field is sticky.
                }
            }
            field INVERT_MODE @'h1d {
                access rw;
                hard_reset 'h0;
                doc {
                    Invert Mode. When set the address matching region is inverted. Therefore, an address match occurs when the untranslated address is in the region outside the defined range (Base Address to Limit Address).

Note: This register field is sticky.
                }
            }
            field MATCH_MODE @'h1e {
                access rw;
                hard_reset 'h0;
                doc {
                    Match Mode. Determines Inbound matching mode for TLPs. The mode depends on the type of TLP that is received as follows:

 For MEM-I/O TLPs, this field is interpreted as follows:
 - 0: Address Match Mode. The iATU operates using addresses as in the outbound direction. The Region Base and Limit Registers must be setup.
 - 1:BAR Match Mode. BAR matching is used. The "BAR Number" field is relevant. Not used for RC.
For CFG0 TLPs, this field is interpreted as follows:
 - 0: Routing ID Match Mode. The iATU interprets the Routing ID (Bytes 8 to 11 of TLP header) as an address. This corresponds to the upper 16 bits of the address in MEM-I/O transactions. The Routing ID of the TLP must be within the base and limit of the iATU region for matching to proceed.
 - 1: Accept Mode. The iATU accepts all CFG0 transactions as address matches. The routing ID in the CFG0 TLP is ignored. This is useful as all received CFG0 TLPs should be processed regardless of the Bus number.
For MSG/MSGD TLPs, this field is interpreted as follows:
 - 0: Address Match Mode. The iATU treats the third dword and fourth dword of the inbound MSG/MSGD TLP as an address and it is matched against the Region Base and Limit Registers.
 - 1: Vendor ID Match Mode. This mode is relevant for ID-routed Vendor Defined Messages. The iATU ignores the Routing ID (Bus, Device, Function) in bits [31:16] of the third dword of the TLP header, but matches against the Vendor ID in bits [15:0] of the third dword of the TLP header. Bits [15:0] of the Region Upper Base register should be programmed with the required Vendor ID. The lower Base and Limit Register should be programmed to translate TLPs based on vendor specific information in the fourth dword of the TLP header.
 -	If SINGLE_ADDRESS_LOCATION_TRANSLATE_EN = 1 AND MSG_TYPE_MATCH_MODE = 1, then Match Mode is ignored.
Note: This register field is sticky.
                }
            }
            field REGION_EN @'h1f {
                access rw;
                hard_reset 'h0;
                doc {
                    Region Enable. This bit must be set to '1' for address translation to take place.

Note: This register field is sticky.
                }
            }
            doc {
                iATU Region Control 2 Register.iATU Region Control 2 Register.
            }
        }
        register IATU_LWR_BASE_ADDR_OFF_INBOUND_14 @'h1d08 {
            bytes 4;
            field LWR_BASE_HW @'h0 {
                bits 12;
                access ro;
                hard_reset 'h0;
                doc {
                    Forms bits [n-1:0] of the start address of the address region to be translated. The start address must be aligned to a CX_ATU_MIN_REGION_SIZE kB boundary, so these bits are always 0.
A write to this location is ignored by the PCIe controller.

n is log2(CX_ATU_MIN_REGION_SIZE)
                }
            }
            field LWR_BASE_RW @'hc {
                bits 20;
                access rw;
                hard_reset 'h0;
                doc {
                    Forms bits [31:n] of the start address of the address region to be translated. 
n is log2(CX_ATU_MIN_REGION_SIZE)

Note: This register field is sticky.
                }
            }
            doc {
                iATU Lower Base Address Register. The CX_ATU_MIN_REGION_SIZE configuration parameter (Value Range: 4 kB, 8 kB, 16 kB, 32 kB, 64 kB defaults to 64 kB) specifies the minimum size of an address translation region. For example, if set to 64 kB; the lower 16 bits of the Base, Limit and Target registers are zero and all address regions are aligned on 64 kB boundaries. More precisely, the lower log2(CX_ATU_MIN_REGION_SIZE) bits are zero.iATU Lower Base Address Register. The CX_ATU_MIN_REGION_SIZE configuration parameter (Value Range: 4 kB, 8 kB, 16 kB, 32 kB, 64 kB defaults to 64 kB) specifies the minimum size of an address translation region. For example, if set to 64 kB; the lower 16 bits of the Base, Limit and Target registers are zero and all address regions are aligned on 64 kB boundaries. More precisely, the lower log2(CX_ATU_MIN_REGION_SIZE) bits are zero.
            }
        }
        register IATU_UPPER_BASE_ADDR_OFF_INBOUND_14 @'h1d0c {
            bytes 4;
            field UPPER_BASE_RW @'h0 {
                bits 32;
                access rw;
                hard_reset 'h0;
                doc {
                    Forms bits [63:32] of the start (and end) address of the address region to be translated.

Note: This register field is sticky.
                }
            }
            doc {
                iATU Upper Base Address Register.iATU Upper Base Address Register.
            }
        }
        register IATU_LIMIT_ADDR_OFF_INBOUND_14 @'h1d10 {
            bytes 4;
            field LIMIT_ADDR_HW @'h0 {
                bits 12;
                access ro;
                hard_reset 'h0;
                doc {
                    Forms lower bits of the end address of the address region to be translated. The end address must be aligned to a CX_ATU_MIN_REGION_SIZE kB boundary, so these bits are always all ones.
A write to this location is ignored by the PCIe controller.
                }
            }
            field LIMIT_ADDR_RW @'hc {
                bits 20;
                access rw;
                hard_reset 'h0;
                doc {
                    Forms upper bits of the end address of the address region to be translated.

Note: This register field is sticky.
                }
            }
            doc {
                iATU Limit Address Register.iATU Limit Address Register.
            }
        }
        register IATU_LWR_TARGET_ADDR_OFF_INBOUND_14 @'h1d14 {
            bytes 4;
            field LWR_TARGET_HW @'h0 {
                bits 12;
                access ro;
                hard_reset 'h0;
                doc {
                    Forms the LSB's of the Lower Target part of the new address of the translated region. The start address must be aligned to a CX_ATU_MIN_REGION_SIZE kB boundary (in address match mode); and to the Bar size boundary (in BAR match mode) so that these bits are always '0'. If the BAR is smaller than the iATU region size, then the iATU target address must align to the iATU region size; otherwise it must align to the BAR size.

A write to this location is ignored by the PCIe controller.
 - Field size depends on log2(CX_ATU_MIN_REGION_SIZE) in address match mode.
 - Field size depends on log2(BAR_MASK+1) in BAR match mode.
                }
            }
            field LWR_TARGET_RW @'hc {
                bits 20;
                access rw;
                hard_reset 'h0;
                doc {
                    Forms MSB's of the Lower Target part of the new address of the translated region. These bits are always '0'.
 - Field size depends on log2(CX_ATU_MIN_REGION_SIZE) in address match mode.
 - Field size depends on log2(BAR_MASK+1) in BAR match mode.
Note: This register field is sticky.
                }
            }
            doc {
                iATU Lower Target Address Register.iATU Lower Target Address Register.
            }
        }
        register IATU_UPPER_TARGET_ADDR_OFF_INBOUND_14 @'h1d18 {
            bytes 4;
            field UPPER_TARGET_RW @'h0 {
                bits 32;
                access rw;
                hard_reset 'h0;
                doc {
                    Forms bits [63:32] of the start address (Upper Target part) of the new address of the translated region. In systems with a 32-bit address space, this register is not used and therefore writing to this register has no effect.

Note: This register field is sticky.
                }
            }
            doc {
                iATU Upper Target Address Register.iATU Upper Target Address Register.
            }
        }
        register IATU_UPPR_LIMIT_ADDR_OFF_INBOUND_14 @'h1d20 {
            bytes 4;
            field UPPR_LIMIT_ADDR_RW @'h0 {
                bits 4;
                access rw;
                hard_reset 'h0;
                doc {
                    Forms the LSB's of the Upper Limit part of the region "end address" to be translated. Only applies to 64-bit systems and when the INCREASE_REGION_SIZE field in IATU_REGION_CTRL_1_OFF_INBOUND_i is '1'

Note: This register field is sticky.
                }
            }
            field UPPR_LIMIT_ADDR_HW @'h4 {
                bits 28;
                access ro;
                hard_reset 'h0;
                doc {
                    Forms MSB's of the Upper Limit part of the region "end address" to be translated. Only applies to 64-bit systems and when the INCREASE_REGION_SIZE field in IATU_REGION_CTRL_1_OFF_INBOUND_i is '1'. These bits are always '0'.
                }
            }
            doc {
                iATU Upper Limit Address Register. The CX_MAX_ATU_REGION_SIZE configuration parameter (Value Range: 0->32, 8=1TB) specifies the maximum region size of an address translation region. This register is only used when the INCREASE_REGION_SIZE field in IATU_REGION_CTRL_1_OFF_INBOUND_i is '1'.iATU Upper Limit Address Register. The CX_MAX_ATU_REGION_SIZE configuration parameter (Value Range: 0->32, 8=1TB) specifies the maximum region size of an address translation region. This register is only used when the INCREASE_REGION_SIZE field in IATU_REGION_CTRL_1_OFF_INBOUND_i is '1'.
            }
        }
        register IATU_REGION_CTRL_1_OFF_OUTBOUND_15 @'h1e00 {
            bytes 4;
            field TYPE @'h0 {
                bits 5;
                access rw;
                hard_reset 'h0;
                doc {
                    When the address of an outbound TLP is matched to this region, then the TYPE field of the TLP is changed to the value in this register.

Note: This register field is sticky.
                }
            }
            field TC @'h5 {
                bits 3;
                access rw;
                hard_reset 'h0;
                doc {
                    When the address of an outbound TLP is matched to this region, then the TC field of the TLP is changed to the value in this register.

Note: This register field is sticky.
                }
            }
            field TD @'h8 {
                access rw;
                hard_reset 'h0;
                doc {
                    This is a reserved field. Do not use.

Note: This register field is sticky.
                }
            }
            field ATTR @'h9 {
                bits 2;
                access rw;
                hard_reset 'h0;
                doc {
                    When the address of an outbound TLP is matched to this region, then the ATTR field of the TLP is changed to the value in this register.

Note: This register field is sticky.
                }
            }
            field INCREASE_REGION_SIZE @'hd {
                access rw;
                hard_reset 'h0;
                doc {
                    Increase the maximum ATU Region size. When set, the maximum ATU Region size is determined by CX_ATU_MAX_REGION_SIZE. When clear, the maximum ATU Region size is 4 GB (default).

Note: This register field is sticky.
                }
            }
            field CTRL_1_FUNC_NUM @'h14 {
                bits 3;
                access rw;
                hard_reset 'h0;
                doc {
                    Function Number.
 - When the address of an outbound TLP is matched to this region and the FUNC_BYPASS field in the "iATU Control 2 Register" is '0', then the function number used in generating the function part of the requester ID (RID) field of the TLP is taken from this 5-bit register. The value in this register must be 0x0 unless multifunction operation in the controller is enabled (CX_NFUNC > 1).
 - When you are using the AXI Bridge, then this field is swapped before AXI decomposition occurs so that the correct "Max_Read_Request_Size" and "Max_Payload_Size" values are used.

Note: This register field is sticky.
                }
            }
            doc {
                iATU Region Control 1 Register.iATU Region Control 1 Register.
            }
        }
        register IATU_REGION_CTRL_2_OFF_OUTBOUND_15 @'h1e04 {
            bytes 4;
            field MSG_CODE @'h0 {
                bits 8;
                access rw;
                hard_reset 'h0;
                doc {
                    MSG TLPs (Message Code). When the address of an outbound TLP is matched to this region, and the translated TLP TYPE field is Msg or MsgD; then the message field of the TLP is changed to the value in this register.

Memory TLPs: (ST;Steering Tag). When the ST field of an outbound TLP is matched to this region, and the translated TLP TYPE field targets memory space; then the ST field of the TLP is changed to the value in this register. Only Valid when the CX_TPH_ENABLE configuration parameter is 1.

Note: This register field is sticky.
                }
            }
            field TAG @'h8 {
                bits 8;
                access rw;
                hard_reset 'h0;
                doc {
                    TAG.

The substituted TAG field (byte 6) in the outgoing TLP header when TAG_SUBSTITUTE_EN is set.

Note: This register field is sticky.
                }
            }
            field TAG_SUBSTITUTE_EN @'h10 {
                access rw;
                hard_reset 'h0;
                doc {
                    TAG Substitute Enable.

When enabled and region address is matched, the iATU substitutes the TAG field of the outbound TLP header with the contents of the TAG field in this register. The expected usage scenario is translation from AXI MWr to Vendor Defined Msg/MsgD.

Note (CX_TPH_ENABLE=1): TAG substitution for MWr will not occur because this field (byte 6) in the TLP header is the ST field. ST substitution can still take place using the MSG_CODE field in IATU_REGION_CTRL_2_OFF_OUTBOUND_i.

Note: This register field is sticky.
                }
            }
            field MSB2BITS_TAG @'h11 {
                bits 2;
                access rw;
                hard_reset 'h0;
                doc {
                    TAG.

Two most significant bits of the substituted TAG field in the outgoing TLP header when TAG_SUBSTITUTE_EN is set. 

Note: This register field is sticky.
                }
            }
            field FUNC_BYPASS @'h13 {
                access rw;
                hard_reset 'h0;
                doc {
                    Function Number Translation Bypass. In this mode, the function number of the translated TLP is taken from your application transmit interface and not from the CTRL_1_FUNC_NUM field of the "iATU Control 1 Register" or the VF_NUMBER field of the "iATU Control 3 Register."

Note: This register field is sticky.
                }
            }
            field SNP @'h14 {
                access rw;
                hard_reset 'h0;
                doc {
                    Serialize Non-Posted Requests. In this mode, when the AXI Bridge is populated, same AXI ID Non-Posted Read/Write Requests are transmitted on the wire if there are no other same ID Non-Posted Requests outstanding.

Note: This register field is sticky.
                }
            }
            field TLP_HEADER_FIELDS_BYPASS @'h15 {
                access rw;
                hard_reset 'h0;
                doc {
                    TLP Header Fields Translation Bypass.  In this mode header fields of the translated TLP is taken from your application transmit interface or, if AMBA is configured,  from the AMBA sideband bus (slv_awmisc_info) and not from the corresponding fields of the IATU_REGION_CTRL_1_OFF_OUTBOUND_i  or IATU_REGION_CTRL_2_OFF_OUTBOUND_i registers. The header fields are
 -	TC
 -	PH
 -	TH
 -	ST
 -	AT
 -	Attr (IDO, RO and NS).
Note: This register field is sticky. 

Note: This register field is sticky.
                }
            }
            field INHIBIT_PAYLOAD @'h16 {
                access rw;
                hard_reset 'h0;
                doc {
                    Inhibit TLP Payload Data for TLP's in Matched Region; assign iATU region to be TLP without data.
When enabled and region address is matched, the iATU marks all TLPs as having no payload data by forcing the TLP header Fmt[1] bit =0, regardless of the application inputs such as slv_wstrb.
 - 1: Fmt[1] =0 so that only TLP type without data is sent. For example, a Msg instead of MsgD will be sent.
 - 0: Fmt[1] =0/1 so that TLPs with or without data can be sent. 
Note: This register field is sticky.
                }
            }
            field HEADER_SUBSTITUTE_EN @'h17 {
                access rw;
                hard_reset 'h0;
                doc {
                    Header Substitute Enable.

When enabled and region address is matched, the iATU fully substitutes bytes 8-11 (for 3 DWORD header) or bytes 12-15 (for 4 DWORD header) of the outbound TLP header with the contents of the LWR_TARGET_RW field in IATU_LWR_TARGET_ADDR_OFF_OUTBOUND_i.
 - 1: LWR_TARGET_RW in the iATU_LWR_TARGET_ADDR_OFF_OUTBOUND_i register is used to fill bytes 8-to-11 (for 3 DWORD header) or bytes 12-to-15 (for 4 DWORD header) of the translated TLP header.
 - 0: LWR_TARGET_RW in the iATU_LWR_TARGET_ADDR_OFF_OUTBOUND_i register forms the new address of the translated region.
Note: This register field is sticky.
                }
            }
            field CFG_SHIFT_MODE @'h1c {
                access rw;
                hard_reset 'h0;
                doc {
                    CFG Shift Mode.

The iATU uses bits [27:12] of the untranslated address (on the XALI0/1/2 interface or AXI slave interface address) to form the BDF number of the outgoing CFG TLP.

This supports the Enhanced Configuration Address Mapping (ECAM) mechanism (Section 7.2.2 of the PCI Express Base 3.1 Specification, revision 1.0) by allowing all outgoing I/O and MEM TLPs (that have been translated to CFG) to be mapped from memory space into any 256 MB region of the PCIe configuration space.

Note: This register field is sticky.
                }
            }
            field INVERT_MODE @'h1d {
                access rw;
                hard_reset 'h0;
                doc {
                    Invert Mode. When set the address matching region is inverted. Therefore, an address match occurs when the untranslated address is in the region outside the defined range (Base Address to Limit Address).

Note: This register field is sticky.
                }
            }
            field REGION_EN @'h1f {
                access rw;
                hard_reset 'h0;
                doc {
                    Region Enable. This bit must be set to '1' for address translation to take place.

Note: This register field is sticky.
                }
            }
            doc {
                iATU Region Control 2 Register.iATU Region Control 2 Register.
            }
        }
        register IATU_LWR_BASE_ADDR_OFF_OUTBOUND_15 @'h1e08 {
            bytes 4;
            field LWR_BASE_HW @'h0 {
                bits 12;
                access ro;
                hard_reset 'h0;
                doc {
                    Forms bits [n-1:0] of the start address of the address region to be translated. The start address must be aligned to a CX_ATU_MIN_REGION_SIZE kB boundary, so these bits are always 0.
A write to this location is ignored by the PCIe controller.

n is log2(CX_ATU_MIN_REGION_SIZE)
                }
            }
            field LWR_BASE_RW @'hc {
                bits 20;
                access rw;
                hard_reset 'h0;
                doc {
                    Forms bits [31:n] of the start address of the address region to be translated. 
n is log2(CX_ATU_MIN_REGION_SIZE)

Note: This register field is sticky.
                }
            }
            doc {
                iATU Lower Base Address Register. The CX_ATU_MIN_REGION_SIZE configuration parameter (Value Range: 4 kB, 8 kB, 16 kB, 32 kB, 64 kB defaults to 64 kB) specifies the minimum size of an address translation region. For example, if set to 64 kB; the lower 16 bits of the Base, Limit and Target registers are zero and all address regions are aligned on 64 kB boundaries. More precisely, the lower log2(CX_ATU_MIN_REGION_SIZE) bits are zero.iATU Lower Base Address Register. The CX_ATU_MIN_REGION_SIZE configuration parameter (Value Range: 4 kB, 8 kB, 16 kB, 32 kB, 64 kB defaults to 64 kB) specifies the minimum size of an address translation region. For example, if set to 64 kB; the lower 16 bits of the Base, Limit and Target registers are zero and all address regions are aligned on 64 kB boundaries. More precisely, the lower log2(CX_ATU_MIN_REGION_SIZE) bits are zero.
            }
        }
        register IATU_UPPER_BASE_ADDR_OFF_OUTBOUND_15 @'h1e0c {
            bytes 4;
            field UPPER_BASE_RW @'h0 {
                bits 32;
                access rw;
                hard_reset 'h0;
                doc {
                    Forms bits [63:32] of the start (and end) address of the address region to be translated. In systems with a 32-bit address space, this register is not used and therefore writing to this register has no effect.

Note: This register field is sticky.
                }
            }
            doc {
                iATU Upper Base Address Register.iATU Upper Base Address Register.
            }
        }
        register IATU_LIMIT_ADDR_OFF_OUTBOUND_15 @'h1e10 {
            bytes 4;
            field LIMIT_ADDR_HW @'h0 {
                bits 12;
                access ro;
                hard_reset 'h0;
                doc {
                    Forms lower bits of the end address of the address region to be translated. The end address must be aligned to a CX_ATU_MIN_REGION_SIZE kB boundary, so these bits are always all ones.
A write to this location is ignored by the PCIe controller.
                }
            }
            field LIMIT_ADDR_RW @'hc {
                bits 20;
                access rw;
                hard_reset 'h0;
                doc {
                    Forms upper bits of the end address of the address region to be translated.

Note: This register field is sticky.
                }
            }
            doc {
                iATU Limit Address Register.iATU Limit Address Register.
            }
        }
        register IATU_LWR_TARGET_ADDR_OFF_OUTBOUND_15 @'h1e14 {
            bytes 4;
            field LWR_TARGET_RW_OUTBOUND @'h0 {
                bits 32;
                access rw;
                hard_reset 'h0;
                doc {
                    When HEADER_SUBSTITUTE_EN in IATU_REGION_CTRL_2_OFF_OUTBOUND_ is '0' (normal operation):
 - LWR_TARGET_RW[31:n] forms MSB's of the Lower Target part of the new address of the translated region;
 - LWR_TARGET_RW[n-1:0] are not used. (The start address must be aligned to a CX_ATU_MIN_REGION_SIZE kB boundary, so the lower bits of the start address of the new address of the translated region (bits n-1:0) are always '0').
 - n is log2(CX_ATU_MIN_REGION_SIZE).
When HEADER_SUBSTITUTE_EN in IATU_REGION_CTRL_2_OFF_OUTBOUND_i is '1':
 - LWR_TARGET_RW[31:0] forms bytes 8-11 (for 3 dword header) or bytes 12-15 (for 4 dword header) of the outbound TLP header. Usage scenarios include the transmission of Vendor Defined Messages where the controller determines the content of bytes 12 to 15 of the TLP header.
Note: This register field is sticky.
                }
            }
            doc {
                iATU Lower Target Address Register.iATU Lower Target Address Register.
            }
        }
        register IATU_UPPER_TARGET_ADDR_OFF_OUTBOUND_15 @'h1e18 {
            bytes 4;
            field UPPER_TARGET_RW @'h0 {
                bits 32;
                access rw;
                hard_reset 'h0;
                doc {
                    Forms bits [63:32] of the start address (Upper Target part) of the new address of the translated region.

Note: This register field is sticky.
                }
            }
            doc {
                iATU Upper Target Address Register.iATU Upper Target Address Register.
            }
        }
        register IATU_UPPR_LIMIT_ADDR_OFF_OUTBOUND_15 @'h1e20 {
            bytes 4;
            field UPPR_LIMIT_ADDR_RW @'h0 {
                bits 4;
                access rw;
                hard_reset 'h0;
                doc {
                    Forms the LSB's of the Upper Limit part of the region "end address" to be translated. Only applies to 64-bit systems and when the INCREASE_REGION_SIZE field in IATU_REGION_CTRL_1_OFF_OUTBOUND_i is '1'

Note: This register field is sticky.
                }
            }
            field UPPR_LIMIT_ADDR_HW @'h4 {
                bits 28;
                access ro;
                hard_reset 'h0;
                doc {
                    Forms MSB's of the Upper Limit part of the region "end address" to be translated. Only applies to 64-bit systems and when the INCREASE_REGION_SIZE field in IATU_REGION_CTRL_1_OFF_OUTBOUND_i is '1'. These bits are always '0'.
                }
            }
            doc {
                iATU Upper Limit Address Register. The CX_MAX_ATU_REGION_SIZE configuration parameter (Value Range: 0->32, 8=1TB) specifies the maximum region size of an address translation region. This register is only used when the INCREASE_REGION_SIZE field in IATU_REGION_CTRL_1_OFF_OUTBOUND_i is '1'.iATU Upper Limit Address Register. The CX_MAX_ATU_REGION_SIZE configuration parameter (Value Range: 0->32, 8=1TB) specifies the maximum region size of an address translation region. This register is only used when the INCREASE_REGION_SIZE field in IATU_REGION_CTRL_1_OFF_OUTBOUND_i is '1'.
            }
        }
        register IATU_REGION_CTRL_1_OFF_INBOUND_15 @'h1f00 {
            bytes 4;
            field TYPE @'h0 {
                bits 5;
                access rw;
                hard_reset 'h0;
                doc {
                    When the TYPE field of an inbound TLP is matched to this value, then address translation proceeds (when all other enabled field-matches are successful).

Note: This register field is sticky.
                }
            }
            field TC @'h5 {
                bits 3;
                access rw;
                hard_reset 'h0;
                doc {
                    When the TC field of an inbound TLP is matched to this value, then address translation proceeds (when all other enabled field-matches are successful). This check is only performed if the "TC Match Enable" bit of the "iATU Control 2 Register" is set.

Note: This register field is sticky.
                }
            }
            field TD @'h8 {
                access rw;
                hard_reset 'h0;
                doc {
                    When the TD field of an inbound TLP is matched to this value, then address translation proceeds (when all other enabled field-matches are successful). This check is only performed if the "TD Match Enable" bit of the "iATU Control 2 Register" is set.

Note: This register field is sticky.
                }
            }
            field ATTR @'h9 {
                bits 2;
                access rw;
                hard_reset 'h0;
                doc {
                    When the ATTR field of an inbound TLP is matched to this value, then address translation proceeds (when all other enabled field-matches are successful). This check is only performed if the "ATTR Match Enable" bit of the "iATU Control 2 Register" is set.

Note: This register field is sticky.
                }
            }
            field INCREASE_REGION_SIZE @'hd {
                access rw;
                hard_reset 'h0;
                doc {
                    Increase the maximum ATU Region size. When set, the maximum ATU Region size is determined by CX_ATU_MAX_REGION_SIZE. When clear, the maximum ATU Region size is 4 GB (default).

Note: This register field is sticky.
                }
            }
            field CTRL_1_FUNC_NUM @'h14 {
                bits 3;
                access rw;
                hard_reset 'h0;
                doc {
                    Function Number.
 - MEM-I/O: When the Address and BAR matching logic in the controller indicate that a MEM-I/O transaction matches a BAR in the function corresponding to this value, then address translation proceeds. This check is only performed if the "Function Number Match Enable" bit of the "iATU Control 2 Register" is set.
 - CFG0/CFG1: When the destination function number as specified in the routing ID of the TLP header matches the function, then address translation proceeds. This check is only performed if the "Function Number Match Enable" bit of the "iATU Control 2 Register" is set.
Note: This register field is sticky.
                }
            }
            doc {
                iATU Region Control 1 Register.iATU Region Control 1 Register.
            }
        }
        register IATU_REGION_CTRL_2_OFF_INBOUND_15 @'h1f04 {
            bytes 4;
            field MSG_CODE @'h0 {
                bits 8;
                access rw;
                hard_reset 'h0;
                doc {
                    MSG TLPs: (Message Code). When the TYPE field of an inbound Msg/MsgD TLP is matched to this value, then address translation proceeds (when all other enabled field-matches are successful). This check is only performed if the "Message Code Match Enable" bit of the "iATU Control 2 Register" is set.

Memory TLPs: (ST;Steering Tag). When the ST field of an inbound TLP is matched to this value, then address translation proceeds. This check is only performed if the "ST Match Enable" bit of the "iATU Control2 Register" is set. The setting is independent of the setting of the TH field. Only Valid when the CX_TPH_ENABLE configuration parameter is 1.

Note: This register field is sticky.
                }
            }
            field BAR_NUM @'h8 {
                bits 3;
                access rw;
                hard_reset 'h0;
                doc {
                    BAR Number. When the BAR number of an inbound MEM or IO TLP " that is matched by the normal internal BAR address matching mechanism " is the same as this field, address translation proceeds (when all other enabled field-matches are successful). This check is only performed if the "Match Mode" bit of the "iATU Control 2 Register" is set.
 - 000b - BAR0
 - 001b - BAR1
 - 010b - BAR2
 - 011b - BAR3
 - 100b - BAR4
 - 101b - BAR5
 - 110b - ROM
 - 111b - reserved
 - IO translation would require either 00100b or 00101b in the inbound TLP TYPE; the BAR Number set in the range 000b - 101b and that BAR configured as an IO BAR.
Note: This register field is sticky.
                }
            }
            field MSG_TYPE_MATCH_MODE @'hd {
                access rw;
                hard_reset 'h0;
                doc {
                    Message Type Match Mode.

When enabled, and if single address location translate enable is set, then inbound TLPs of type MSG/MSGd which match the type field of the iatu_region_ctrl_1_OFF_inbound register (=>TYPE[4:3]=2'b10) will be translated.
Message type match mode overrides any value of MATCH_MODE field in this register. Usage scenarios for this are translation of VDM or ATS messages when AXI bridge is configured on client interface.

Note: This register field is sticky.
                }
            }
            field TC_MATCH_EN @'he {
                access rw;
                hard_reset 'h0;
                doc {
                    TC Match Enable. Ensures that a successful TC TLP field comparison match (see TC field of the "iATU Control 1 Register") occurs for address translation to proceed.

Note: This register field is sticky.
                }
            }
            field TD_MATCH_EN @'hf {
                access rw;
                hard_reset 'h0;
                doc {
                    TD Match Enable. Ensures that a successful TD TLP field comparison match (see TD field of the "iATU Control 1 Register") occurs for address translation to proceed.

Note: This register field is sticky.
                }
            }
            field ATTR_MATCH_EN @'h10 {
                access rw;
                hard_reset 'h0;
                doc {
                    ATTR Match Enable. Ensures that a successful ATTR TLP field comparison match (see ATTR field of the "iATU Control 1 Register") occurs for address translation to proceed.

Note: This register field is sticky.
                }
            }
            field FUNC_NUM_MATCH_EN @'h13 {
                access rw;
                hard_reset 'h0;
                doc {
                    Function Number Match Enable. Ensures that a successful Function Number TLP field comparison match (see Function Number field of the "iATU Control 1 Register") occurs (in MEM-I/O and CFG0/CFG1 transactions) for address translation to proceed.

Note: This register field is sticky.
                }
            }
            field MSG_CODE_MATCH_EN @'h15 {
                access rw;
                hard_reset 'h0;
                doc {
                    Message Code Match Enable (Msg TLPS). Ensures that a successful message Code TLP field comparison match (see Message Code field of the "iATU Control 2 Register") occurs (in MSG transactions) for address translation to proceed.

ST Match Enable (Mem TLPs). Ensures that a successful ST TLP field comparison match (see ST field of the "iATU Control 2 Register") occurs (in MEM transactions) for address translation to proceed. Only Valid when the CX_TPH_ENABLE configuration parameter is 1

Note: This register field is sticky.
                }
            }
            field SINGLE_ADDR_LOC_TRANS_EN @'h17 {
                access rw;
                hard_reset 'h0;
                doc {
                    Single Address Location Translate Enable.

When enabled, Rx TLPs can be translated to a single address location as determined by the target address register of the iATU region.
The main usage scenario is translation of Messages (such as Vendor Defined or ATS Messages) to MWr TLPs when the AXI bridge is enabled.

Note: This register field is sticky.
                }
            }
            field RESPONSE_CODE @'h18 {
                bits 2;
                access rw;
                hard_reset 'h0;
                doc {
                    Response Code. Defines the type of response to give for accesses matching this region. This overrides the normal RADM filter response. Note that this feature is not available for any region where Single Address Location Translate is enabled.
 - 00 - Normal RADM filter response is used.
 - 01 - Unsupported request (UR)
 - 10 - Completer abort (CA)
 - 11 - Not used / undefined / reserved.
Note: This register field is sticky.
                }
            }
            field FUZZY_TYPE_MATCH_CODE @'h1b {
                access rw;
                hard_reset 'h0;
                doc {
                    Fuzzy Type Match Mode. When enabled, the iATU relaxes the matching of the TLP TYPE field against the expected TYPE field so that
 - CfgRd0 and CfgRd1 TLPs are seen as identical. Similarly with CfgWr0 and CfgWr1.
 - MWr, MRd and MRdLk TLPs are seen as identical
 - The Routing field of Msg/MsgD TLPs is ignored
 - FetchAdd, Swap and CAS are seen as identical.
For example, CFG0 in the TYPE field in the "iATU Control 1 Register" matches against an inbound CfgRd0, CfgRd1, CfgWr0 or CfgWr1 TLP.

Note: This register field is sticky.
                }
            }
            field CFG_SHIFT_MODE @'h1c {
                access rw;
                hard_reset 'h0;
                doc {
                    CFG Shift Mode. This is useful for CFG transactions where the PCIe configuration mechanism maps bits [27:12] of the address to the bus/device and function number. This allows a CFG configuration space to be located in any 256MB window of your application memory space using a 28-bit effective address. Shifts bits [31:16] of the untranslated address to form bits [27:12] of the translated address.

Note: This register field is sticky.
                }
            }
            field INVERT_MODE @'h1d {
                access rw;
                hard_reset 'h0;
                doc {
                    Invert Mode. When set the address matching region is inverted. Therefore, an address match occurs when the untranslated address is in the region outside the defined range (Base Address to Limit Address).

Note: This register field is sticky.
                }
            }
            field MATCH_MODE @'h1e {
                access rw;
                hard_reset 'h0;
                doc {
                    Match Mode. Determines Inbound matching mode for TLPs. The mode depends on the type of TLP that is received as follows:

 For MEM-I/O TLPs, this field is interpreted as follows:
 - 0: Address Match Mode. The iATU operates using addresses as in the outbound direction. The Region Base and Limit Registers must be setup.
 - 1:BAR Match Mode. BAR matching is used. The "BAR Number" field is relevant. Not used for RC.
For CFG0 TLPs, this field is interpreted as follows:
 - 0: Routing ID Match Mode. The iATU interprets the Routing ID (Bytes 8 to 11 of TLP header) as an address. This corresponds to the upper 16 bits of the address in MEM-I/O transactions. The Routing ID of the TLP must be within the base and limit of the iATU region for matching to proceed.
 - 1: Accept Mode. The iATU accepts all CFG0 transactions as address matches. The routing ID in the CFG0 TLP is ignored. This is useful as all received CFG0 TLPs should be processed regardless of the Bus number.
For MSG/MSGD TLPs, this field is interpreted as follows:
 - 0: Address Match Mode. The iATU treats the third dword and fourth dword of the inbound MSG/MSGD TLP as an address and it is matched against the Region Base and Limit Registers.
 - 1: Vendor ID Match Mode. This mode is relevant for ID-routed Vendor Defined Messages. The iATU ignores the Routing ID (Bus, Device, Function) in bits [31:16] of the third dword of the TLP header, but matches against the Vendor ID in bits [15:0] of the third dword of the TLP header. Bits [15:0] of the Region Upper Base register should be programmed with the required Vendor ID. The lower Base and Limit Register should be programmed to translate TLPs based on vendor specific information in the fourth dword of the TLP header.
 -	If SINGLE_ADDRESS_LOCATION_TRANSLATE_EN = 1 AND MSG_TYPE_MATCH_MODE = 1, then Match Mode is ignored.
Note: This register field is sticky.
                }
            }
            field REGION_EN @'h1f {
                access rw;
                hard_reset 'h0;
                doc {
                    Region Enable. This bit must be set to '1' for address translation to take place.

Note: This register field is sticky.
                }
            }
            doc {
                iATU Region Control 2 Register.iATU Region Control 2 Register.
            }
        }
        register IATU_LWR_BASE_ADDR_OFF_INBOUND_15 @'h1f08 {
            bytes 4;
            field LWR_BASE_HW @'h0 {
                bits 12;
                access ro;
                hard_reset 'h0;
                doc {
                    Forms bits [n-1:0] of the start address of the address region to be translated. The start address must be aligned to a CX_ATU_MIN_REGION_SIZE kB boundary, so these bits are always 0.
A write to this location is ignored by the PCIe controller.

n is log2(CX_ATU_MIN_REGION_SIZE)
                }
            }
            field LWR_BASE_RW @'hc {
                bits 20;
                access rw;
                hard_reset 'h0;
                doc {
                    Forms bits [31:n] of the start address of the address region to be translated. 
n is log2(CX_ATU_MIN_REGION_SIZE)

Note: This register field is sticky.
                }
            }
            doc {
                iATU Lower Base Address Register. The CX_ATU_MIN_REGION_SIZE configuration parameter (Value Range: 4 kB, 8 kB, 16 kB, 32 kB, 64 kB defaults to 64 kB) specifies the minimum size of an address translation region. For example, if set to 64 kB; the lower 16 bits of the Base, Limit and Target registers are zero and all address regions are aligned on 64 kB boundaries. More precisely, the lower log2(CX_ATU_MIN_REGION_SIZE) bits are zero.iATU Lower Base Address Register. The CX_ATU_MIN_REGION_SIZE configuration parameter (Value Range: 4 kB, 8 kB, 16 kB, 32 kB, 64 kB defaults to 64 kB) specifies the minimum size of an address translation region. For example, if set to 64 kB; the lower 16 bits of the Base, Limit and Target registers are zero and all address regions are aligned on 64 kB boundaries. More precisely, the lower log2(CX_ATU_MIN_REGION_SIZE) bits are zero.
            }
        }
        register IATU_UPPER_BASE_ADDR_OFF_INBOUND_15 @'h1f0c {
            bytes 4;
            field UPPER_BASE_RW @'h0 {
                bits 32;
                access rw;
                hard_reset 'h0;
                doc {
                    Forms bits [63:32] of the start (and end) address of the address region to be translated.

Note: This register field is sticky.
                }
            }
            doc {
                iATU Upper Base Address Register.iATU Upper Base Address Register.
            }
        }
        register IATU_LIMIT_ADDR_OFF_INBOUND_15 @'h1f10 {
            bytes 4;
            field LIMIT_ADDR_HW @'h0 {
                bits 12;
                access ro;
                hard_reset 'h0;
                doc {
                    Forms lower bits of the end address of the address region to be translated. The end address must be aligned to a CX_ATU_MIN_REGION_SIZE kB boundary, so these bits are always all ones.
A write to this location is ignored by the PCIe controller.
                }
            }
            field LIMIT_ADDR_RW @'hc {
                bits 20;
                access rw;
                hard_reset 'h0;
                doc {
                    Forms upper bits of the end address of the address region to be translated.

Note: This register field is sticky.
                }
            }
            doc {
                iATU Limit Address Register.iATU Limit Address Register.
            }
        }
        register IATU_LWR_TARGET_ADDR_OFF_INBOUND_15 @'h1f14 {
            bytes 4;
            field LWR_TARGET_HW @'h0 {
                bits 12;
                access ro;
                hard_reset 'h0;
                doc {
                    Forms the LSB's of the Lower Target part of the new address of the translated region. The start address must be aligned to a CX_ATU_MIN_REGION_SIZE kB boundary (in address match mode); and to the Bar size boundary (in BAR match mode) so that these bits are always '0'. If the BAR is smaller than the iATU region size, then the iATU target address must align to the iATU region size; otherwise it must align to the BAR size.

A write to this location is ignored by the PCIe controller.
 - Field size depends on log2(CX_ATU_MIN_REGION_SIZE) in address match mode.
 - Field size depends on log2(BAR_MASK+1) in BAR match mode.
                }
            }
            field LWR_TARGET_RW @'hc {
                bits 20;
                access rw;
                hard_reset 'h0;
                doc {
                    Forms MSB's of the Lower Target part of the new address of the translated region. These bits are always '0'.
 - Field size depends on log2(CX_ATU_MIN_REGION_SIZE) in address match mode.
 - Field size depends on log2(BAR_MASK+1) in BAR match mode.
Note: This register field is sticky.
                }
            }
            doc {
                iATU Lower Target Address Register.iATU Lower Target Address Register.
            }
        }
        register IATU_UPPER_TARGET_ADDR_OFF_INBOUND_15 @'h1f18 {
            bytes 4;
            field UPPER_TARGET_RW @'h0 {
                bits 32;
                access rw;
                hard_reset 'h0;
                doc {
                    Forms bits [63:32] of the start address (Upper Target part) of the new address of the translated region. In systems with a 32-bit address space, this register is not used and therefore writing to this register has no effect.

Note: This register field is sticky.
                }
            }
            doc {
                iATU Upper Target Address Register.iATU Upper Target Address Register.
            }
        }
        register IATU_UPPR_LIMIT_ADDR_OFF_INBOUND_15 @'h1f20 {
            bytes 4;
            field UPPR_LIMIT_ADDR_RW @'h0 {
                bits 4;
                access rw;
                hard_reset 'h0;
                doc {
                    Forms the LSB's of the Upper Limit part of the region "end address" to be translated. Only applies to 64-bit systems and when the INCREASE_REGION_SIZE field in IATU_REGION_CTRL_1_OFF_INBOUND_i is '1'

Note: This register field is sticky.
                }
            }
            field UPPR_LIMIT_ADDR_HW @'h4 {
                bits 28;
                access ro;
                hard_reset 'h0;
                doc {
                    Forms MSB's of the Upper Limit part of the region "end address" to be translated. Only applies to 64-bit systems and when the INCREASE_REGION_SIZE field in IATU_REGION_CTRL_1_OFF_INBOUND_i is '1'. These bits are always '0'.
                }
            }
            doc {
                iATU Upper Limit Address Register. The CX_MAX_ATU_REGION_SIZE configuration parameter (Value Range: 0->32, 8=1TB) specifies the maximum region size of an address translation region. This register is only used when the INCREASE_REGION_SIZE field in IATU_REGION_CTRL_1_OFF_INBOUND_i is '1'.iATU Upper Limit Address Register. The CX_MAX_ATU_REGION_SIZE configuration parameter (Value Range: 0->32, 8=1TB) specifies the maximum region size of an address translation region. This register is only used when the INCREASE_REGION_SIZE field in IATU_REGION_CTRL_1_OFF_INBOUND_i is '1'.
            }
        }
        doc {
            ATU Por Logic Structure
        }
    }
    doc {
        DWC PCIE-EP Memory Map
    }
}

