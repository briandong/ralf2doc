regfile pcrm_regs {
	register PCRM_MCU_SCRATCH0 @'h0 {
		field PCRM_MCU_SCRATCH0 {
			bits   32;
			access rw;
			reset  'h0;
		}
	}
        register PCRM_MCU_SCRATCH1 @'h4 {
		field PCRM_MCU_SCRATCH1 {
			bits   32;
			access rw;
			reset  'h0;
		}
	}
}

block pcrm_block {
	bytes 4;
	regfile  pcrm_regs @'h0;
}

system pcrm_regmodel {
	bytes 4;
	block  pcrm_block @'h0;
}


