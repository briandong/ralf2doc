system ccf_top {
        bytes 4;
        block ecf_ccf_axi_ccf_Probe_T_cdma0_main_Probe @0xD8000 {
            bytes 4;
            register ccf_Probe_T_cdma0_main_Probe_Id_CoreId @0x0 {
                bytes 4;
                field CORETYPEID @'h0 {
                    bits 8;
                    access ro;
                    hard_reset 'h6;
                    doc {
                        Field identifying the type of IP.
                    }
                }
                field CORECHECKSUM @'h8 {
                    bits 24;
                    access ro;
                    hard_reset 'h650255;
                    doc {
                        Field containing a checksum of the parameters of the IP.
                    }
                }
            }
            register ccf_Probe_T_cdma0_main_Probe_Id_RevisionId @0x4 {
                bytes 4;
                field USERID @'h0 {
                    bits 8;
                    access ro;
                    hard_reset 'h0;
                    doc {
                        Field containing a user defined value, not used anywhere inside the IP itself.
                    }
                }
                field FLEXNOCID @'h8 {
                    bits 24;
                    access ro;
                    hard_reset 'h84f8c6;
                    doc {
                        Field containing the build revision of the software used to generate the IP HDL code.
                    }
                }
            }
            register ccf_Probe_T_cdma0_main_Probe_MainCtl @0x8 {
                bytes 4;
                field ERREN @'h0 {
                    access rw;
                    hard_reset 'h0;
                    doc {
                        Register field ErrEn enables the probe to send on the ObsTx output any packet with Error status, independently of filtering mechanisms, thus constituting a simple supplementary global filter.
                    }
                }
                field TRACEEN @'h1 {
                    access ro;
                    hard_reset 'h0;
                    doc {
                        Register field TraceEn enables the probe to send filtered packets (Trace) on the ObsTx observation output.
                    }
                }
                field PAYLOADEN @'h2 {
                    access rw;
                    hard_reset 'h0;
                    doc {
                        Register field PayloadEn, when set to 1, enables traces to contain headers and payload. When set ot 0, only headers are reported.
                    }
                }
                field STATEN @'h3 {
                    access rw;
                    hard_reset 'h0;
                    doc {
                        When set to 1, register field StatEn enables statistics profiling. The probe sendS statistics results to the output for signal ObsTx. All statistics counters are cleared when the StatEn bit goes from 0 to 1. When set to 0, counters are disabled.
                    }
                }
                field ALARMEN @'h4 {
                    access rw;
                    hard_reset 'h0;
                    doc {
                        When set, register field AlarmEn enables the probe to collect alarm-related information. When the register field bit is null, both TraceAlarm and StatAlarm outputs are driven to 0.
                    }
                }
                field STATCONDDUMP @'h5 {
                    access rw;
                    hard_reset 'h0;
                    doc {
                        When set, register field StatCondDump enables the dump of a statistics frame to the range of counter values set for registers StatAlarmMin, StatAlarmMax, and AlarmMode. This field also renders register StatAlarmStatus inoperative. When parameter statisticsCounterAlarm is set to False, the StatCondDump register bit is reserved.
                    }
                }
                field INTRUSIVEMODE @'h6 {
                    access ro;
                    hard_reset 'h0;
                    doc {
                        When set to 1, register field IntrusiveMode enables trace operation in Intrusive flow-control mode. When set to 0, the register  enables trace operation in Overflow flow-control mode
                    }
                }
                field FILTBYTEALWAYSCHAINABLEEN @'h7 {
                    access rw;
                    hard_reset 'h0;
                    doc {
                        When set to 0, filters are mapped to all statistic counters when counting bytes or enabled bytes. Therefore, only filter events mapped to even counters can be counted using a pair of chained counters.When set to 1, filters are mapped only to even statistic counters when counting bytes or enabled bytes. Thus events from any filter can be counted using a pair of chained counters.
                    }
                }
                doc {
                    Register MainCtl contains probe global control bits. The register has seven bit fields:Register MainCtl contains probe global control bits. The register has seven bit fields:
                }
            }
            register ccf_Probe_T_cdma0_main_Probe_CfgCtl @0xC {
                bytes 4;
                field GLOBALEN @'h0 {
                    access rw;
                    hard_reset 'h0;
                }
                field ACTIVE @'h1 {
                    access ro;
                    hard_reset 'h0;
                }
            }
            register ccf_Probe_T_cdma0_main_Probe_Reserved_00 @0x10 {
                bytes 4;
                field ccf_Probe_T_cdma0_main_Probe_Reserved_00 {
                    bits 32;
                    access rw;
                    hard_reset 'h0;
                }
            }
            register ccf_Probe_T_cdma0_main_Probe_Reserved_01 @0x14 {
                bytes 4;
                field ccf_Probe_T_cdma0_main_Probe_Reserved_01 {
                    bits 32;
                    access rw;
                    hard_reset 'h0;
                }
            }
            register ccf_Probe_T_cdma0_main_Probe_Reserved_02 @0x18 {
                bytes 4;
                field ccf_Probe_T_cdma0_main_Probe_Reserved_02 {
                    bits 32;
                    access rw;
                    hard_reset 'h0;
                }
            }
            register ccf_Probe_T_cdma0_main_Probe_Reserved_03 @0x1C {
                bytes 4;
                field ccf_Probe_T_cdma0_main_Probe_Reserved_03 {
                    bits 32;
                    access rw;
                    hard_reset 'h0;
                }
            }
            register ccf_Probe_T_cdma0_main_Probe_Reserved_04 @0x20 {
                bytes 4;
                field ccf_Probe_T_cdma0_main_Probe_Reserved_04 {
                    bits 32;
                    access rw;
                    hard_reset 'h0;
                }
            }
            register ccf_Probe_T_cdma0_main_Probe_StatPeriod @0x24 {
                bytes 4;
                field STATPERIOD @'h0 {
                    bits 5;
                    access rw;
                    hard_reset 'h0;
                    doc {
                        Register StatPeriod is a 5-bit register that sets a period, within a range of 2 cycles to 2 gigacycles, during which statistics are collected before being dumped automatically. Setting the register implicitly enables automatic mode operation for statistics collection. The period is calculated with the formula: N_Cycle = 2**StatPeriodWhen register StatPeriod is set to its default value 0, automatic dump mode is disabled, and register StatGo is activated for manual mode operation. Note: When parameter statisticsCollection is set to False, StatPeriod is reserved.
                    }
                }
            }
            register ccf_Probe_T_cdma0_main_Probe_StatGo @0x28 {
                bytes 4;
                field STATGO @'h0 {
                    access w1c;
                    hard_reset 'h0;
                    doc {
                        Writing a 1 to the 1-bit pulse register StatGo generates a statistics dump.The register is active when statistics collection operates in manual mode, that is, when register StatPeriod is set to 0.NOTE  The written value is not stored in StatGo. A read always returns 0.
                    }
                }
            }
            register ccf_Probe_T_cdma0_main_Probe_StatAlarmMin @0x2C {
                bytes 4;
                field STATALARMMIN @'h0 {
                    bits 22;
                    access rw;
                    hard_reset 'h0;
                    doc {
                        Register StatAlarmMin contains the minimum count value used in statistics alarm comparisons. The number of bits is equal to twice the value set forparameter wStatisticsCounter. When parameter statisticsCounterAlarm is set to False, StatAlarmMin is reserved.
                    }
                }
            }
            register ccf_Probe_T_cdma0_main_Probe_StatAlarmMax @0x30 {
                bytes 4;
                field STATALARMMAX @'h0 {
                    bits 22;
                    access rw;
                    hard_reset 'h0;
                    doc {
                        Register StatAlarmMax contains the maximum count value used in statistics alarm comparisons.The number of bits is equal to twice the value set for parameter wStatisticsCounter. When parameter statisticsCounterAlarm is set to False, StatAlarmMax is reserved.
                    }
                }
            }
            register ccf_Probe_T_cdma0_main_Probe_StatAlarmStatus @0x34 {
                bytes 4;
                field STATALARMSTATUS @'h0 {
                    access ro;
                    hard_reset 'h0;
                    doc {
                        Register StatAlarmStatus is a read-only 1-bit register indicating that at least one statistics counter has exceeded the programmed values for registers StatAlarmMin or StatAlarmMax. Output signal StatAlarm is equal to the values stored in register MainCtl fields StatAlarmStatus and AlarmEn. When parameter statisticsCounterAlarm is set to False, StatAlarmStatus is reserved.
                    }
                }
            }
            register ccf_Probe_T_cdma0_main_Probe_StatAlarmClr @0x38 {
                bytes 4;
                field STATALARMCLR @'h0 {
                    access w1c;
                    hard_reset 'h0;
                    doc {
                        Register StatAlarmClr is a 1-bit register. Writing a 1 to this register clears the StatAlarmStatus register bit.When parameter statisticsCounterAlarm is set to False, StatAlarmClr is reserved.NOTE  The written value is not stored in StatAlarmClr. A read always returns 0.
                    }
                }
            }
            register ccf_Probe_T_cdma0_main_Probe_StatAlarmEn @0x3C {
                bytes 4;
                field STATALARMEN @'h0 {
                    access rw;
                    hard_reset 'h1;
                    doc {
                        Register StatAlarmEn is a 1-bit register. When set to 0 it masks StatAlarm and CtiTrigOut(1) signal interrupts.
                    }
                }
            }
            register ccf_Probe_T_cdma0_main_Probe_Reserved_05 @0x40 {
                bytes 4;
                field ccf_Probe_T_cdma0_main_Probe_Reserved_05 {
                    bits 32;
                    access rw;
                    hard_reset 'h0;
                }
            }
            register ccf_Probe_T_cdma0_main_Probe_Reserved_06 @0x44 {
                bytes 4;
                field ccf_Probe_T_cdma0_main_Probe_Reserved_06 {
                    bits 32;
                    access rw;
                    hard_reset 'h0;
                }
            }
            register ccf_Probe_T_cdma0_main_Probe_Reserved_07 @0x48 {
                bytes 4;
                field ccf_Probe_T_cdma0_main_Probe_Reserved_07 {
                    bits 32;
                    access rw;
                    hard_reset 'h0;
                }
            }
            register ccf_Probe_T_cdma0_main_Probe_Reserved_08 @0x4C {
                bytes 4;
                field ccf_Probe_T_cdma0_main_Probe_Reserved_08 {
                    bits 32;
                    access rw;
                    hard_reset 'h0;
                }
            }
            register ccf_Probe_T_cdma0_main_Probe_Reserved_09 @0x50 {
                bytes 4;
                field ccf_Probe_T_cdma0_main_Probe_Reserved_09 {
                    bits 32;
                    access rw;
                    hard_reset 'h0;
                }
            }
            register ccf_Probe_T_cdma0_main_Probe_Reserved_10 @0x54 {
                bytes 4;
                field ccf_Probe_T_cdma0_main_Probe_Reserved_10 {
                    bits 32;
                    access rw;
                    hard_reset 'h0;
                }
            }
            register ccf_Probe_T_cdma0_main_Probe_Reserved_11 @0x58 {
                bytes 4;
                field ccf_Probe_T_cdma0_main_Probe_Reserved_11 {
                    bits 32;
                    access rw;
                    hard_reset 'h0;
                }
            }
            register ccf_Probe_T_cdma0_main_Probe_Reserved_12 @0x5C {
                bytes 4;
                field ccf_Probe_T_cdma0_main_Probe_Reserved_12 {
                    bits 32;
                    access rw;
                    hard_reset 'h0;
                }
            }
            register ccf_Probe_T_cdma0_main_Probe_Reserved_13 @0x60 {
                bytes 4;
                field ccf_Probe_T_cdma0_main_Probe_Reserved_13 {
                    bits 32;
                    access rw;
                    hard_reset 'h0;
                }
            }
            register ccf_Probe_T_cdma0_main_Probe_Reserved_14 @0x64 {
                bytes 4;
                field ccf_Probe_T_cdma0_main_Probe_Reserved_14 {
                    bits 32;
                    access rw;
                    hard_reset 'h0;
                }
            }
            register ccf_Probe_T_cdma0_main_Probe_Reserved_15 @0x68 {
                bytes 4;
                field ccf_Probe_T_cdma0_main_Probe_Reserved_15 {
                    bits 32;
                    access rw;
                    hard_reset 'h0;
                }
            }
            register ccf_Probe_T_cdma0_main_Probe_Reserved_16 @0x6C {
                bytes 4;
                field ccf_Probe_T_cdma0_main_Probe_Reserved_16 {
                    bits 32;
                    access rw;
                    hard_reset 'h0;
                }
            }
            register ccf_Probe_T_cdma0_main_Probe_Reserved_17 @0x70 {
                bytes 4;
                field ccf_Probe_T_cdma0_main_Probe_Reserved_17 {
                    bits 32;
                    access rw;
                    hard_reset 'h0;
                }
            }
            register ccf_Probe_T_cdma0_main_Probe_Reserved_18 @0x74 {
                bytes 4;
                field ccf_Probe_T_cdma0_main_Probe_Reserved_18 {
                    bits 32;
                    access rw;
                    hard_reset 'h0;
                }
            }
            register ccf_Probe_T_cdma0_main_Probe_Reserved_19 @0x78 {
                bytes 4;
                field ccf_Probe_T_cdma0_main_Probe_Reserved_19 {
                    bits 32;
                    access rw;
                    hard_reset 'h0;
                }
            }
            register ccf_Probe_T_cdma0_main_Probe_Reserved_20 @0x7C {
                bytes 4;
                field ccf_Probe_T_cdma0_main_Probe_Reserved_20 {
                    bits 32;
                    access rw;
                    hard_reset 'h0;
                }
            }
            register ccf_Probe_T_cdma0_main_Probe_Reserved_21 @0x80 {
                bytes 4;
                field ccf_Probe_T_cdma0_main_Probe_Reserved_21 {
                    bits 32;
                    access rw;
                    hard_reset 'h0;
                }
            }
            register ccf_Probe_T_cdma0_main_Probe_Reserved_22 @0x84 {
                bytes 4;
                field ccf_Probe_T_cdma0_main_Probe_Reserved_22 {
                    bits 32;
                    access rw;
                    hard_reset 'h0;
                }
            }
            register ccf_Probe_T_cdma0_main_Probe_Reserved_23 @0x88 {
                bytes 4;
                field ccf_Probe_T_cdma0_main_Probe_Reserved_23 {
                    bits 32;
                    access rw;
                    hard_reset 'h0;
                }
            }
            register ccf_Probe_T_cdma0_main_Probe_Reserved_24 @0x8C {
                bytes 4;
                field ccf_Probe_T_cdma0_main_Probe_Reserved_24 {
                    bits 32;
                    access rw;
                    hard_reset 'h0;
                }
            }
            register ccf_Probe_T_cdma0_main_Probe_Reserved_25 @0x90 {
                bytes 4;
                field ccf_Probe_T_cdma0_main_Probe_Reserved_25 {
                    bits 32;
                    access rw;
                    hard_reset 'h0;
                }
            }
            register ccf_Probe_T_cdma0_main_Probe_Reserved_26 @0x94 {
                bytes 4;
                field ccf_Probe_T_cdma0_main_Probe_Reserved_26 {
                    bits 32;
                    access rw;
                    hard_reset 'h0;
                }
            }
            register ccf_Probe_T_cdma0_main_Probe_Reserved_27 @0x98 {
                bytes 4;
                field ccf_Probe_T_cdma0_main_Probe_Reserved_27 {
                    bits 32;
                    access rw;
                    hard_reset 'h0;
                }
            }
            register ccf_Probe_T_cdma0_main_Probe_Reserved_28 @0x9C {
                bytes 4;
                field ccf_Probe_T_cdma0_main_Probe_Reserved_28 {
                    bits 32;
                    access rw;
                    hard_reset 'h0;
                }
            }
            register ccf_Probe_T_cdma0_main_Probe_Reserved_29 @0xA0 {
                bytes 4;
                field ccf_Probe_T_cdma0_main_Probe_Reserved_29 {
                    bits 32;
                    access rw;
                    hard_reset 'h0;
                }
            }
            register ccf_Probe_T_cdma0_main_Probe_Reserved_30 @0xA4 {
                bytes 4;
                field ccf_Probe_T_cdma0_main_Probe_Reserved_30 {
                    bits 32;
                    access rw;
                    hard_reset 'h0;
                }
            }
            register ccf_Probe_T_cdma0_main_Probe_Reserved_31 @0xA8 {
                bytes 4;
                field ccf_Probe_T_cdma0_main_Probe_Reserved_31 {
                    bits 32;
                    access rw;
                    hard_reset 'h0;
                }
            }
            register ccf_Probe_T_cdma0_main_Probe_Reserved_32 @0xAC {
                bytes 4;
                field ccf_Probe_T_cdma0_main_Probe_Reserved_32 {
                    bits 32;
                    access rw;
                    hard_reset 'h0;
                }
            }
            register ccf_Probe_T_cdma0_main_Probe_Reserved_33 @0xB0 {
                bytes 4;
                field ccf_Probe_T_cdma0_main_Probe_Reserved_33 {
                    bits 32;
                    access rw;
                    hard_reset 'h0;
                }
            }
            register ccf_Probe_T_cdma0_main_Probe_Reserved_34 @0xB4 {
                bytes 4;
                field ccf_Probe_T_cdma0_main_Probe_Reserved_34 {
                    bits 32;
                    access rw;
                    hard_reset 'h0;
                }
            }
            register ccf_Probe_T_cdma0_main_Probe_Reserved_35 @0xB8 {
                bytes 4;
                field ccf_Probe_T_cdma0_main_Probe_Reserved_35 {
                    bits 32;
                    access rw;
                    hard_reset 'h0;
                }
            }
            register ccf_Probe_T_cdma0_main_Probe_Reserved_36 @0xBC {
                bytes 4;
                field ccf_Probe_T_cdma0_main_Probe_Reserved_36 {
                    bits 32;
                    access rw;
                    hard_reset 'h0;
                }
            }
            register ccf_Probe_T_cdma0_main_Probe_Reserved_37 @0xC0 {
                bytes 4;
                field ccf_Probe_T_cdma0_main_Probe_Reserved_37 {
                    bits 32;
                    access rw;
                    hard_reset 'h0;
                }
            }
            register ccf_Probe_T_cdma0_main_Probe_Reserved_38 @0xC4 {
                bytes 4;
                field ccf_Probe_T_cdma0_main_Probe_Reserved_38 {
                    bits 32;
                    access rw;
                    hard_reset 'h0;
                }
            }
            register ccf_Probe_T_cdma0_main_Probe_Reserved_39 @0xC8 {
                bytes 4;
                field ccf_Probe_T_cdma0_main_Probe_Reserved_39 {
                    bits 32;
                    access rw;
                    hard_reset 'h0;
                }
            }
            register ccf_Probe_T_cdma0_main_Probe_Reserved_40 @0xCC {
                bytes 4;
                field ccf_Probe_T_cdma0_main_Probe_Reserved_40 {
                    bits 32;
                    access rw;
                    hard_reset 'h0;
                }
            }
            register ccf_Probe_T_cdma0_main_Probe_Reserved_41 @0xD0 {
                bytes 4;
                field ccf_Probe_T_cdma0_main_Probe_Reserved_41 {
                    bits 32;
                    access rw;
                    hard_reset 'h0;
                }
            }
            register ccf_Probe_T_cdma0_main_Probe_Reserved_42 @0xD4 {
                bytes 4;
                field ccf_Probe_T_cdma0_main_Probe_Reserved_42 {
                    bits 32;
                    access rw;
                    hard_reset 'h0;
                }
            }
            register ccf_Probe_T_cdma0_main_Probe_Reserved_43 @0xD8 {
                bytes 4;
                field ccf_Probe_T_cdma0_main_Probe_Reserved_43 {
                    bits 32;
                    access rw;
                    hard_reset 'h0;
                }
            }
            register ccf_Probe_T_cdma0_main_Probe_Reserved_44 @0xDC {
                bytes 4;
                field ccf_Probe_T_cdma0_main_Probe_Reserved_44 {
                    bits 32;
                    access rw;
                    hard_reset 'h0;
                }
            }
            register ccf_Probe_T_cdma0_main_Probe_Reserved_45 @0xE0 {
                bytes 4;
                field ccf_Probe_T_cdma0_main_Probe_Reserved_45 {
                    bits 32;
                    access rw;
                    hard_reset 'h0;
                }
            }
            register ccf_Probe_T_cdma0_main_Probe_Reserved_46 @0xE4 {
                bytes 4;
                field ccf_Probe_T_cdma0_main_Probe_Reserved_46 {
                    bits 32;
                    access rw;
                    hard_reset 'h0;
                }
            }
            register ccf_Probe_T_cdma0_main_Probe_Reserved_47 @0xE8 {
                bytes 4;
                field ccf_Probe_T_cdma0_main_Probe_Reserved_47 {
                    bits 32;
                    access rw;
                    hard_reset 'h0;
                }
            }
            register ccf_Probe_T_cdma0_main_Probe_Reserved_48 @0xEC {
                bytes 4;
                field ccf_Probe_T_cdma0_main_Probe_Reserved_48 {
                    bits 32;
                    access rw;
                    hard_reset 'h0;
                }
            }
            register ccf_Probe_T_cdma0_main_Probe_Reserved_49 @0xF0 {
                bytes 4;
                field ccf_Probe_T_cdma0_main_Probe_Reserved_49 {
                    bits 32;
                    access rw;
                    hard_reset 'h0;
                }
            }
            register ccf_Probe_T_cdma0_main_Probe_Reserved_50 @0xF4 {
                bytes 4;
                field ccf_Probe_T_cdma0_main_Probe_Reserved_50 {
                    bits 32;
                    access rw;
                    hard_reset 'h0;
                }
            }
            register ccf_Probe_T_cdma0_main_Probe_Reserved_51 @0xF8 {
                bytes 4;
                field ccf_Probe_T_cdma0_main_Probe_Reserved_51 {
                    bits 32;
                    access rw;
                    hard_reset 'h0;
                }
            }
            register ccf_Probe_T_cdma0_main_Probe_Reserved_52 @0xFC {
                bytes 4;
                field ccf_Probe_T_cdma0_main_Probe_Reserved_52 {
                    bits 32;
                    access rw;
                    hard_reset 'h0;
                }
            }
            register ccf_Probe_T_cdma0_main_Probe_Reserved_53 @0x100 {
                bytes 4;
                field ccf_Probe_T_cdma0_main_Probe_Reserved_53 {
                    bits 32;
                    access rw;
                    hard_reset 'h0;
                }
            }
            register ccf_Probe_T_cdma0_main_Probe_Reserved_54 @0x104 {
                bytes 4;
                field ccf_Probe_T_cdma0_main_Probe_Reserved_54 {
                    bits 32;
                    access rw;
                    hard_reset 'h0;
                }
            }
            register ccf_Probe_T_cdma0_main_Probe_Reserved_55 @0x108 {
                bytes 4;
                field ccf_Probe_T_cdma0_main_Probe_Reserved_55 {
                    bits 32;
                    access rw;
                    hard_reset 'h0;
                }
            }
            register ccf_Probe_T_cdma0_main_Probe_Reserved_56 @0x10C {
                bytes 4;
                field ccf_Probe_T_cdma0_main_Probe_Reserved_56 {
                    bits 32;
                    access rw;
                    hard_reset 'h0;
                }
            }
            register ccf_Probe_T_cdma0_main_Probe_Reserved_57 @0x110 {
                bytes 4;
                field ccf_Probe_T_cdma0_main_Probe_Reserved_57 {
                    bits 32;
                    access rw;
                    hard_reset 'h0;
                }
            }
            register ccf_Probe_T_cdma0_main_Probe_Reserved_58 @0x114 {
                bytes 4;
                field ccf_Probe_T_cdma0_main_Probe_Reserved_58 {
                    bits 32;
                    access rw;
                    hard_reset 'h0;
                }
            }
            register ccf_Probe_T_cdma0_main_Probe_Reserved_59 @0x118 {
                bytes 4;
                field ccf_Probe_T_cdma0_main_Probe_Reserved_59 {
                    bits 32;
                    access rw;
                    hard_reset 'h0;
                }
            }
            register ccf_Probe_T_cdma0_main_Probe_Reserved_60 @0x11C {
                bytes 4;
                field ccf_Probe_T_cdma0_main_Probe_Reserved_60 {
                    bits 32;
                    access rw;
                    hard_reset 'h0;
                }
            }
            register ccf_Probe_T_cdma0_main_Probe_Reserved_61 @0x120 {
                bytes 4;
                field ccf_Probe_T_cdma0_main_Probe_Reserved_61 {
                    bits 32;
                    access rw;
                    hard_reset 'h0;
                }
            }
            register ccf_Probe_T_cdma0_main_Probe_Reserved_62 @0x124 {
                bytes 4;
                field ccf_Probe_T_cdma0_main_Probe_Reserved_62 {
                    bits 32;
                    access rw;
                    hard_reset 'h0;
                }
            }
            register ccf_Probe_T_cdma0_main_Probe_Reserved_63 @0x128 {
                bytes 4;
                field ccf_Probe_T_cdma0_main_Probe_Reserved_63 {
                    bits 32;
                    access rw;
                    hard_reset 'h0;
                }
            }
            register ccf_Probe_T_cdma0_main_Probe_Reserved_64 @0x12C {
                bytes 4;
                field ccf_Probe_T_cdma0_main_Probe_Reserved_64 {
                    bits 32;
                    access rw;
                    hard_reset 'h0;
                }
            }
            register ccf_Probe_T_cdma0_main_Probe_Reserved_65 @0x130 {
                bytes 4;
                field ccf_Probe_T_cdma0_main_Probe_Reserved_65 {
                    bits 32;
                    access rw;
                    hard_reset 'h0;
                }
            }
            register ccf_Probe_T_cdma0_main_Probe_Reserved_66 @0x134 {
                bytes 4;
                field ccf_Probe_T_cdma0_main_Probe_Reserved_66 {
                    bits 32;
                    access rw;
                    hard_reset 'h0;
                }
            }
            register ccf_Probe_T_cdma0_main_Probe_Counters_0_Src @0x138 {
                bytes 4;
                field INTEVENT @'h0 {
                    bits 5;
                    access rw;
                    hard_reset 'h0;
                    enum { OFF = 0, CYCLE = 1, IDLE = 2, XFER = 3, BUSY = 4, WAIT = 5, PKT = 6, LUT = 7, BYTE = 8, PRESS0 = 9, PRESS1 = 10, PRESS2 = 11, FILT0 = 12, FILT1 = 13, FILT2 = 14, FILT3 = 15, CHAIN = 16, LUT_BYTE_EN = 17, LUT_BYTE = 18, FILT_BYTE_EN = 19, FILT_BYTE = 20, PRESS3 = 21, PRESS4 = 22, PRESS5 = 23, PRESS6 = 24, RSV_0 = 25, RSV_1 = 26, RSV_2 = 27, RSV_3 = 28, RSV_4 = 29, RSV_5 = 30, RSV_6 = 31 };
                    doc {
                        Internal packet event
                    }
                }
                field EXTEVENT @'h5 {
                    access rw;
                    hard_reset 'h0;
                    doc {
                        When greater than 0, the entire register value is used to select an external hardware event source. The index of the external event is equal to {ExtEvent,IntEvent}.
                    }
                }
                doc {
                    Register CntSrc indicates the event source used to increment the counter. Unassigned values (non-existing Press level or ExtEvent index, or unimplemented Filter) are equivalent to OFF.
	Register CntSrc indicates the event source used to increment the counter. Unassigned values (non-existing Press level or ExtEvent index, or unimplemented Filter) are equivalent to OFF.
	
                }
            }
            register ccf_Probe_T_cdma0_main_Probe_Counters_0_AlarmMode @0x13C {
                bytes 4;
                field COUNTERS_0_ALARMMODE @'h0 {
                    bits 2;
                    access rw;
                    hard_reset 'h0;
                    enum { OFF = 0, MIN = 1, MAX = 2, MIN_MAX = 3 };
                    doc {
                        Register AlarmMode is a 2-bit register that is present when parameter statisticsCounterAlarm is set to True. The register defines the statistics-alarm behavior of the counter.
                    }
                }
            }
            register ccf_Probe_T_cdma0_main_Probe_Counters_0_Val @0x140 {
                bytes 4;
                field COUNTERS_0_VAL @'h0 {
                    bits 11;
                    access ro;
                    hard_reset 'h0;
                    doc {
                        Register Val is a read-only register that is always present. The register containsthe statistics counter value either pending StatAlarm output, or when statisticscollection is suspended subsequent to triggers or signal statSuspend.
                    }
                }
            }
            register ccf_Probe_T_cdma0_main_Probe_Reserved_67 @0x144 {
                bytes 4;
                field ccf_Probe_T_cdma0_main_Probe_Reserved_67 {
                    bits 32;
                    access rw;
                    hard_reset 'h0;
                }
            }
            register ccf_Probe_T_cdma0_main_Probe_Reserved_68 @0x148 {
                bytes 4;
                field ccf_Probe_T_cdma0_main_Probe_Reserved_68 {
                    bits 32;
                    access rw;
                    hard_reset 'h0;
                }
            }
            register ccf_Probe_T_cdma0_main_Probe_Counters_1_Src @0x14C {
                bytes 4;
                field INTEVENT @'h0 {
                    bits 5;
                    access rw;
                    hard_reset 'h0;
                    enum { OFF = 0, CYCLE = 1, IDLE = 2, XFER = 3, BUSY = 4, WAIT = 5, PKT = 6, LUT = 7, BYTE = 8, PRESS0 = 9, PRESS1 = 10, PRESS2 = 11, FILT0 = 12, FILT1 = 13, FILT2 = 14, FILT3 = 15, CHAIN = 16, LUT_BYTE_EN = 17, LUT_BYTE = 18, FILT_BYTE_EN = 19, FILT_BYTE = 20, PRESS3 = 21, PRESS4 = 22, PRESS5 = 23, PRESS6 = 24, RSV_0 = 25, RSV_1 = 26, RSV_2 = 27, RSV_3 = 28, RSV_4 = 29, RSV_5 = 30, RSV_6 = 31 };
                    doc {
                        Internal packet event
                    }
                }
                field EXTEVENT @'h5 {
                    access rw;
                    hard_reset 'h0;
                    doc {
                        When greater than 0, the entire register value is used to select an external hardware event source. The index of the external event is equal to {ExtEvent,IntEvent}.
                    }
                }
                doc {
                    Register CntSrc indicates the event source used to increment the counter. Unassigned values (non-existing Press level or ExtEvent index, or unimplemented Filter) are equivalent to OFF.
	Register CntSrc indicates the event source used to increment the counter. Unassigned values (non-existing Press level or ExtEvent index, or unimplemented Filter) are equivalent to OFF.
	
                }
            }
            register ccf_Probe_T_cdma0_main_Probe_Counters_1_AlarmMode @0x150 {
                bytes 4;
                field COUNTERS_1_ALARMMODE @'h0 {
                    bits 2;
                    access rw;
                    hard_reset 'h0;
                    enum { OFF = 0, MIN = 1, MAX = 2, MIN_MAX = 3 };
                    doc {
                        Register AlarmMode is a 2-bit register that is present when parameter statisticsCounterAlarm is set to True. The register defines the statistics-alarm behavior of the counter.
                    }
                }
            }
            register ccf_Probe_T_cdma0_main_Probe_Counters_1_Val @0x154 {
                bytes 4;
                field COUNTERS_1_VAL @'h0 {
                    bits 11;
                    access ro;
                    hard_reset 'h0;
                    doc {
                        Register Val is a read-only register that is always present. The register containsthe statistics counter value either pending StatAlarm output, or when statisticscollection is suspended subsequent to triggers or signal statSuspend.
                    }
                }
            }
            register ccf_Probe_T_cdma0_main_Probe_Reserved_69 @0x158 {
                bytes 4;
                field ccf_Probe_T_cdma0_main_Probe_Reserved_69 {
                    bits 32;
                    access rw;
                    hard_reset 'h0;
                }
            }
            register ccf_Probe_T_cdma0_main_Probe_Reserved_70 @0x15C {
                bytes 4;
                field ccf_Probe_T_cdma0_main_Probe_Reserved_70 {
                    bits 32;
                    access rw;
                    hard_reset 'h0;
                }
            }
            register ccf_Probe_T_cdma0_main_Probe_Reserved_71 @0x160 {
                bytes 4;
                field ccf_Probe_T_cdma0_main_Probe_Reserved_71 {
                    bits 32;
                    access rw;
                    hard_reset 'h0;
                }
            }
            register ccf_Probe_T_cdma0_main_Probe_Reserved_72 @0x164 {
                bytes 4;
                field ccf_Probe_T_cdma0_main_Probe_Reserved_72 {
                    bits 32;
                    access rw;
                    hard_reset 'h0;
                }
            }
            register ccf_Probe_T_cdma0_main_Probe_Reserved_73 @0x168 {
                bytes 4;
                field ccf_Probe_T_cdma0_main_Probe_Reserved_73 {
                    bits 32;
                    access rw;
                    hard_reset 'h0;
                }
            }
            register ccf_Probe_T_cdma0_main_Probe_Reserved_74 @0x16C {
                bytes 4;
                field ccf_Probe_T_cdma0_main_Probe_Reserved_74 {
                    bits 32;
                    access rw;
                    hard_reset 'h0;
                }
            }
            register ccf_Probe_T_cdma0_main_Probe_Reserved_75 @0x170 {
                bytes 4;
                field ccf_Probe_T_cdma0_main_Probe_Reserved_75 {
                    bits 32;
                    access rw;
                    hard_reset 'h0;
                }
            }
            register ccf_Probe_T_cdma0_main_Probe_Reserved_76 @0x174 {
                bytes 4;
                field ccf_Probe_T_cdma0_main_Probe_Reserved_76 {
                    bits 32;
                    access rw;
                    hard_reset 'h0;
                }
            }
            register ccf_Probe_T_cdma0_main_Probe_Reserved_77 @0x178 {
                bytes 4;
                field ccf_Probe_T_cdma0_main_Probe_Reserved_77 {
                    bits 32;
                    access rw;
                    hard_reset 'h0;
                }
            }
            register ccf_Probe_T_cdma0_main_Probe_Reserved_78 @0x17C {
                bytes 4;
                field ccf_Probe_T_cdma0_main_Probe_Reserved_78 {
                    bits 32;
                    access rw;
                    hard_reset 'h0;
                }
            }
            register ccf_Probe_T_cdma0_main_Probe_Reserved_79 @0x180 {
                bytes 4;
                field ccf_Probe_T_cdma0_main_Probe_Reserved_79 {
                    bits 32;
                    access rw;
                    hard_reset 'h0;
                }
            }
            register ccf_Probe_T_cdma0_main_Probe_Reserved_80 @0x184 {
                bytes 4;
                field ccf_Probe_T_cdma0_main_Probe_Reserved_80 {
                    bits 32;
                    access rw;
                    hard_reset 'h0;
                }
            }
            register ccf_Probe_T_cdma0_main_Probe_Reserved_81 @0x188 {
                bytes 4;
                field ccf_Probe_T_cdma0_main_Probe_Reserved_81 {
                    bits 32;
                    access rw;
                    hard_reset 'h0;
                }
            }
            register ccf_Probe_T_cdma0_main_Probe_Reserved_82 @0x18C {
                bytes 4;
                field ccf_Probe_T_cdma0_main_Probe_Reserved_82 {
                    bits 32;
                    access rw;
                    hard_reset 'h0;
                }
            }
            register ccf_Probe_T_cdma0_main_Probe_Reserved_83 @0x190 {
                bytes 4;
                field ccf_Probe_T_cdma0_main_Probe_Reserved_83 {
                    bits 32;
                    access rw;
                    hard_reset 'h0;
                }
            }
            register ccf_Probe_T_cdma0_main_Probe_Reserved_84 @0x194 {
                bytes 4;
                field ccf_Probe_T_cdma0_main_Probe_Reserved_84 {
                    bits 32;
                    access rw;
                    hard_reset 'h0;
                }
            }
            register ccf_Probe_T_cdma0_main_Probe_Reserved_85 @0x198 {
                bytes 4;
                field ccf_Probe_T_cdma0_main_Probe_Reserved_85 {
                    bits 32;
                    access rw;
                    hard_reset 'h0;
                }
            }
            register ccf_Probe_T_cdma0_main_Probe_Reserved_86 @0x19C {
                bytes 4;
                field ccf_Probe_T_cdma0_main_Probe_Reserved_86 {
                    bits 32;
                    access rw;
                    hard_reset 'h0;
                }
            }
            register ccf_Probe_T_cdma0_main_Probe_Reserved_87 @0x1A0 {
                bytes 4;
                field ccf_Probe_T_cdma0_main_Probe_Reserved_87 {
                    bits 32;
                    access rw;
                    hard_reset 'h0;
                }
            }
            register ccf_Probe_T_cdma0_main_Probe_Reserved_88 @0x1A4 {
                bytes 4;
                field ccf_Probe_T_cdma0_main_Probe_Reserved_88 {
                    bits 32;
                    access rw;
                    hard_reset 'h0;
                }
            }
            register ccf_Probe_T_cdma0_main_Probe_Reserved_89 @0x1A8 {
                bytes 4;
                field ccf_Probe_T_cdma0_main_Probe_Reserved_89 {
                    bits 32;
                    access rw;
                    hard_reset 'h0;
                }
            }
            register ccf_Probe_T_cdma0_main_Probe_Reserved_90 @0x1AC {
                bytes 4;
                field ccf_Probe_T_cdma0_main_Probe_Reserved_90 {
                    bits 32;
                    access rw;
                    hard_reset 'h0;
                }
            }
            register ccf_Probe_T_cdma0_main_Probe_Reserved_91 @0x1B0 {
                bytes 4;
                field ccf_Probe_T_cdma0_main_Probe_Reserved_91 {
                    bits 32;
                    access rw;
                    hard_reset 'h0;
                }
            }
            register ccf_Probe_T_cdma0_main_Probe_Reserved_92 @0x1B4 {
                bytes 4;
                field ccf_Probe_T_cdma0_main_Probe_Reserved_92 {
                    bits 32;
                    access rw;
                    hard_reset 'h0;
                }
            }
            register ccf_Probe_T_cdma0_main_Probe_Reserved_93 @0x1B8 {
                bytes 4;
                field ccf_Probe_T_cdma0_main_Probe_Reserved_93 {
                    bits 32;
                    access rw;
                    hard_reset 'h0;
                }
            }
            register ccf_Probe_T_cdma0_main_Probe_Reserved_94 @0x1BC {
                bytes 4;
                field ccf_Probe_T_cdma0_main_Probe_Reserved_94 {
                    bits 32;
                    access rw;
                    hard_reset 'h0;
                }
            }
            register ccf_Probe_T_cdma0_main_Probe_Reserved_95 @0x1C0 {
                bytes 4;
                field ccf_Probe_T_cdma0_main_Probe_Reserved_95 {
                    bits 32;
                    access rw;
                    hard_reset 'h0;
                }
            }
            register ccf_Probe_T_cdma0_main_Probe_Reserved_96 @0x1C4 {
                bytes 4;
                field ccf_Probe_T_cdma0_main_Probe_Reserved_96 {
                    bits 32;
                    access rw;
                    hard_reset 'h0;
                }
            }
            register ccf_Probe_T_cdma0_main_Probe_Reserved_97 @0x1C8 {
                bytes 4;
                field ccf_Probe_T_cdma0_main_Probe_Reserved_97 {
                    bits 32;
                    access rw;
                    hard_reset 'h0;
                }
            }
            register ccf_Probe_T_cdma0_main_Probe_Reserved_98 @0x1CC {
                bytes 4;
                field ccf_Probe_T_cdma0_main_Probe_Reserved_98 {
                    bits 32;
                    access rw;
                    hard_reset 'h0;
                }
            }
            register ccf_Probe_T_cdma0_main_Probe_Reserved_99 @0x1D0 {
                bytes 4;
                field ccf_Probe_T_cdma0_main_Probe_Reserved_99 {
                    bits 32;
                    access rw;
                    hard_reset 'h0;
                }
            }
            register ccf_Probe_T_cdma0_main_Probe_Reserved_100 @0x1D4 {
                bytes 4;
                field ccf_Probe_T_cdma0_main_Probe_Reserved_100 {
                    bits 32;
                    access rw;
                    hard_reset 'h0;
                }
            }
            register ccf_Probe_T_cdma0_main_Probe_Reserved_101 @0x1D8 {
                bytes 4;
                field ccf_Probe_T_cdma0_main_Probe_Reserved_101 {
                    bits 32;
                    access rw;
                    hard_reset 'h0;
                }
            }
            register ccf_Probe_T_cdma0_main_Probe_Reserved_102 @0x1DC {
                bytes 4;
                field ccf_Probe_T_cdma0_main_Probe_Reserved_102 {
                    bits 32;
                    access rw;
                    hard_reset 'h0;
                }
            }
            register ccf_Probe_T_cdma0_main_Probe_Reserved_103 @0x1E0 {
                bytes 4;
                field ccf_Probe_T_cdma0_main_Probe_Reserved_103 {
                    bits 32;
                    access rw;
                    hard_reset 'h0;
                }
            }
            register ccf_Probe_T_cdma0_main_Probe_Reserved_104 @0x1E4 {
                bytes 4;
                field ccf_Probe_T_cdma0_main_Probe_Reserved_104 {
                    bits 32;
                    access rw;
                    hard_reset 'h0;
                }
            }
            register ccf_Probe_T_cdma0_main_Probe_Reserved_105 @0x1E8 {
                bytes 4;
                field ccf_Probe_T_cdma0_main_Probe_Reserved_105 {
                    bits 32;
                    access rw;
                    hard_reset 'h0;
                }
            }
            register ccf_Probe_T_cdma0_main_Probe_Reserved_106 @0x1EC {
                bytes 4;
                field ccf_Probe_T_cdma0_main_Probe_Reserved_106 {
                    bits 32;
                    access rw;
                    hard_reset 'h0;
                }
            }
            register ccf_Probe_T_cdma0_main_Probe_Reserved_107 @0x1F0 {
                bytes 4;
                field ccf_Probe_T_cdma0_main_Probe_Reserved_107 {
                    bits 32;
                    access rw;
                    hard_reset 'h0;
                }
            }
            register ccf_Probe_T_cdma0_main_Probe_Reserved_108 @0x1F4 {
                bytes 4;
                field ccf_Probe_T_cdma0_main_Probe_Reserved_108 {
                    bits 32;
                    access rw;
                    hard_reset 'h0;
                }
            }
            register ccf_Probe_T_cdma0_main_Probe_Reserved_109 @0x1F8 {
                bytes 4;
                field ccf_Probe_T_cdma0_main_Probe_Reserved_109 {
                    bits 32;
                    access rw;
                    hard_reset 'h0;
                }
            }
            register ccf_Probe_T_cdma0_main_Probe_Reserved_110 @0x1FC {
                bytes 4;
                field ccf_Probe_T_cdma0_main_Probe_Reserved_110 {
                    bits 32;
                    access rw;
                    hard_reset 'h0;
                }
            }
            register ccf_Probe_T_cdma0_main_Probe_Reserved_111 @0x200 {
                bytes 4;
                field ccf_Probe_T_cdma0_main_Probe_Reserved_111 {
                    bits 32;
                    access rw;
                    hard_reset 'h0;
                }
            }
            register ccf_Probe_T_cdma0_main_Probe_Reserved_112 @0x204 {
                bytes 4;
                field ccf_Probe_T_cdma0_main_Probe_Reserved_112 {
                    bits 32;
                    access rw;
                    hard_reset 'h0;
                }
            }
            register ccf_Probe_T_cdma0_main_Probe_Reserved_113 @0x208 {
                bytes 4;
                field ccf_Probe_T_cdma0_main_Probe_Reserved_113 {
                    bits 32;
                    access rw;
                    hard_reset 'h0;
                }
            }
            register ccf_Probe_T_cdma0_main_Probe_Reserved_114 @0x20C {
                bytes 4;
                field ccf_Probe_T_cdma0_main_Probe_Reserved_114 {
                    bits 32;
                    access rw;
                    hard_reset 'h0;
                }
            }
            register ccf_Probe_T_cdma0_main_Probe_Reserved_115 @0x210 {
                bytes 4;
                field ccf_Probe_T_cdma0_main_Probe_Reserved_115 {
                    bits 32;
                    access rw;
                    hard_reset 'h0;
                }
            }
            register ccf_Probe_T_cdma0_main_Probe_Reserved_116 @0x214 {
                bytes 4;
                field ccf_Probe_T_cdma0_main_Probe_Reserved_116 {
                    bits 32;
                    access rw;
                    hard_reset 'h0;
                }
            }
            register ccf_Probe_T_cdma0_main_Probe_Reserved_117 @0x218 {
                bytes 4;
                field ccf_Probe_T_cdma0_main_Probe_Reserved_117 {
                    bits 32;
                    access rw;
                    hard_reset 'h0;
                }
            }
            register ccf_Probe_T_cdma0_main_Probe_Reserved_118 @0x21C {
                bytes 4;
                field ccf_Probe_T_cdma0_main_Probe_Reserved_118 {
                    bits 32;
                    access rw;
                    hard_reset 'h0;
                }
            }
            register ccf_Probe_T_cdma0_main_Probe_Reserved_119 @0x220 {
                bytes 4;
                field ccf_Probe_T_cdma0_main_Probe_Reserved_119 {
                    bits 32;
                    access rw;
                    hard_reset 'h0;
                }
            }
            register ccf_Probe_T_cdma0_main_Probe_Reserved_120 @0x224 {
                bytes 4;
                field ccf_Probe_T_cdma0_main_Probe_Reserved_120 {
                    bits 32;
                    access rw;
                    hard_reset 'h0;
                }
            }
            register ccf_Probe_T_cdma0_main_Probe_Reserved_121 @0x228 {
                bytes 4;
                field ccf_Probe_T_cdma0_main_Probe_Reserved_121 {
                    bits 32;
                    access rw;
                    hard_reset 'h0;
                }
            }
            register ccf_Probe_T_cdma0_main_Probe_Reserved_122 @0x22C {
                bytes 4;
                field ccf_Probe_T_cdma0_main_Probe_Reserved_122 {
                    bits 32;
                    access rw;
                    hard_reset 'h0;
                }
            }
            register ccf_Probe_T_cdma0_main_Probe_Reserved_123 @0x230 {
                bytes 4;
                field ccf_Probe_T_cdma0_main_Probe_Reserved_123 {
                    bits 32;
                    access rw;
                    hard_reset 'h0;
                }
            }
            register ccf_Probe_T_cdma0_main_Probe_Reserved_124 @0x234 {
                bytes 4;
                field ccf_Probe_T_cdma0_main_Probe_Reserved_124 {
                    bits 32;
                    access rw;
                    hard_reset 'h0;
                }
            }
            register ccf_Probe_T_cdma0_main_Probe_Reserved_125 @0x238 {
                bytes 4;
                field ccf_Probe_T_cdma0_main_Probe_Reserved_125 {
                    bits 32;
                    access rw;
                    hard_reset 'h0;
                }
            }
            register ccf_Probe_T_cdma0_main_Probe_Reserved_126 @0x23C {
                bytes 4;
                field ccf_Probe_T_cdma0_main_Probe_Reserved_126 {
                    bits 32;
                    access rw;
                    hard_reset 'h0;
                }
            }
            register ccf_Probe_T_cdma0_main_Probe_Reserved_127 @0x240 {
                bytes 4;
                field ccf_Probe_T_cdma0_main_Probe_Reserved_127 {
                    bits 32;
                    access rw;
                    hard_reset 'h0;
                }
            }
            register ccf_Probe_T_cdma0_main_Probe_Reserved_128 @0x244 {
                bytes 4;
                field ccf_Probe_T_cdma0_main_Probe_Reserved_128 {
                    bits 32;
                    access rw;
                    hard_reset 'h0;
                }
            }
            register ccf_Probe_T_cdma0_main_Probe_Reserved_129 @0x248 {
                bytes 4;
                field ccf_Probe_T_cdma0_main_Probe_Reserved_129 {
                    bits 32;
                    access rw;
                    hard_reset 'h0;
                }
            }
            register ccf_Probe_T_cdma0_main_Probe_Reserved_130 @0x24C {
                bytes 4;
                field ccf_Probe_T_cdma0_main_Probe_Reserved_130 {
                    bits 32;
                    access rw;
                    hard_reset 'h0;
                }
            }
            register ccf_Probe_T_cdma0_main_Probe_Reserved_131 @0x250 {
                bytes 4;
                field ccf_Probe_T_cdma0_main_Probe_Reserved_131 {
                    bits 32;
                    access rw;
                    hard_reset 'h0;
                }
            }
            register ccf_Probe_T_cdma0_main_Probe_Reserved_132 @0x254 {
                bytes 4;
                field ccf_Probe_T_cdma0_main_Probe_Reserved_132 {
                    bits 32;
                    access rw;
                    hard_reset 'h0;
                }
            }
            register ccf_Probe_T_cdma0_main_Probe_Reserved_133 @0x258 {
                bytes 4;
                field ccf_Probe_T_cdma0_main_Probe_Reserved_133 {
                    bits 32;
                    access rw;
                    hard_reset 'h0;
                }
            }
            register ccf_Probe_T_cdma0_main_Probe_Reserved_134 @0x25C {
                bytes 4;
                field ccf_Probe_T_cdma0_main_Probe_Reserved_134 {
                    bits 32;
                    access rw;
                    hard_reset 'h0;
                }
            }
            register ccf_Probe_T_cdma0_main_Probe_Reserved_135 @0x260 {
                bytes 4;
                field ccf_Probe_T_cdma0_main_Probe_Reserved_135 {
                    bits 32;
                    access rw;
                    hard_reset 'h0;
                }
            }
            register ccf_Probe_T_cdma0_main_Probe_Reserved_136 @0x264 {
                bytes 4;
                field ccf_Probe_T_cdma0_main_Probe_Reserved_136 {
                    bits 32;
                    access rw;
                    hard_reset 'h0;
                }
            }
            register ccf_Probe_T_cdma0_main_Probe_Reserved_137 @0x268 {
                bytes 4;
                field ccf_Probe_T_cdma0_main_Probe_Reserved_137 {
                    bits 32;
                    access rw;
                    hard_reset 'h0;
                }
            }
            register ccf_Probe_T_cdma0_main_Probe_Reserved_138 @0x26C {
                bytes 4;
                field ccf_Probe_T_cdma0_main_Probe_Reserved_138 {
                    bits 32;
                    access rw;
                    hard_reset 'h0;
                }
            }
            register ccf_Probe_T_cdma0_main_Probe_Reserved_139 @0x270 {
                bytes 4;
                field ccf_Probe_T_cdma0_main_Probe_Reserved_139 {
                    bits 32;
                    access rw;
                    hard_reset 'h0;
                }
            }
            register ccf_Probe_T_cdma0_main_Probe_Reserved_140 @0x274 {
                bytes 4;
                field ccf_Probe_T_cdma0_main_Probe_Reserved_140 {
                    bits 32;
                    access rw;
                    hard_reset 'h0;
                }
            }
            register ccf_Probe_T_cdma0_main_Probe_Reserved_141 @0x278 {
                bytes 4;
                field ccf_Probe_T_cdma0_main_Probe_Reserved_141 {
                    bits 32;
                    access rw;
                    hard_reset 'h0;
                }
            }
            register ccf_Probe_T_cdma0_main_Probe_Reserved_142 @0x27C {
                bytes 4;
                field ccf_Probe_T_cdma0_main_Probe_Reserved_142 {
                    bits 32;
                    access rw;
                    hard_reset 'h0;
                }
            }
            register ccf_Probe_T_cdma0_main_Probe_Reserved_143 @0x280 {
                bytes 4;
                field ccf_Probe_T_cdma0_main_Probe_Reserved_143 {
                    bits 32;
                    access rw;
                    hard_reset 'h0;
                }
            }
            register ccf_Probe_T_cdma0_main_Probe_Reserved_144 @0x284 {
                bytes 4;
                field ccf_Probe_T_cdma0_main_Probe_Reserved_144 {
                    bits 32;
                    access rw;
                    hard_reset 'h0;
                }
            }
            register ccf_Probe_T_cdma0_main_Probe_Reserved_145 @0x288 {
                bytes 4;
                field ccf_Probe_T_cdma0_main_Probe_Reserved_145 {
                    bits 32;
                    access rw;
                    hard_reset 'h0;
                }
            }
            register ccf_Probe_T_cdma0_main_Probe_Reserved_146 @0x28C {
                bytes 4;
                field ccf_Probe_T_cdma0_main_Probe_Reserved_146 {
                    bits 32;
                    access rw;
                    hard_reset 'h0;
                }
            }
            register ccf_Probe_T_cdma0_main_Probe_Reserved_147 @0x290 {
                bytes 4;
                field ccf_Probe_T_cdma0_main_Probe_Reserved_147 {
                    bits 32;
                    access rw;
                    hard_reset 'h0;
                }
            }
            register ccf_Probe_T_cdma0_main_Probe_Reserved_148 @0x294 {
                bytes 4;
                field ccf_Probe_T_cdma0_main_Probe_Reserved_148 {
                    bits 32;
                    access rw;
                    hard_reset 'h0;
                }
            }
            register ccf_Probe_T_cdma0_main_Probe_Reserved_149 @0x298 {
                bytes 4;
                field ccf_Probe_T_cdma0_main_Probe_Reserved_149 {
                    bits 32;
                    access rw;
                    hard_reset 'h0;
                }
            }
            register ccf_Probe_T_cdma0_main_Probe_Reserved_150 @0x29C {
                bytes 4;
                field ccf_Probe_T_cdma0_main_Probe_Reserved_150 {
                    bits 32;
                    access rw;
                    hard_reset 'h0;
                }
            }
            register ccf_Probe_T_cdma0_main_Probe_Reserved_151 @0x2A0 {
                bytes 4;
                field ccf_Probe_T_cdma0_main_Probe_Reserved_151 {
                    bits 32;
                    access rw;
                    hard_reset 'h0;
                }
            }
            register ccf_Probe_T_cdma0_main_Probe_Reserved_152 @0x2A4 {
                bytes 4;
                field ccf_Probe_T_cdma0_main_Probe_Reserved_152 {
                    bits 32;
                    access rw;
                    hard_reset 'h0;
                }
            }
            register ccf_Probe_T_cdma0_main_Probe_Reserved_153 @0x2A8 {
                bytes 4;
                field ccf_Probe_T_cdma0_main_Probe_Reserved_153 {
                    bits 32;
                    access rw;
                    hard_reset 'h0;
                }
            }
            register ccf_Probe_T_cdma0_main_Probe_Reserved_154 @0x2AC {
                bytes 4;
                field ccf_Probe_T_cdma0_main_Probe_Reserved_154 {
                    bits 32;
                    access rw;
                    hard_reset 'h0;
                }
            }
            register ccf_Probe_T_cdma0_main_Probe_Reserved_155 @0x2B0 {
                bytes 4;
                field ccf_Probe_T_cdma0_main_Probe_Reserved_155 {
                    bits 32;
                    access rw;
                    hard_reset 'h0;
                }
            }
            register ccf_Probe_T_cdma0_main_Probe_Reserved_156 @0x2B4 {
                bytes 4;
                field ccf_Probe_T_cdma0_main_Probe_Reserved_156 {
                    bits 32;
                    access rw;
                    hard_reset 'h0;
                }
            }
            register ccf_Probe_T_cdma0_main_Probe_Reserved_157 @0x2B8 {
                bytes 4;
                field ccf_Probe_T_cdma0_main_Probe_Reserved_157 {
                    bits 32;
                    access rw;
                    hard_reset 'h0;
                }
            }
            register ccf_Probe_T_cdma0_main_Probe_Reserved_158 @0x2BC {
                bytes 4;
                field ccf_Probe_T_cdma0_main_Probe_Reserved_158 {
                    bits 32;
                    access rw;
                    hard_reset 'h0;
                }
            }
            register ccf_Probe_T_cdma0_main_Probe_Reserved_159 @0x2C0 {
                bytes 4;
                field ccf_Probe_T_cdma0_main_Probe_Reserved_159 {
                    bits 32;
                    access rw;
                    hard_reset 'h0;
                }
            }
            register ccf_Probe_T_cdma0_main_Probe_Reserved_160 @0x2C4 {
                bytes 4;
                field ccf_Probe_T_cdma0_main_Probe_Reserved_160 {
                    bits 32;
                    access rw;
                    hard_reset 'h0;
                }
            }
            register ccf_Probe_T_cdma0_main_Probe_Reserved_161 @0x2C8 {
                bytes 4;
                field ccf_Probe_T_cdma0_main_Probe_Reserved_161 {
                    bits 32;
                    access rw;
                    hard_reset 'h0;
                }
            }
            register ccf_Probe_T_cdma0_main_Probe_Reserved_162 @0x2CC {
                bytes 4;
                field ccf_Probe_T_cdma0_main_Probe_Reserved_162 {
                    bits 32;
                    access rw;
                    hard_reset 'h0;
                }
            }
            register ccf_Probe_T_cdma0_main_Probe_Reserved_163 @0x2D0 {
                bytes 4;
                field ccf_Probe_T_cdma0_main_Probe_Reserved_163 {
                    bits 32;
                    access rw;
                    hard_reset 'h0;
                }
            }
            register ccf_Probe_T_cdma0_main_Probe_Reserved_164 @0x2D4 {
                bytes 4;
                field ccf_Probe_T_cdma0_main_Probe_Reserved_164 {
                    bits 32;
                    access rw;
                    hard_reset 'h0;
                }
            }
            register ccf_Probe_T_cdma0_main_Probe_Reserved_165 @0x2D8 {
                bytes 4;
                field ccf_Probe_T_cdma0_main_Probe_Reserved_165 {
                    bits 32;
                    access rw;
                    hard_reset 'h0;
                }
            }
            register ccf_Probe_T_cdma0_main_Probe_Reserved_166 @0x2DC {
                bytes 4;
                field ccf_Probe_T_cdma0_main_Probe_Reserved_166 {
                    bits 32;
                    access rw;
                    hard_reset 'h0;
                }
            }
            register ccf_Probe_T_cdma0_main_Probe_Reserved_167 @0x2E0 {
                bytes 4;
                field ccf_Probe_T_cdma0_main_Probe_Reserved_167 {
                    bits 32;
                    access rw;
                    hard_reset 'h0;
                }
            }
            register ccf_Probe_T_cdma0_main_Probe_Reserved_168 @0x2E4 {
                bytes 4;
                field ccf_Probe_T_cdma0_main_Probe_Reserved_168 {
                    bits 32;
                    access rw;
                    hard_reset 'h0;
                }
            }
            register ccf_Probe_T_cdma0_main_Probe_Reserved_169 @0x2E8 {
                bytes 4;
                field ccf_Probe_T_cdma0_main_Probe_Reserved_169 {
                    bits 32;
                    access rw;
                    hard_reset 'h0;
                }
            }
            register ccf_Probe_T_cdma0_main_Probe_Reserved_170 @0x2EC {
                bytes 4;
                field ccf_Probe_T_cdma0_main_Probe_Reserved_170 {
                    bits 32;
                    access rw;
                    hard_reset 'h0;
                }
            }
            register ccf_Probe_T_cdma0_main_Probe_Reserved_171 @0x2F0 {
                bytes 4;
                field ccf_Probe_T_cdma0_main_Probe_Reserved_171 {
                    bits 32;
                    access rw;
                    hard_reset 'h0;
                }
            }
            register ccf_Probe_T_cdma0_main_Probe_Reserved_172 @0x2F4 {
                bytes 4;
                field ccf_Probe_T_cdma0_main_Probe_Reserved_172 {
                    bits 32;
                    access rw;
                    hard_reset 'h0;
                }
            }
            register ccf_Probe_T_cdma0_main_Probe_Reserved_173 @0x2F8 {
                bytes 4;
                field ccf_Probe_T_cdma0_main_Probe_Reserved_173 {
                    bits 32;
                    access rw;
                    hard_reset 'h0;
                }
            }
            register ccf_Probe_T_cdma0_main_Probe_Reserved_174 @0x2FC {
                bytes 4;
                field ccf_Probe_T_cdma0_main_Probe_Reserved_174 {
                    bits 32;
                    access rw;
                    hard_reset 'h0;
                }
            }
            register ccf_Probe_T_cdma0_main_Probe_Reserved_175 @0x300 {
                bytes 4;
                field ccf_Probe_T_cdma0_main_Probe_Reserved_175 {
                    bits 32;
                    access rw;
                    hard_reset 'h0;
                }
            }
            register ccf_Probe_T_cdma0_main_Probe_Reserved_176 @0x304 {
                bytes 4;
                field ccf_Probe_T_cdma0_main_Probe_Reserved_176 {
                    bits 32;
                    access rw;
                    hard_reset 'h0;
                }
            }
            register ccf_Probe_T_cdma0_main_Probe_Reserved_177 @0x308 {
                bytes 4;
                field ccf_Probe_T_cdma0_main_Probe_Reserved_177 {
                    bits 32;
                    access rw;
                    hard_reset 'h0;
                }
            }
            register ccf_Probe_T_cdma0_main_Probe_Reserved_178 @0x30C {
                bytes 4;
                field ccf_Probe_T_cdma0_main_Probe_Reserved_178 {
                    bits 32;
                    access rw;
                    hard_reset 'h0;
                }
            }
            register ccf_Probe_T_cdma0_main_Probe_Reserved_179 @0x310 {
                bytes 4;
                field ccf_Probe_T_cdma0_main_Probe_Reserved_179 {
                    bits 32;
                    access rw;
                    hard_reset 'h0;
                }
            }
            register ccf_Probe_T_cdma0_main_Probe_Reserved_180 @0x314 {
                bytes 4;
                field ccf_Probe_T_cdma0_main_Probe_Reserved_180 {
                    bits 32;
                    access rw;
                    hard_reset 'h0;
                }
            }
            register ccf_Probe_T_cdma0_main_Probe_Reserved_181 @0x318 {
                bytes 4;
                field ccf_Probe_T_cdma0_main_Probe_Reserved_181 {
                    bits 32;
                    access rw;
                    hard_reset 'h0;
                }
            }
            register ccf_Probe_T_cdma0_main_Probe_Reserved_182 @0x31C {
                bytes 4;
                field ccf_Probe_T_cdma0_main_Probe_Reserved_182 {
                    bits 32;
                    access rw;
                    hard_reset 'h0;
                }
            }
            register ccf_Probe_T_cdma0_main_Probe_Reserved_183 @0x320 {
                bytes 4;
                field ccf_Probe_T_cdma0_main_Probe_Reserved_183 {
                    bits 32;
                    access rw;
                    hard_reset 'h0;
                }
            }
            register ccf_Probe_T_cdma0_main_Probe_Reserved_184 @0x324 {
                bytes 4;
                field ccf_Probe_T_cdma0_main_Probe_Reserved_184 {
                    bits 32;
                    access rw;
                    hard_reset 'h0;
                }
            }
            register ccf_Probe_T_cdma0_main_Probe_Reserved_185 @0x328 {
                bytes 4;
                field ccf_Probe_T_cdma0_main_Probe_Reserved_185 {
                    bits 32;
                    access rw;
                    hard_reset 'h0;
                }
            }
            register ccf_Probe_T_cdma0_main_Probe_Reserved_186 @0x32C {
                bytes 4;
                field ccf_Probe_T_cdma0_main_Probe_Reserved_186 {
                    bits 32;
                    access rw;
                    hard_reset 'h0;
                }
            }
            register ccf_Probe_T_cdma0_main_Probe_Reserved_187 @0x330 {
                bytes 4;
                field ccf_Probe_T_cdma0_main_Probe_Reserved_187 {
                    bits 32;
                    access rw;
                    hard_reset 'h0;
                }
            }
            register ccf_Probe_T_cdma0_main_Probe_Reserved_188 @0x334 {
                bytes 4;
                field ccf_Probe_T_cdma0_main_Probe_Reserved_188 {
                    bits 32;
                    access rw;
                    hard_reset 'h0;
                }
            }
            register ccf_Probe_T_cdma0_main_Probe_Reserved_189 @0x338 {
                bytes 4;
                field ccf_Probe_T_cdma0_main_Probe_Reserved_189 {
                    bits 32;
                    access rw;
                    hard_reset 'h0;
                }
            }
            register ccf_Probe_T_cdma0_main_Probe_Reserved_190 @0x33C {
                bytes 4;
                field ccf_Probe_T_cdma0_main_Probe_Reserved_190 {
                    bits 32;
                    access rw;
                    hard_reset 'h0;
                }
            }
            register ccf_Probe_T_cdma0_main_Probe_Reserved_191 @0x340 {
                bytes 4;
                field ccf_Probe_T_cdma0_main_Probe_Reserved_191 {
                    bits 32;
                    access rw;
                    hard_reset 'h0;
                }
            }
            register ccf_Probe_T_cdma0_main_Probe_Reserved_192 @0x344 {
                bytes 4;
                field ccf_Probe_T_cdma0_main_Probe_Reserved_192 {
                    bits 32;
                    access rw;
                    hard_reset 'h0;
                }
            }
            register ccf_Probe_T_cdma0_main_Probe_Reserved_193 @0x348 {
                bytes 4;
                field ccf_Probe_T_cdma0_main_Probe_Reserved_193 {
                    bits 32;
                    access rw;
                    hard_reset 'h0;
                }
            }
            register ccf_Probe_T_cdma0_main_Probe_Reserved_194 @0x34C {
                bytes 4;
                field ccf_Probe_T_cdma0_main_Probe_Reserved_194 {
                    bits 32;
                    access rw;
                    hard_reset 'h0;
                }
            }
            register ccf_Probe_T_cdma0_main_Probe_Reserved_195 @0x350 {
                bytes 4;
                field ccf_Probe_T_cdma0_main_Probe_Reserved_195 {
                    bits 32;
                    access rw;
                    hard_reset 'h0;
                }
            }
            register ccf_Probe_T_cdma0_main_Probe_Reserved_196 @0x354 {
                bytes 4;
                field ccf_Probe_T_cdma0_main_Probe_Reserved_196 {
                    bits 32;
                    access rw;
                    hard_reset 'h0;
                }
            }
            register ccf_Probe_T_cdma0_main_Probe_Reserved_197 @0x358 {
                bytes 4;
                field ccf_Probe_T_cdma0_main_Probe_Reserved_197 {
                    bits 32;
                    access rw;
                    hard_reset 'h0;
                }
            }
            register ccf_Probe_T_cdma0_main_Probe_Reserved_198 @0x35C {
                bytes 4;
                field ccf_Probe_T_cdma0_main_Probe_Reserved_198 {
                    bits 32;
                    access rw;
                    hard_reset 'h0;
                }
            }
            register ccf_Probe_T_cdma0_main_Probe_Reserved_199 @0x360 {
                bytes 4;
                field ccf_Probe_T_cdma0_main_Probe_Reserved_199 {
                    bits 32;
                    access rw;
                    hard_reset 'h0;
                }
            }
            register ccf_Probe_T_cdma0_main_Probe_Reserved_200 @0x364 {
                bytes 4;
                field ccf_Probe_T_cdma0_main_Probe_Reserved_200 {
                    bits 32;
                    access rw;
                    hard_reset 'h0;
                }
            }
            register ccf_Probe_T_cdma0_main_Probe_Reserved_201 @0x368 {
                bytes 4;
                field ccf_Probe_T_cdma0_main_Probe_Reserved_201 {
                    bits 32;
                    access rw;
                    hard_reset 'h0;
                }
            }
            register ccf_Probe_T_cdma0_main_Probe_Reserved_202 @0x36C {
                bytes 4;
                field ccf_Probe_T_cdma0_main_Probe_Reserved_202 {
                    bits 32;
                    access rw;
                    hard_reset 'h0;
                }
            }
            register ccf_Probe_T_cdma0_main_Probe_Reserved_203 @0x370 {
                bytes 4;
                field ccf_Probe_T_cdma0_main_Probe_Reserved_203 {
                    bits 32;
                    access rw;
                    hard_reset 'h0;
                }
            }
            register ccf_Probe_T_cdma0_main_Probe_Reserved_204 @0x374 {
                bytes 4;
                field ccf_Probe_T_cdma0_main_Probe_Reserved_204 {
                    bits 32;
                    access rw;
                    hard_reset 'h0;
                }
            }
            register ccf_Probe_T_cdma0_main_Probe_Reserved_205 @0x378 {
                bytes 4;
                field ccf_Probe_T_cdma0_main_Probe_Reserved_205 {
                    bits 32;
                    access rw;
                    hard_reset 'h0;
                }
            }
            register ccf_Probe_T_cdma0_main_Probe_Reserved_206 @0x37C {
                bytes 4;
                field ccf_Probe_T_cdma0_main_Probe_Reserved_206 {
                    bits 32;
                    access rw;
                    hard_reset 'h0;
                }
            }
            register ccf_Probe_T_cdma0_main_Probe_Reserved_207 @0x380 {
                bytes 4;
                field ccf_Probe_T_cdma0_main_Probe_Reserved_207 {
                    bits 32;
                    access rw;
                    hard_reset 'h0;
                }
            }
            register ccf_Probe_T_cdma0_main_Probe_Reserved_208 @0x384 {
                bytes 4;
                field ccf_Probe_T_cdma0_main_Probe_Reserved_208 {
                    bits 32;
                    access rw;
                    hard_reset 'h0;
                }
            }
            register ccf_Probe_T_cdma0_main_Probe_Reserved_209 @0x388 {
                bytes 4;
                field ccf_Probe_T_cdma0_main_Probe_Reserved_209 {
                    bits 32;
                    access rw;
                    hard_reset 'h0;
                }
            }
            register ccf_Probe_T_cdma0_main_Probe_Reserved_210 @0x38C {
                bytes 4;
                field ccf_Probe_T_cdma0_main_Probe_Reserved_210 {
                    bits 32;
                    access rw;
                    hard_reset 'h0;
                }
            }
            register ccf_Probe_T_cdma0_main_Probe_Reserved_211 @0x390 {
                bytes 4;
                field ccf_Probe_T_cdma0_main_Probe_Reserved_211 {
                    bits 32;
                    access rw;
                    hard_reset 'h0;
                }
            }
            register ccf_Probe_T_cdma0_main_Probe_Reserved_212 @0x394 {
                bytes 4;
                field ccf_Probe_T_cdma0_main_Probe_Reserved_212 {
                    bits 32;
                    access rw;
                    hard_reset 'h0;
                }
            }
            register ccf_Probe_T_cdma0_main_Probe_Reserved_213 @0x398 {
                bytes 4;
                field ccf_Probe_T_cdma0_main_Probe_Reserved_213 {
                    bits 32;
                    access rw;
                    hard_reset 'h0;
                }
            }
            register ccf_Probe_T_cdma0_main_Probe_Reserved_214 @0x39C {
                bytes 4;
                field ccf_Probe_T_cdma0_main_Probe_Reserved_214 {
                    bits 32;
                    access rw;
                    hard_reset 'h0;
                }
            }
            register ccf_Probe_T_cdma0_main_Probe_Reserved_215 @0x3A0 {
                bytes 4;
                field ccf_Probe_T_cdma0_main_Probe_Reserved_215 {
                    bits 32;
                    access rw;
                    hard_reset 'h0;
                }
            }
            register ccf_Probe_T_cdma0_main_Probe_Reserved_216 @0x3A4 {
                bytes 4;
                field ccf_Probe_T_cdma0_main_Probe_Reserved_216 {
                    bits 32;
                    access rw;
                    hard_reset 'h0;
                }
            }
            register ccf_Probe_T_cdma0_main_Probe_Reserved_217 @0x3A8 {
                bytes 4;
                field ccf_Probe_T_cdma0_main_Probe_Reserved_217 {
                    bits 32;
                    access rw;
                    hard_reset 'h0;
                }
            }
            register ccf_Probe_T_cdma0_main_Probe_Reserved_218 @0x3AC {
                bytes 4;
                field ccf_Probe_T_cdma0_main_Probe_Reserved_218 {
                    bits 32;
                    access rw;
                    hard_reset 'h0;
                }
            }
            register ccf_Probe_T_cdma0_main_Probe_Reserved_219 @0x3B0 {
                bytes 4;
                field ccf_Probe_T_cdma0_main_Probe_Reserved_219 {
                    bits 32;
                    access rw;
                    hard_reset 'h0;
                }
            }
            register ccf_Probe_T_cdma0_main_Probe_Reserved_220 @0x3B4 {
                bytes 4;
                field ccf_Probe_T_cdma0_main_Probe_Reserved_220 {
                    bits 32;
                    access rw;
                    hard_reset 'h0;
                }
            }
            register ccf_Probe_T_cdma0_main_Probe_Reserved_221 @0x3B8 {
                bytes 4;
                field ccf_Probe_T_cdma0_main_Probe_Reserved_221 {
                    bits 32;
                    access rw;
                    hard_reset 'h0;
                }
            }
            register ccf_Probe_T_cdma0_main_Probe_Reserved_222 @0x3BC {
                bytes 4;
                field ccf_Probe_T_cdma0_main_Probe_Reserved_222 {
                    bits 32;
                    access rw;
                    hard_reset 'h0;
                }
            }
            register ccf_Probe_T_cdma0_main_Probe_Reserved_223 @0x3C0 {
                bytes 4;
                field ccf_Probe_T_cdma0_main_Probe_Reserved_223 {
                    bits 32;
                    access rw;
                    hard_reset 'h0;
                }
            }
            register ccf_Probe_T_cdma0_main_Probe_Reserved_224 @0x3C4 {
                bytes 4;
                field ccf_Probe_T_cdma0_main_Probe_Reserved_224 {
                    bits 32;
                    access rw;
                    hard_reset 'h0;
                }
            }
            register ccf_Probe_T_cdma0_main_Probe_Reserved_225 @0x3C8 {
                bytes 4;
                field ccf_Probe_T_cdma0_main_Probe_Reserved_225 {
                    bits 32;
                    access rw;
                    hard_reset 'h0;
                }
            }
            register ccf_Probe_T_cdma0_main_Probe_Reserved_226 @0x3CC {
                bytes 4;
                field ccf_Probe_T_cdma0_main_Probe_Reserved_226 {
                    bits 32;
                    access rw;
                    hard_reset 'h0;
                }
            }
            register ccf_Probe_T_cdma0_main_Probe_Reserved_227 @0x3D0 {
                bytes 4;
                field ccf_Probe_T_cdma0_main_Probe_Reserved_227 {
                    bits 32;
                    access rw;
                    hard_reset 'h0;
                }
            }
            register ccf_Probe_T_cdma0_main_Probe_Reserved_228 @0x3D4 {
                bytes 4;
                field ccf_Probe_T_cdma0_main_Probe_Reserved_228 {
                    bits 32;
                    access rw;
                    hard_reset 'h0;
                }
            }
            register ccf_Probe_T_cdma0_main_Probe_Reserved_229 @0x3D8 {
                bytes 4;
                field ccf_Probe_T_cdma0_main_Probe_Reserved_229 {
                    bits 32;
                    access rw;
                    hard_reset 'h0;
                }
            }
            register ccf_Probe_T_cdma0_main_Probe_Reserved_230 @0x3DC {
                bytes 4;
                field ccf_Probe_T_cdma0_main_Probe_Reserved_230 {
                    bits 32;
                    access rw;
                    hard_reset 'h0;
                }
            }
            register ccf_Probe_T_cdma0_main_Probe_Reserved_231 @0x3E0 {
                bytes 4;
                field ccf_Probe_T_cdma0_main_Probe_Reserved_231 {
                    bits 32;
                    access rw;
                    hard_reset 'h0;
                }
            }
            register ccf_Probe_T_cdma0_main_Probe_Reserved_232 @0x3E4 {
                bytes 4;
                field ccf_Probe_T_cdma0_main_Probe_Reserved_232 {
                    bits 32;
                    access rw;
                    hard_reset 'h0;
                }
            }
            register ccf_Probe_T_cdma0_main_Probe_Reserved_233 @0x3E8 {
                bytes 4;
                field ccf_Probe_T_cdma0_main_Probe_Reserved_233 {
                    bits 32;
                    access rw;
                    hard_reset 'h0;
                }
            }
            register ccf_Probe_T_cdma0_main_Probe_Reserved_234 @0x3EC {
                bytes 4;
                field ccf_Probe_T_cdma0_main_Probe_Reserved_234 {
                    bits 32;
                    access rw;
                    hard_reset 'h0;
                }
            }
            register ccf_Probe_T_cdma0_main_Probe_Reserved_235 @0x3F0 {
                bytes 4;
                field ccf_Probe_T_cdma0_main_Probe_Reserved_235 {
                    bits 32;
                    access rw;
                    hard_reset 'h0;
                }
            }
            register ccf_Probe_T_cdma0_main_Probe_Reserved_236 @0x3F4 {
                bytes 4;
                field ccf_Probe_T_cdma0_main_Probe_Reserved_236 {
                    bits 32;
                    access rw;
                    hard_reset 'h0;
                }
            }
            register ccf_Probe_T_cdma0_main_Probe_Reserved_237 @0x3F8 {
                bytes 4;
                field ccf_Probe_T_cdma0_main_Probe_Reserved_237 {
                    bits 32;
                    access rw;
                    hard_reset 'h0;
                }
            }
            register ccf_Probe_T_cdma0_main_Probe_Reserved_238 @0x3FC {
                bytes 4;
                field ccf_Probe_T_cdma0_main_Probe_Reserved_238 {
                    bits 32;
                    access rw;
                    hard_reset 'h0;
                }
            }
        }
        block ecf_ccf_axi_ccf_Probe_T_cdma1_main_Probe @0xD8400 {
            bytes 4;
            register ccf_Probe_T_cdma1_main_Probe_Id_CoreId @0x0 {
                bytes 4;
                field CORETYPEID @'h0 {
                    bits 8;
                    access ro;
                    hard_reset 'h6;
                    doc {
                        Field identifying the type of IP.
                    }
                }
                field CORECHECKSUM @'h8 {
                    bits 24;
                    access ro;
                    hard_reset 'h864c38;
                    doc {
                        Field containing a checksum of the parameters of the IP.
                    }
                }
            }
            register ccf_Probe_T_cdma1_main_Probe_Id_RevisionId @0x4 {
                bytes 4;
                field USERID @'h0 {
                    bits 8;
                    access ro;
                    hard_reset 'h0;
                    doc {
                        Field containing a user defined value, not used anywhere inside the IP itself.
                    }
                }
                field FLEXNOCID @'h8 {
                    bits 24;
                    access ro;
                    hard_reset 'h84f8c6;
                    doc {
                        Field containing the build revision of the software used to generate the IP HDL code.
                    }
                }
            }
            register ccf_Probe_T_cdma1_main_Probe_MainCtl @0x8 {
                bytes 4;
                field ERREN @'h0 {
                    access rw;
                    hard_reset 'h0;
                    doc {
                        Register field ErrEn enables the probe to send on the ObsTx output any packet with Error status, independently of filtering mechanisms, thus constituting a simple supplementary global filter.
                    }
                }
                field TRACEEN @'h1 {
                    access ro;
                    hard_reset 'h0;
                    doc {
                        Register field TraceEn enables the probe to send filtered packets (Trace) on the ObsTx observation output.
                    }
                }
                field PAYLOADEN @'h2 {
                    access rw;
                    hard_reset 'h0;
                    doc {
                        Register field PayloadEn, when set to 1, enables traces to contain headers and payload. When set ot 0, only headers are reported.
                    }
                }
                field STATEN @'h3 {
                    access rw;
                    hard_reset 'h0;
                    doc {
                        When set to 1, register field StatEn enables statistics profiling. The probe sendS statistics results to the output for signal ObsTx. All statistics counters are cleared when the StatEn bit goes from 0 to 1. When set to 0, counters are disabled.
                    }
                }
                field ALARMEN @'h4 {
                    access rw;
                    hard_reset 'h0;
                    doc {
                        When set, register field AlarmEn enables the probe to collect alarm-related information. When the register field bit is null, both TraceAlarm and StatAlarm outputs are driven to 0.
                    }
                }
                field STATCONDDUMP @'h5 {
                    access rw;
                    hard_reset 'h0;
                    doc {
                        When set, register field StatCondDump enables the dump of a statistics frame to the range of counter values set for registers StatAlarmMin, StatAlarmMax, and AlarmMode. This field also renders register StatAlarmStatus inoperative. When parameter statisticsCounterAlarm is set to False, the StatCondDump register bit is reserved.
                    }
                }
                field INTRUSIVEMODE @'h6 {
                    access ro;
                    hard_reset 'h0;
                    doc {
                        When set to 1, register field IntrusiveMode enables trace operation in Intrusive flow-control mode. When set to 0, the register  enables trace operation in Overflow flow-control mode
                    }
                }
                field FILTBYTEALWAYSCHAINABLEEN @'h7 {
                    access rw;
                    hard_reset 'h0;
                    doc {
                        When set to 0, filters are mapped to all statistic counters when counting bytes or enabled bytes. Therefore, only filter events mapped to even counters can be counted using a pair of chained counters.When set to 1, filters are mapped only to even statistic counters when counting bytes or enabled bytes. Thus events from any filter can be counted using a pair of chained counters.
                    }
                }
                doc {
                    Register MainCtl contains probe global control bits. The register has seven bit fields:Register MainCtl contains probe global control bits. The register has seven bit fields:
                }
            }
            register ccf_Probe_T_cdma1_main_Probe_CfgCtl @0xC {
                bytes 4;
                field GLOBALEN @'h0 {
                    access rw;
                    hard_reset 'h0;
                }
                field ACTIVE @'h1 {
                    access ro;
                    hard_reset 'h0;
                }
            }
            register ccf_Probe_T_cdma1_main_Probe_Reserved_00 @0x10 {
                bytes 4;
                field ccf_Probe_T_cdma1_main_Probe_Reserved_00 {
                    bits 32;
                    access rw;
                    hard_reset 'h0;
                }
            }
            register ccf_Probe_T_cdma1_main_Probe_Reserved_01 @0x14 {
                bytes 4;
                field ccf_Probe_T_cdma1_main_Probe_Reserved_01 {
                    bits 32;
                    access rw;
                    hard_reset 'h0;
                }
            }
            register ccf_Probe_T_cdma1_main_Probe_Reserved_02 @0x18 {
                bytes 4;
                field ccf_Probe_T_cdma1_main_Probe_Reserved_02 {
                    bits 32;
                    access rw;
                    hard_reset 'h0;
                }
            }
            register ccf_Probe_T_cdma1_main_Probe_Reserved_03 @0x1C {
                bytes 4;
                field ccf_Probe_T_cdma1_main_Probe_Reserved_03 {
                    bits 32;
                    access rw;
                    hard_reset 'h0;
                }
            }
            register ccf_Probe_T_cdma1_main_Probe_Reserved_04 @0x20 {
                bytes 4;
                field ccf_Probe_T_cdma1_main_Probe_Reserved_04 {
                    bits 32;
                    access rw;
                    hard_reset 'h0;
                }
            }
            register ccf_Probe_T_cdma1_main_Probe_StatPeriod @0x24 {
                bytes 4;
                field STATPERIOD @'h0 {
                    bits 5;
                    access rw;
                    hard_reset 'h0;
                    doc {
                        Register StatPeriod is a 5-bit register that sets a period, within a range of 2 cycles to 2 gigacycles, during which statistics are collected before being dumped automatically. Setting the register implicitly enables automatic mode operation for statistics collection. The period is calculated with the formula: N_Cycle = 2**StatPeriodWhen register StatPeriod is set to its default value 0, automatic dump mode is disabled, and register StatGo is activated for manual mode operation. Note: When parameter statisticsCollection is set to False, StatPeriod is reserved.
                    }
                }
            }
            register ccf_Probe_T_cdma1_main_Probe_StatGo @0x28 {
                bytes 4;
                field STATGO @'h0 {
                    access w1c;
                    hard_reset 'h0;
                    doc {
                        Writing a 1 to the 1-bit pulse register StatGo generates a statistics dump.The register is active when statistics collection operates in manual mode, that is, when register StatPeriod is set to 0.NOTE  The written value is not stored in StatGo. A read always returns 0.
                    }
                }
            }
            register ccf_Probe_T_cdma1_main_Probe_StatAlarmMin @0x2C {
                bytes 4;
                field STATALARMMIN @'h0 {
                    bits 22;
                    access rw;
                    hard_reset 'h0;
                    doc {
                        Register StatAlarmMin contains the minimum count value used in statistics alarm comparisons. The number of bits is equal to twice the value set forparameter wStatisticsCounter. When parameter statisticsCounterAlarm is set to False, StatAlarmMin is reserved.
                    }
                }
            }
            register ccf_Probe_T_cdma1_main_Probe_StatAlarmMax @0x30 {
                bytes 4;
                field STATALARMMAX @'h0 {
                    bits 22;
                    access rw;
                    hard_reset 'h0;
                    doc {
                        Register StatAlarmMax contains the maximum count value used in statistics alarm comparisons.The number of bits is equal to twice the value set for parameter wStatisticsCounter. When parameter statisticsCounterAlarm is set to False, StatAlarmMax is reserved.
                    }
                }
            }
            register ccf_Probe_T_cdma1_main_Probe_StatAlarmStatus @0x34 {
                bytes 4;
                field STATALARMSTATUS @'h0 {
                    access ro;
                    hard_reset 'h0;
                    doc {
                        Register StatAlarmStatus is a read-only 1-bit register indicating that at least one statistics counter has exceeded the programmed values for registers StatAlarmMin or StatAlarmMax. Output signal StatAlarm is equal to the values stored in register MainCtl fields StatAlarmStatus and AlarmEn. When parameter statisticsCounterAlarm is set to False, StatAlarmStatus is reserved.
                    }
                }
            }
            register ccf_Probe_T_cdma1_main_Probe_StatAlarmClr @0x38 {
                bytes 4;
                field STATALARMCLR @'h0 {
                    access w1c;
                    hard_reset 'h0;
                    doc {
                        Register StatAlarmClr is a 1-bit register. Writing a 1 to this register clears the StatAlarmStatus register bit.When parameter statisticsCounterAlarm is set to False, StatAlarmClr is reserved.NOTE  The written value is not stored in StatAlarmClr. A read always returns 0.
                    }
                }
            }
            register ccf_Probe_T_cdma1_main_Probe_StatAlarmEn @0x3C {
                bytes 4;
                field STATALARMEN @'h0 {
                    access rw;
                    hard_reset 'h1;
                    doc {
                        Register StatAlarmEn is a 1-bit register. When set to 0 it masks StatAlarm and CtiTrigOut(1) signal interrupts.
                    }
                }
            }
            register ccf_Probe_T_cdma1_main_Probe_Reserved_05 @0x40 {
                bytes 4;
                field ccf_Probe_T_cdma1_main_Probe_Reserved_05 {
                    bits 32;
                    access rw;
                    hard_reset 'h0;
                }
            }
            register ccf_Probe_T_cdma1_main_Probe_Reserved_06 @0x44 {
                bytes 4;
                field ccf_Probe_T_cdma1_main_Probe_Reserved_06 {
                    bits 32;
                    access rw;
                    hard_reset 'h0;
                }
            }
            register ccf_Probe_T_cdma1_main_Probe_Reserved_07 @0x48 {
                bytes 4;
                field ccf_Probe_T_cdma1_main_Probe_Reserved_07 {
                    bits 32;
                    access rw;
                    hard_reset 'h0;
                }
            }
            register ccf_Probe_T_cdma1_main_Probe_Reserved_08 @0x4C {
                bytes 4;
                field ccf_Probe_T_cdma1_main_Probe_Reserved_08 {
                    bits 32;
                    access rw;
                    hard_reset 'h0;
                }
            }
            register ccf_Probe_T_cdma1_main_Probe_Reserved_09 @0x50 {
                bytes 4;
                field ccf_Probe_T_cdma1_main_Probe_Reserved_09 {
                    bits 32;
                    access rw;
                    hard_reset 'h0;
                }
            }
            register ccf_Probe_T_cdma1_main_Probe_Reserved_10 @0x54 {
                bytes 4;
                field ccf_Probe_T_cdma1_main_Probe_Reserved_10 {
                    bits 32;
                    access rw;
                    hard_reset 'h0;
                }
            }
            register ccf_Probe_T_cdma1_main_Probe_Reserved_11 @0x58 {
                bytes 4;
                field ccf_Probe_T_cdma1_main_Probe_Reserved_11 {
                    bits 32;
                    access rw;
                    hard_reset 'h0;
                }
            }
            register ccf_Probe_T_cdma1_main_Probe_Reserved_12 @0x5C {
                bytes 4;
                field ccf_Probe_T_cdma1_main_Probe_Reserved_12 {
                    bits 32;
                    access rw;
                    hard_reset 'h0;
                }
            }
            register ccf_Probe_T_cdma1_main_Probe_Reserved_13 @0x60 {
                bytes 4;
                field ccf_Probe_T_cdma1_main_Probe_Reserved_13 {
                    bits 32;
                    access rw;
                    hard_reset 'h0;
                }
            }
            register ccf_Probe_T_cdma1_main_Probe_Reserved_14 @0x64 {
                bytes 4;
                field ccf_Probe_T_cdma1_main_Probe_Reserved_14 {
                    bits 32;
                    access rw;
                    hard_reset 'h0;
                }
            }
            register ccf_Probe_T_cdma1_main_Probe_Reserved_15 @0x68 {
                bytes 4;
                field ccf_Probe_T_cdma1_main_Probe_Reserved_15 {
                    bits 32;
                    access rw;
                    hard_reset 'h0;
                }
            }
            register ccf_Probe_T_cdma1_main_Probe_Reserved_16 @0x6C {
                bytes 4;
                field ccf_Probe_T_cdma1_main_Probe_Reserved_16 {
                    bits 32;
                    access rw;
                    hard_reset 'h0;
                }
            }
            register ccf_Probe_T_cdma1_main_Probe_Reserved_17 @0x70 {
                bytes 4;
                field ccf_Probe_T_cdma1_main_Probe_Reserved_17 {
                    bits 32;
                    access rw;
                    hard_reset 'h0;
                }
            }
            register ccf_Probe_T_cdma1_main_Probe_Reserved_18 @0x74 {
                bytes 4;
                field ccf_Probe_T_cdma1_main_Probe_Reserved_18 {
                    bits 32;
                    access rw;
                    hard_reset 'h0;
                }
            }
            register ccf_Probe_T_cdma1_main_Probe_Reserved_19 @0x78 {
                bytes 4;
                field ccf_Probe_T_cdma1_main_Probe_Reserved_19 {
                    bits 32;
                    access rw;
                    hard_reset 'h0;
                }
            }
            register ccf_Probe_T_cdma1_main_Probe_Reserved_20 @0x7C {
                bytes 4;
                field ccf_Probe_T_cdma1_main_Probe_Reserved_20 {
                    bits 32;
                    access rw;
                    hard_reset 'h0;
                }
            }
            register ccf_Probe_T_cdma1_main_Probe_Reserved_21 @0x80 {
                bytes 4;
                field ccf_Probe_T_cdma1_main_Probe_Reserved_21 {
                    bits 32;
                    access rw;
                    hard_reset 'h0;
                }
            }
            register ccf_Probe_T_cdma1_main_Probe_Reserved_22 @0x84 {
                bytes 4;
                field ccf_Probe_T_cdma1_main_Probe_Reserved_22 {
                    bits 32;
                    access rw;
                    hard_reset 'h0;
                }
            }
            register ccf_Probe_T_cdma1_main_Probe_Reserved_23 @0x88 {
                bytes 4;
                field ccf_Probe_T_cdma1_main_Probe_Reserved_23 {
                    bits 32;
                    access rw;
                    hard_reset 'h0;
                }
            }
            register ccf_Probe_T_cdma1_main_Probe_Reserved_24 @0x8C {
                bytes 4;
                field ccf_Probe_T_cdma1_main_Probe_Reserved_24 {
                    bits 32;
                    access rw;
                    hard_reset 'h0;
                }
            }
            register ccf_Probe_T_cdma1_main_Probe_Reserved_25 @0x90 {
                bytes 4;
                field ccf_Probe_T_cdma1_main_Probe_Reserved_25 {
                    bits 32;
                    access rw;
                    hard_reset 'h0;
                }
            }
            register ccf_Probe_T_cdma1_main_Probe_Reserved_26 @0x94 {
                bytes 4;
                field ccf_Probe_T_cdma1_main_Probe_Reserved_26 {
                    bits 32;
                    access rw;
                    hard_reset 'h0;
                }
            }
            register ccf_Probe_T_cdma1_main_Probe_Reserved_27 @0x98 {
                bytes 4;
                field ccf_Probe_T_cdma1_main_Probe_Reserved_27 {
                    bits 32;
                    access rw;
                    hard_reset 'h0;
                }
            }
            register ccf_Probe_T_cdma1_main_Probe_Reserved_28 @0x9C {
                bytes 4;
                field ccf_Probe_T_cdma1_main_Probe_Reserved_28 {
                    bits 32;
                    access rw;
                    hard_reset 'h0;
                }
            }
            register ccf_Probe_T_cdma1_main_Probe_Reserved_29 @0xA0 {
                bytes 4;
                field ccf_Probe_T_cdma1_main_Probe_Reserved_29 {
                    bits 32;
                    access rw;
                    hard_reset 'h0;
                }
            }
            register ccf_Probe_T_cdma1_main_Probe_Reserved_30 @0xA4 {
                bytes 4;
                field ccf_Probe_T_cdma1_main_Probe_Reserved_30 {
                    bits 32;
                    access rw;
                    hard_reset 'h0;
                }
            }
            register ccf_Probe_T_cdma1_main_Probe_Reserved_31 @0xA8 {
                bytes 4;
                field ccf_Probe_T_cdma1_main_Probe_Reserved_31 {
                    bits 32;
                    access rw;
                    hard_reset 'h0;
                }
            }
            register ccf_Probe_T_cdma1_main_Probe_Reserved_32 @0xAC {
                bytes 4;
                field ccf_Probe_T_cdma1_main_Probe_Reserved_32 {
                    bits 32;
                    access rw;
                    hard_reset 'h0;
                }
            }
            register ccf_Probe_T_cdma1_main_Probe_Reserved_33 @0xB0 {
                bytes 4;
                field ccf_Probe_T_cdma1_main_Probe_Reserved_33 {
                    bits 32;
                    access rw;
                    hard_reset 'h0;
                }
            }
            register ccf_Probe_T_cdma1_main_Probe_Reserved_34 @0xB4 {
                bytes 4;
                field ccf_Probe_T_cdma1_main_Probe_Reserved_34 {
                    bits 32;
                    access rw;
                    hard_reset 'h0;
                }
            }
            register ccf_Probe_T_cdma1_main_Probe_Reserved_35 @0xB8 {
                bytes 4;
                field ccf_Probe_T_cdma1_main_Probe_Reserved_35 {
                    bits 32;
                    access rw;
                    hard_reset 'h0;
                }
            }
            register ccf_Probe_T_cdma1_main_Probe_Reserved_36 @0xBC {
                bytes 4;
                field ccf_Probe_T_cdma1_main_Probe_Reserved_36 {
                    bits 32;
                    access rw;
                    hard_reset 'h0;
                }
            }
            register ccf_Probe_T_cdma1_main_Probe_Reserved_37 @0xC0 {
                bytes 4;
                field ccf_Probe_T_cdma1_main_Probe_Reserved_37 {
                    bits 32;
                    access rw;
                    hard_reset 'h0;
                }
            }
            register ccf_Probe_T_cdma1_main_Probe_Reserved_38 @0xC4 {
                bytes 4;
                field ccf_Probe_T_cdma1_main_Probe_Reserved_38 {
                    bits 32;
                    access rw;
                    hard_reset 'h0;
                }
            }
            register ccf_Probe_T_cdma1_main_Probe_Reserved_39 @0xC8 {
                bytes 4;
                field ccf_Probe_T_cdma1_main_Probe_Reserved_39 {
                    bits 32;
                    access rw;
                    hard_reset 'h0;
                }
            }
            register ccf_Probe_T_cdma1_main_Probe_Reserved_40 @0xCC {
                bytes 4;
                field ccf_Probe_T_cdma1_main_Probe_Reserved_40 {
                    bits 32;
                    access rw;
                    hard_reset 'h0;
                }
            }
            register ccf_Probe_T_cdma1_main_Probe_Reserved_41 @0xD0 {
                bytes 4;
                field ccf_Probe_T_cdma1_main_Probe_Reserved_41 {
                    bits 32;
                    access rw;
                    hard_reset 'h0;
                }
            }
            register ccf_Probe_T_cdma1_main_Probe_Reserved_42 @0xD4 {
                bytes 4;
                field ccf_Probe_T_cdma1_main_Probe_Reserved_42 {
                    bits 32;
                    access rw;
                    hard_reset 'h0;
                }
            }
            register ccf_Probe_T_cdma1_main_Probe_Reserved_43 @0xD8 {
                bytes 4;
                field ccf_Probe_T_cdma1_main_Probe_Reserved_43 {
                    bits 32;
                    access rw;
                    hard_reset 'h0;
                }
            }
            register ccf_Probe_T_cdma1_main_Probe_Reserved_44 @0xDC {
                bytes 4;
                field ccf_Probe_T_cdma1_main_Probe_Reserved_44 {
                    bits 32;
                    access rw;
                    hard_reset 'h0;
                }
            }
            register ccf_Probe_T_cdma1_main_Probe_Reserved_45 @0xE0 {
                bytes 4;
                field ccf_Probe_T_cdma1_main_Probe_Reserved_45 {
                    bits 32;
                    access rw;
                    hard_reset 'h0;
                }
            }
            register ccf_Probe_T_cdma1_main_Probe_Reserved_46 @0xE4 {
                bytes 4;
                field ccf_Probe_T_cdma1_main_Probe_Reserved_46 {
                    bits 32;
                    access rw;
                    hard_reset 'h0;
                }
            }
            register ccf_Probe_T_cdma1_main_Probe_Reserved_47 @0xE8 {
                bytes 4;
                field ccf_Probe_T_cdma1_main_Probe_Reserved_47 {
                    bits 32;
                    access rw;
                    hard_reset 'h0;
                }
            }
            register ccf_Probe_T_cdma1_main_Probe_Reserved_48 @0xEC {
                bytes 4;
                field ccf_Probe_T_cdma1_main_Probe_Reserved_48 {
                    bits 32;
                    access rw;
                    hard_reset 'h0;
                }
            }
            register ccf_Probe_T_cdma1_main_Probe_Reserved_49 @0xF0 {
                bytes 4;
                field ccf_Probe_T_cdma1_main_Probe_Reserved_49 {
                    bits 32;
                    access rw;
                    hard_reset 'h0;
                }
            }
            register ccf_Probe_T_cdma1_main_Probe_Reserved_50 @0xF4 {
                bytes 4;
                field ccf_Probe_T_cdma1_main_Probe_Reserved_50 {
                    bits 32;
                    access rw;
                    hard_reset 'h0;
                }
            }
            register ccf_Probe_T_cdma1_main_Probe_Reserved_51 @0xF8 {
                bytes 4;
                field ccf_Probe_T_cdma1_main_Probe_Reserved_51 {
                    bits 32;
                    access rw;
                    hard_reset 'h0;
                }
            }
            register ccf_Probe_T_cdma1_main_Probe_Reserved_52 @0xFC {
                bytes 4;
                field ccf_Probe_T_cdma1_main_Probe_Reserved_52 {
                    bits 32;
                    access rw;
                    hard_reset 'h0;
                }
            }
            register ccf_Probe_T_cdma1_main_Probe_Reserved_53 @0x100 {
                bytes 4;
                field ccf_Probe_T_cdma1_main_Probe_Reserved_53 {
                    bits 32;
                    access rw;
                    hard_reset 'h0;
                }
            }
            register ccf_Probe_T_cdma1_main_Probe_Reserved_54 @0x104 {
                bytes 4;
                field ccf_Probe_T_cdma1_main_Probe_Reserved_54 {
                    bits 32;
                    access rw;
                    hard_reset 'h0;
                }
            }
            register ccf_Probe_T_cdma1_main_Probe_Reserved_55 @0x108 {
                bytes 4;
                field ccf_Probe_T_cdma1_main_Probe_Reserved_55 {
                    bits 32;
                    access rw;
                    hard_reset 'h0;
                }
            }
            register ccf_Probe_T_cdma1_main_Probe_Reserved_56 @0x10C {
                bytes 4;
                field ccf_Probe_T_cdma1_main_Probe_Reserved_56 {
                    bits 32;
                    access rw;
                    hard_reset 'h0;
                }
            }
            register ccf_Probe_T_cdma1_main_Probe_Reserved_57 @0x110 {
                bytes 4;
                field ccf_Probe_T_cdma1_main_Probe_Reserved_57 {
                    bits 32;
                    access rw;
                    hard_reset 'h0;
                }
            }
            register ccf_Probe_T_cdma1_main_Probe_Reserved_58 @0x114 {
                bytes 4;
                field ccf_Probe_T_cdma1_main_Probe_Reserved_58 {
                    bits 32;
                    access rw;
                    hard_reset 'h0;
                }
            }
            register ccf_Probe_T_cdma1_main_Probe_Reserved_59 @0x118 {
                bytes 4;
                field ccf_Probe_T_cdma1_main_Probe_Reserved_59 {
                    bits 32;
                    access rw;
                    hard_reset 'h0;
                }
            }
            register ccf_Probe_T_cdma1_main_Probe_Reserved_60 @0x11C {
                bytes 4;
                field ccf_Probe_T_cdma1_main_Probe_Reserved_60 {
                    bits 32;
                    access rw;
                    hard_reset 'h0;
                }
            }
            register ccf_Probe_T_cdma1_main_Probe_Reserved_61 @0x120 {
                bytes 4;
                field ccf_Probe_T_cdma1_main_Probe_Reserved_61 {
                    bits 32;
                    access rw;
                    hard_reset 'h0;
                }
            }
            register ccf_Probe_T_cdma1_main_Probe_Reserved_62 @0x124 {
                bytes 4;
                field ccf_Probe_T_cdma1_main_Probe_Reserved_62 {
                    bits 32;
                    access rw;
                    hard_reset 'h0;
                }
            }
            register ccf_Probe_T_cdma1_main_Probe_Reserved_63 @0x128 {
                bytes 4;
                field ccf_Probe_T_cdma1_main_Probe_Reserved_63 {
                    bits 32;
                    access rw;
                    hard_reset 'h0;
                }
            }
            register ccf_Probe_T_cdma1_main_Probe_Reserved_64 @0x12C {
                bytes 4;
                field ccf_Probe_T_cdma1_main_Probe_Reserved_64 {
                    bits 32;
                    access rw;
                    hard_reset 'h0;
                }
            }
            register ccf_Probe_T_cdma1_main_Probe_Reserved_65 @0x130 {
                bytes 4;
                field ccf_Probe_T_cdma1_main_Probe_Reserved_65 {
                    bits 32;
                    access rw;
                    hard_reset 'h0;
                }
            }
            register ccf_Probe_T_cdma1_main_Probe_Reserved_66 @0x134 {
                bytes 4;
                field ccf_Probe_T_cdma1_main_Probe_Reserved_66 {
                    bits 32;
                    access rw;
                    hard_reset 'h0;
                }
            }
            register ccf_Probe_T_cdma1_main_Probe_Counters_0_Src @0x138 {
                bytes 4;
                field INTEVENT @'h0 {
                    bits 5;
                    access rw;
                    hard_reset 'h0;
                    enum { OFF = 0, CYCLE = 1, IDLE = 2, XFER = 3, BUSY = 4, WAIT = 5, PKT = 6, LUT = 7, BYTE = 8, PRESS0 = 9, PRESS1 = 10, PRESS2 = 11, FILT0 = 12, FILT1 = 13, FILT2 = 14, FILT3 = 15, CHAIN = 16, LUT_BYTE_EN = 17, LUT_BYTE = 18, FILT_BYTE_EN = 19, FILT_BYTE = 20, PRESS3 = 21, PRESS4 = 22, PRESS5 = 23, PRESS6 = 24, RSV_0 = 25, RSV_1 = 26, RSV_2 = 27, RSV_3 = 28, RSV_4 = 29, RSV_5 = 30, RSV_6 = 31 };
                    doc {
                        Internal packet event
                    }
                }
                field EXTEVENT @'h5 {
                    access rw;
                    hard_reset 'h0;
                    doc {
                        When greater than 0, the entire register value is used to select an external hardware event source. The index of the external event is equal to {ExtEvent,IntEvent}.
                    }
                }
                doc {
                    Register CntSrc indicates the event source used to increment the counter. Unassigned values (non-existing Press level or ExtEvent index, or unimplemented Filter) are equivalent to OFF.
	Register CntSrc indicates the event source used to increment the counter. Unassigned values (non-existing Press level or ExtEvent index, or unimplemented Filter) are equivalent to OFF.
	
                }
            }
            register ccf_Probe_T_cdma1_main_Probe_Counters_0_AlarmMode @0x13C {
                bytes 4;
                field COUNTERS_0_ALARMMODE @'h0 {
                    bits 2;
                    access rw;
                    hard_reset 'h0;
                    enum { OFF = 0, MIN = 1, MAX = 2, MIN_MAX = 3 };
                    doc {
                        Register AlarmMode is a 2-bit register that is present when parameter statisticsCounterAlarm is set to True. The register defines the statistics-alarm behavior of the counter.
                    }
                }
            }
            register ccf_Probe_T_cdma1_main_Probe_Counters_0_Val @0x140 {
                bytes 4;
                field COUNTERS_0_VAL @'h0 {
                    bits 11;
                    access ro;
                    hard_reset 'h0;
                    doc {
                        Register Val is a read-only register that is always present. The register containsthe statistics counter value either pending StatAlarm output, or when statisticscollection is suspended subsequent to triggers or signal statSuspend.
                    }
                }
            }
            register ccf_Probe_T_cdma1_main_Probe_Reserved_67 @0x144 {
                bytes 4;
                field ccf_Probe_T_cdma1_main_Probe_Reserved_67 {
                    bits 32;
                    access rw;
                    hard_reset 'h0;
                }
            }
            register ccf_Probe_T_cdma1_main_Probe_Reserved_68 @0x148 {
                bytes 4;
                field ccf_Probe_T_cdma1_main_Probe_Reserved_68 {
                    bits 32;
                    access rw;
                    hard_reset 'h0;
                }
            }
            register ccf_Probe_T_cdma1_main_Probe_Counters_1_Src @0x14C {
                bytes 4;
                field INTEVENT @'h0 {
                    bits 5;
                    access rw;
                    hard_reset 'h0;
                    enum { OFF = 0, CYCLE = 1, IDLE = 2, XFER = 3, BUSY = 4, WAIT = 5, PKT = 6, LUT = 7, BYTE = 8, PRESS0 = 9, PRESS1 = 10, PRESS2 = 11, FILT0 = 12, FILT1 = 13, FILT2 = 14, FILT3 = 15, CHAIN = 16, LUT_BYTE_EN = 17, LUT_BYTE = 18, FILT_BYTE_EN = 19, FILT_BYTE = 20, PRESS3 = 21, PRESS4 = 22, PRESS5 = 23, PRESS6 = 24, RSV_0 = 25, RSV_1 = 26, RSV_2 = 27, RSV_3 = 28, RSV_4 = 29, RSV_5 = 30, RSV_6 = 31 };
                    doc {
                        Internal packet event
                    }
                }
                field EXTEVENT @'h5 {
                    access rw;
                    hard_reset 'h0;
                    doc {
                        When greater than 0, the entire register value is used to select an external hardware event source. The index of the external event is equal to {ExtEvent,IntEvent}.
                    }
                }
                doc {
                    Register CntSrc indicates the event source used to increment the counter. Unassigned values (non-existing Press level or ExtEvent index, or unimplemented Filter) are equivalent to OFF.
	Register CntSrc indicates the event source used to increment the counter. Unassigned values (non-existing Press level or ExtEvent index, or unimplemented Filter) are equivalent to OFF.
	
                }
            }
            register ccf_Probe_T_cdma1_main_Probe_Counters_1_AlarmMode @0x150 {
                bytes 4;
                field COUNTERS_1_ALARMMODE @'h0 {
                    bits 2;
                    access rw;
                    hard_reset 'h0;
                    enum { OFF = 0, MIN = 1, MAX = 2, MIN_MAX = 3 };
                    doc {
                        Register AlarmMode is a 2-bit register that is present when parameter statisticsCounterAlarm is set to True. The register defines the statistics-alarm behavior of the counter.
                    }
                }
            }
            register ccf_Probe_T_cdma1_main_Probe_Counters_1_Val @0x154 {
                bytes 4;
                field COUNTERS_1_VAL @'h0 {
                    bits 11;
                    access ro;
                    hard_reset 'h0;
                    doc {
                        Register Val is a read-only register that is always present. The register containsthe statistics counter value either pending StatAlarm output, or when statisticscollection is suspended subsequent to triggers or signal statSuspend.
                    }
                }
            }
            register ccf_Probe_T_cdma1_main_Probe_Reserved_69 @0x158 {
                bytes 4;
                field ccf_Probe_T_cdma1_main_Probe_Reserved_69 {
                    bits 32;
                    access rw;
                    hard_reset 'h0;
                }
            }
            register ccf_Probe_T_cdma1_main_Probe_Reserved_70 @0x15C {
                bytes 4;
                field ccf_Probe_T_cdma1_main_Probe_Reserved_70 {
                    bits 32;
                    access rw;
                    hard_reset 'h0;
                }
            }
            register ccf_Probe_T_cdma1_main_Probe_Reserved_71 @0x160 {
                bytes 4;
                field ccf_Probe_T_cdma1_main_Probe_Reserved_71 {
                    bits 32;
                    access rw;
                    hard_reset 'h0;
                }
            }
            register ccf_Probe_T_cdma1_main_Probe_Reserved_72 @0x164 {
                bytes 4;
                field ccf_Probe_T_cdma1_main_Probe_Reserved_72 {
                    bits 32;
                    access rw;
                    hard_reset 'h0;
                }
            }
            register ccf_Probe_T_cdma1_main_Probe_Reserved_73 @0x168 {
                bytes 4;
                field ccf_Probe_T_cdma1_main_Probe_Reserved_73 {
                    bits 32;
                    access rw;
                    hard_reset 'h0;
                }
            }
            register ccf_Probe_T_cdma1_main_Probe_Reserved_74 @0x16C {
                bytes 4;
                field ccf_Probe_T_cdma1_main_Probe_Reserved_74 {
                    bits 32;
                    access rw;
                    hard_reset 'h0;
                }
            }
            register ccf_Probe_T_cdma1_main_Probe_Reserved_75 @0x170 {
                bytes 4;
                field ccf_Probe_T_cdma1_main_Probe_Reserved_75 {
                    bits 32;
                    access rw;
                    hard_reset 'h0;
                }
            }
            register ccf_Probe_T_cdma1_main_Probe_Reserved_76 @0x174 {
                bytes 4;
                field ccf_Probe_T_cdma1_main_Probe_Reserved_76 {
                    bits 32;
                    access rw;
                    hard_reset 'h0;
                }
            }
            register ccf_Probe_T_cdma1_main_Probe_Reserved_77 @0x178 {
                bytes 4;
                field ccf_Probe_T_cdma1_main_Probe_Reserved_77 {
                    bits 32;
                    access rw;
                    hard_reset 'h0;
                }
            }
            register ccf_Probe_T_cdma1_main_Probe_Reserved_78 @0x17C {
                bytes 4;
                field ccf_Probe_T_cdma1_main_Probe_Reserved_78 {
                    bits 32;
                    access rw;
                    hard_reset 'h0;
                }
            }
            register ccf_Probe_T_cdma1_main_Probe_Reserved_79 @0x180 {
                bytes 4;
                field ccf_Probe_T_cdma1_main_Probe_Reserved_79 {
                    bits 32;
                    access rw;
                    hard_reset 'h0;
                }
            }
            register ccf_Probe_T_cdma1_main_Probe_Reserved_80 @0x184 {
                bytes 4;
                field ccf_Probe_T_cdma1_main_Probe_Reserved_80 {
                    bits 32;
                    access rw;
                    hard_reset 'h0;
                }
            }
            register ccf_Probe_T_cdma1_main_Probe_Reserved_81 @0x188 {
                bytes 4;
                field ccf_Probe_T_cdma1_main_Probe_Reserved_81 {
                    bits 32;
                    access rw;
                    hard_reset 'h0;
                }
            }
            register ccf_Probe_T_cdma1_main_Probe_Reserved_82 @0x18C {
                bytes 4;
                field ccf_Probe_T_cdma1_main_Probe_Reserved_82 {
                    bits 32;
                    access rw;
                    hard_reset 'h0;
                }
            }
            register ccf_Probe_T_cdma1_main_Probe_Reserved_83 @0x190 {
                bytes 4;
                field ccf_Probe_T_cdma1_main_Probe_Reserved_83 {
                    bits 32;
                    access rw;
                    hard_reset 'h0;
                }
            }
            register ccf_Probe_T_cdma1_main_Probe_Reserved_84 @0x194 {
                bytes 4;
                field ccf_Probe_T_cdma1_main_Probe_Reserved_84 {
                    bits 32;
                    access rw;
                    hard_reset 'h0;
                }
            }
            register ccf_Probe_T_cdma1_main_Probe_Reserved_85 @0x198 {
                bytes 4;
                field ccf_Probe_T_cdma1_main_Probe_Reserved_85 {
                    bits 32;
                    access rw;
                    hard_reset 'h0;
                }
            }
            register ccf_Probe_T_cdma1_main_Probe_Reserved_86 @0x19C {
                bytes 4;
                field ccf_Probe_T_cdma1_main_Probe_Reserved_86 {
                    bits 32;
                    access rw;
                    hard_reset 'h0;
                }
            }
            register ccf_Probe_T_cdma1_main_Probe_Reserved_87 @0x1A0 {
                bytes 4;
                field ccf_Probe_T_cdma1_main_Probe_Reserved_87 {
                    bits 32;
                    access rw;
                    hard_reset 'h0;
                }
            }
            register ccf_Probe_T_cdma1_main_Probe_Reserved_88 @0x1A4 {
                bytes 4;
                field ccf_Probe_T_cdma1_main_Probe_Reserved_88 {
                    bits 32;
                    access rw;
                    hard_reset 'h0;
                }
            }
            register ccf_Probe_T_cdma1_main_Probe_Reserved_89 @0x1A8 {
                bytes 4;
                field ccf_Probe_T_cdma1_main_Probe_Reserved_89 {
                    bits 32;
                    access rw;
                    hard_reset 'h0;
                }
            }
            register ccf_Probe_T_cdma1_main_Probe_Reserved_90 @0x1AC {
                bytes 4;
                field ccf_Probe_T_cdma1_main_Probe_Reserved_90 {
                    bits 32;
                    access rw;
                    hard_reset 'h0;
                }
            }
            register ccf_Probe_T_cdma1_main_Probe_Reserved_91 @0x1B0 {
                bytes 4;
                field ccf_Probe_T_cdma1_main_Probe_Reserved_91 {
                    bits 32;
                    access rw;
                    hard_reset 'h0;
                }
            }
            register ccf_Probe_T_cdma1_main_Probe_Reserved_92 @0x1B4 {
                bytes 4;
                field ccf_Probe_T_cdma1_main_Probe_Reserved_92 {
                    bits 32;
                    access rw;
                    hard_reset 'h0;
                }
            }
            register ccf_Probe_T_cdma1_main_Probe_Reserved_93 @0x1B8 {
                bytes 4;
                field ccf_Probe_T_cdma1_main_Probe_Reserved_93 {
                    bits 32;
                    access rw;
                    hard_reset 'h0;
                }
            }
            register ccf_Probe_T_cdma1_main_Probe_Reserved_94 @0x1BC {
                bytes 4;
                field ccf_Probe_T_cdma1_main_Probe_Reserved_94 {
                    bits 32;
                    access rw;
                    hard_reset 'h0;
                }
            }
            register ccf_Probe_T_cdma1_main_Probe_Reserved_95 @0x1C0 {
                bytes 4;
                field ccf_Probe_T_cdma1_main_Probe_Reserved_95 {
                    bits 32;
                    access rw;
                    hard_reset 'h0;
                }
            }
            register ccf_Probe_T_cdma1_main_Probe_Reserved_96 @0x1C4 {
                bytes 4;
                field ccf_Probe_T_cdma1_main_Probe_Reserved_96 {
                    bits 32;
                    access rw;
                    hard_reset 'h0;
                }
            }
            register ccf_Probe_T_cdma1_main_Probe_Reserved_97 @0x1C8 {
                bytes 4;
                field ccf_Probe_T_cdma1_main_Probe_Reserved_97 {
                    bits 32;
                    access rw;
                    hard_reset 'h0;
                }
            }
            register ccf_Probe_T_cdma1_main_Probe_Reserved_98 @0x1CC {
                bytes 4;
                field ccf_Probe_T_cdma1_main_Probe_Reserved_98 {
                    bits 32;
                    access rw;
                    hard_reset 'h0;
                }
            }
            register ccf_Probe_T_cdma1_main_Probe_Reserved_99 @0x1D0 {
                bytes 4;
                field ccf_Probe_T_cdma1_main_Probe_Reserved_99 {
                    bits 32;
                    access rw;
                    hard_reset 'h0;
                }
            }
            register ccf_Probe_T_cdma1_main_Probe_Reserved_100 @0x1D4 {
                bytes 4;
                field ccf_Probe_T_cdma1_main_Probe_Reserved_100 {
                    bits 32;
                    access rw;
                    hard_reset 'h0;
                }
            }
            register ccf_Probe_T_cdma1_main_Probe_Reserved_101 @0x1D8 {
                bytes 4;
                field ccf_Probe_T_cdma1_main_Probe_Reserved_101 {
                    bits 32;
                    access rw;
                    hard_reset 'h0;
                }
            }
            register ccf_Probe_T_cdma1_main_Probe_Reserved_102 @0x1DC {
                bytes 4;
                field ccf_Probe_T_cdma1_main_Probe_Reserved_102 {
                    bits 32;
                    access rw;
                    hard_reset 'h0;
                }
            }
            register ccf_Probe_T_cdma1_main_Probe_Reserved_103 @0x1E0 {
                bytes 4;
                field ccf_Probe_T_cdma1_main_Probe_Reserved_103 {
                    bits 32;
                    access rw;
                    hard_reset 'h0;
                }
            }
            register ccf_Probe_T_cdma1_main_Probe_Reserved_104 @0x1E4 {
                bytes 4;
                field ccf_Probe_T_cdma1_main_Probe_Reserved_104 {
                    bits 32;
                    access rw;
                    hard_reset 'h0;
                }
            }
            register ccf_Probe_T_cdma1_main_Probe_Reserved_105 @0x1E8 {
                bytes 4;
                field ccf_Probe_T_cdma1_main_Probe_Reserved_105 {
                    bits 32;
                    access rw;
                    hard_reset 'h0;
                }
            }
            register ccf_Probe_T_cdma1_main_Probe_Reserved_106 @0x1EC {
                bytes 4;
                field ccf_Probe_T_cdma1_main_Probe_Reserved_106 {
                    bits 32;
                    access rw;
                    hard_reset 'h0;
                }
            }
            register ccf_Probe_T_cdma1_main_Probe_Reserved_107 @0x1F0 {
                bytes 4;
                field ccf_Probe_T_cdma1_main_Probe_Reserved_107 {
                    bits 32;
                    access rw;
                    hard_reset 'h0;
                }
            }
            register ccf_Probe_T_cdma1_main_Probe_Reserved_108 @0x1F4 {
                bytes 4;
                field ccf_Probe_T_cdma1_main_Probe_Reserved_108 {
                    bits 32;
                    access rw;
                    hard_reset 'h0;
                }
            }
            register ccf_Probe_T_cdma1_main_Probe_Reserved_109 @0x1F8 {
                bytes 4;
                field ccf_Probe_T_cdma1_main_Probe_Reserved_109 {
                    bits 32;
                    access rw;
                    hard_reset 'h0;
                }
            }
            register ccf_Probe_T_cdma1_main_Probe_Reserved_110 @0x1FC {
                bytes 4;
                field ccf_Probe_T_cdma1_main_Probe_Reserved_110 {
                    bits 32;
                    access rw;
                    hard_reset 'h0;
                }
            }
            register ccf_Probe_T_cdma1_main_Probe_Reserved_111 @0x200 {
                bytes 4;
                field ccf_Probe_T_cdma1_main_Probe_Reserved_111 {
                    bits 32;
                    access rw;
                    hard_reset 'h0;
                }
            }
            register ccf_Probe_T_cdma1_main_Probe_Reserved_112 @0x204 {
                bytes 4;
                field ccf_Probe_T_cdma1_main_Probe_Reserved_112 {
                    bits 32;
                    access rw;
                    hard_reset 'h0;
                }
            }
            register ccf_Probe_T_cdma1_main_Probe_Reserved_113 @0x208 {
                bytes 4;
                field ccf_Probe_T_cdma1_main_Probe_Reserved_113 {
                    bits 32;
                    access rw;
                    hard_reset 'h0;
                }
            }
            register ccf_Probe_T_cdma1_main_Probe_Reserved_114 @0x20C {
                bytes 4;
                field ccf_Probe_T_cdma1_main_Probe_Reserved_114 {
                    bits 32;
                    access rw;
                    hard_reset 'h0;
                }
            }
            register ccf_Probe_T_cdma1_main_Probe_Reserved_115 @0x210 {
                bytes 4;
                field ccf_Probe_T_cdma1_main_Probe_Reserved_115 {
                    bits 32;
                    access rw;
                    hard_reset 'h0;
                }
            }
            register ccf_Probe_T_cdma1_main_Probe_Reserved_116 @0x214 {
                bytes 4;
                field ccf_Probe_T_cdma1_main_Probe_Reserved_116 {
                    bits 32;
                    access rw;
                    hard_reset 'h0;
                }
            }
            register ccf_Probe_T_cdma1_main_Probe_Reserved_117 @0x218 {
                bytes 4;
                field ccf_Probe_T_cdma1_main_Probe_Reserved_117 {
                    bits 32;
                    access rw;
                    hard_reset 'h0;
                }
            }
            register ccf_Probe_T_cdma1_main_Probe_Reserved_118 @0x21C {
                bytes 4;
                field ccf_Probe_T_cdma1_main_Probe_Reserved_118 {
                    bits 32;
                    access rw;
                    hard_reset 'h0;
                }
            }
            register ccf_Probe_T_cdma1_main_Probe_Reserved_119 @0x220 {
                bytes 4;
                field ccf_Probe_T_cdma1_main_Probe_Reserved_119 {
                    bits 32;
                    access rw;
                    hard_reset 'h0;
                }
            }
            register ccf_Probe_T_cdma1_main_Probe_Reserved_120 @0x224 {
                bytes 4;
                field ccf_Probe_T_cdma1_main_Probe_Reserved_120 {
                    bits 32;
                    access rw;
                    hard_reset 'h0;
                }
            }
            register ccf_Probe_T_cdma1_main_Probe_Reserved_121 @0x228 {
                bytes 4;
                field ccf_Probe_T_cdma1_main_Probe_Reserved_121 {
                    bits 32;
                    access rw;
                    hard_reset 'h0;
                }
            }
            register ccf_Probe_T_cdma1_main_Probe_Reserved_122 @0x22C {
                bytes 4;
                field ccf_Probe_T_cdma1_main_Probe_Reserved_122 {
                    bits 32;
                    access rw;
                    hard_reset 'h0;
                }
            }
            register ccf_Probe_T_cdma1_main_Probe_Reserved_123 @0x230 {
                bytes 4;
                field ccf_Probe_T_cdma1_main_Probe_Reserved_123 {
                    bits 32;
                    access rw;
                    hard_reset 'h0;
                }
            }
            register ccf_Probe_T_cdma1_main_Probe_Reserved_124 @0x234 {
                bytes 4;
                field ccf_Probe_T_cdma1_main_Probe_Reserved_124 {
                    bits 32;
                    access rw;
                    hard_reset 'h0;
                }
            }
            register ccf_Probe_T_cdma1_main_Probe_Reserved_125 @0x238 {
                bytes 4;
                field ccf_Probe_T_cdma1_main_Probe_Reserved_125 {
                    bits 32;
                    access rw;
                    hard_reset 'h0;
                }
            }
            register ccf_Probe_T_cdma1_main_Probe_Reserved_126 @0x23C {
                bytes 4;
                field ccf_Probe_T_cdma1_main_Probe_Reserved_126 {
                    bits 32;
                    access rw;
                    hard_reset 'h0;
                }
            }
            register ccf_Probe_T_cdma1_main_Probe_Reserved_127 @0x240 {
                bytes 4;
                field ccf_Probe_T_cdma1_main_Probe_Reserved_127 {
                    bits 32;
                    access rw;
                    hard_reset 'h0;
                }
            }
            register ccf_Probe_T_cdma1_main_Probe_Reserved_128 @0x244 {
                bytes 4;
                field ccf_Probe_T_cdma1_main_Probe_Reserved_128 {
                    bits 32;
                    access rw;
                    hard_reset 'h0;
                }
            }
            register ccf_Probe_T_cdma1_main_Probe_Reserved_129 @0x248 {
                bytes 4;
                field ccf_Probe_T_cdma1_main_Probe_Reserved_129 {
                    bits 32;
                    access rw;
                    hard_reset 'h0;
                }
            }
            register ccf_Probe_T_cdma1_main_Probe_Reserved_130 @0x24C {
                bytes 4;
                field ccf_Probe_T_cdma1_main_Probe_Reserved_130 {
                    bits 32;
                    access rw;
                    hard_reset 'h0;
                }
            }
            register ccf_Probe_T_cdma1_main_Probe_Reserved_131 @0x250 {
                bytes 4;
                field ccf_Probe_T_cdma1_main_Probe_Reserved_131 {
                    bits 32;
                    access rw;
                    hard_reset 'h0;
                }
            }
            register ccf_Probe_T_cdma1_main_Probe_Reserved_132 @0x254 {
                bytes 4;
                field ccf_Probe_T_cdma1_main_Probe_Reserved_132 {
                    bits 32;
                    access rw;
                    hard_reset 'h0;
                }
            }
            register ccf_Probe_T_cdma1_main_Probe_Reserved_133 @0x258 {
                bytes 4;
                field ccf_Probe_T_cdma1_main_Probe_Reserved_133 {
                    bits 32;
                    access rw;
                    hard_reset 'h0;
                }
            }
            register ccf_Probe_T_cdma1_main_Probe_Reserved_134 @0x25C {
                bytes 4;
                field ccf_Probe_T_cdma1_main_Probe_Reserved_134 {
                    bits 32;
                    access rw;
                    hard_reset 'h0;
                }
            }
            register ccf_Probe_T_cdma1_main_Probe_Reserved_135 @0x260 {
                bytes 4;
                field ccf_Probe_T_cdma1_main_Probe_Reserved_135 {
                    bits 32;
                    access rw;
                    hard_reset 'h0;
                }
            }
            register ccf_Probe_T_cdma1_main_Probe_Reserved_136 @0x264 {
                bytes 4;
                field ccf_Probe_T_cdma1_main_Probe_Reserved_136 {
                    bits 32;
                    access rw;
                    hard_reset 'h0;
                }
            }
            register ccf_Probe_T_cdma1_main_Probe_Reserved_137 @0x268 {
                bytes 4;
                field ccf_Probe_T_cdma1_main_Probe_Reserved_137 {
                    bits 32;
                    access rw;
                    hard_reset 'h0;
                }
            }
            register ccf_Probe_T_cdma1_main_Probe_Reserved_138 @0x26C {
                bytes 4;
                field ccf_Probe_T_cdma1_main_Probe_Reserved_138 {
                    bits 32;
                    access rw;
                    hard_reset 'h0;
                }
            }
            register ccf_Probe_T_cdma1_main_Probe_Reserved_139 @0x270 {
                bytes 4;
                field ccf_Probe_T_cdma1_main_Probe_Reserved_139 {
                    bits 32;
                    access rw;
                    hard_reset 'h0;
                }
            }
            register ccf_Probe_T_cdma1_main_Probe_Reserved_140 @0x274 {
                bytes 4;
                field ccf_Probe_T_cdma1_main_Probe_Reserved_140 {
                    bits 32;
                    access rw;
                    hard_reset 'h0;
                }
            }
            register ccf_Probe_T_cdma1_main_Probe_Reserved_141 @0x278 {
                bytes 4;
                field ccf_Probe_T_cdma1_main_Probe_Reserved_141 {
                    bits 32;
                    access rw;
                    hard_reset 'h0;
                }
            }
            register ccf_Probe_T_cdma1_main_Probe_Reserved_142 @0x27C {
                bytes 4;
                field ccf_Probe_T_cdma1_main_Probe_Reserved_142 {
                    bits 32;
                    access rw;
                    hard_reset 'h0;
                }
            }
            register ccf_Probe_T_cdma1_main_Probe_Reserved_143 @0x280 {
                bytes 4;
                field ccf_Probe_T_cdma1_main_Probe_Reserved_143 {
                    bits 32;
                    access rw;
                    hard_reset 'h0;
                }
            }
            register ccf_Probe_T_cdma1_main_Probe_Reserved_144 @0x284 {
                bytes 4;
                field ccf_Probe_T_cdma1_main_Probe_Reserved_144 {
                    bits 32;
                    access rw;
                    hard_reset 'h0;
                }
            }
            register ccf_Probe_T_cdma1_main_Probe_Reserved_145 @0x288 {
                bytes 4;
                field ccf_Probe_T_cdma1_main_Probe_Reserved_145 {
                    bits 32;
                    access rw;
                    hard_reset 'h0;
                }
            }
            register ccf_Probe_T_cdma1_main_Probe_Reserved_146 @0x28C {
                bytes 4;
                field ccf_Probe_T_cdma1_main_Probe_Reserved_146 {
                    bits 32;
                    access rw;
                    hard_reset 'h0;
                }
            }
            register ccf_Probe_T_cdma1_main_Probe_Reserved_147 @0x290 {
                bytes 4;
                field ccf_Probe_T_cdma1_main_Probe_Reserved_147 {
                    bits 32;
                    access rw;
                    hard_reset 'h0;
                }
            }
            register ccf_Probe_T_cdma1_main_Probe_Reserved_148 @0x294 {
                bytes 4;
                field ccf_Probe_T_cdma1_main_Probe_Reserved_148 {
                    bits 32;
                    access rw;
                    hard_reset 'h0;
                }
            }
            register ccf_Probe_T_cdma1_main_Probe_Reserved_149 @0x298 {
                bytes 4;
                field ccf_Probe_T_cdma1_main_Probe_Reserved_149 {
                    bits 32;
                    access rw;
                    hard_reset 'h0;
                }
            }
            register ccf_Probe_T_cdma1_main_Probe_Reserved_150 @0x29C {
                bytes 4;
                field ccf_Probe_T_cdma1_main_Probe_Reserved_150 {
                    bits 32;
                    access rw;
                    hard_reset 'h0;
                }
            }
            register ccf_Probe_T_cdma1_main_Probe_Reserved_151 @0x2A0 {
                bytes 4;
                field ccf_Probe_T_cdma1_main_Probe_Reserved_151 {
                    bits 32;
                    access rw;
                    hard_reset 'h0;
                }
            }
            register ccf_Probe_T_cdma1_main_Probe_Reserved_152 @0x2A4 {
                bytes 4;
                field ccf_Probe_T_cdma1_main_Probe_Reserved_152 {
                    bits 32;
                    access rw;
                    hard_reset 'h0;
                }
            }
            register ccf_Probe_T_cdma1_main_Probe_Reserved_153 @0x2A8 {
                bytes 4;
                field ccf_Probe_T_cdma1_main_Probe_Reserved_153 {
                    bits 32;
                    access rw;
                    hard_reset 'h0;
                }
            }
            register ccf_Probe_T_cdma1_main_Probe_Reserved_154 @0x2AC {
                bytes 4;
                field ccf_Probe_T_cdma1_main_Probe_Reserved_154 {
                    bits 32;
                    access rw;
                    hard_reset 'h0;
                }
            }
            register ccf_Probe_T_cdma1_main_Probe_Reserved_155 @0x2B0 {
                bytes 4;
                field ccf_Probe_T_cdma1_main_Probe_Reserved_155 {
                    bits 32;
                    access rw;
                    hard_reset 'h0;
                }
            }
            register ccf_Probe_T_cdma1_main_Probe_Reserved_156 @0x2B4 {
                bytes 4;
                field ccf_Probe_T_cdma1_main_Probe_Reserved_156 {
                    bits 32;
                    access rw;
                    hard_reset 'h0;
                }
            }
            register ccf_Probe_T_cdma1_main_Probe_Reserved_157 @0x2B8 {
                bytes 4;
                field ccf_Probe_T_cdma1_main_Probe_Reserved_157 {
                    bits 32;
                    access rw;
                    hard_reset 'h0;
                }
            }
            register ccf_Probe_T_cdma1_main_Probe_Reserved_158 @0x2BC {
                bytes 4;
                field ccf_Probe_T_cdma1_main_Probe_Reserved_158 {
                    bits 32;
                    access rw;
                    hard_reset 'h0;
                }
            }
            register ccf_Probe_T_cdma1_main_Probe_Reserved_159 @0x2C0 {
                bytes 4;
                field ccf_Probe_T_cdma1_main_Probe_Reserved_159 {
                    bits 32;
                    access rw;
                    hard_reset 'h0;
                }
            }
            register ccf_Probe_T_cdma1_main_Probe_Reserved_160 @0x2C4 {
                bytes 4;
                field ccf_Probe_T_cdma1_main_Probe_Reserved_160 {
                    bits 32;
                    access rw;
                    hard_reset 'h0;
                }
            }
            register ccf_Probe_T_cdma1_main_Probe_Reserved_161 @0x2C8 {
                bytes 4;
                field ccf_Probe_T_cdma1_main_Probe_Reserved_161 {
                    bits 32;
                    access rw;
                    hard_reset 'h0;
                }
            }
            register ccf_Probe_T_cdma1_main_Probe_Reserved_162 @0x2CC {
                bytes 4;
                field ccf_Probe_T_cdma1_main_Probe_Reserved_162 {
                    bits 32;
                    access rw;
                    hard_reset 'h0;
                }
            }
            register ccf_Probe_T_cdma1_main_Probe_Reserved_163 @0x2D0 {
                bytes 4;
                field ccf_Probe_T_cdma1_main_Probe_Reserved_163 {
                    bits 32;
                    access rw;
                    hard_reset 'h0;
                }
            }
            register ccf_Probe_T_cdma1_main_Probe_Reserved_164 @0x2D4 {
                bytes 4;
                field ccf_Probe_T_cdma1_main_Probe_Reserved_164 {
                    bits 32;
                    access rw;
                    hard_reset 'h0;
                }
            }
            register ccf_Probe_T_cdma1_main_Probe_Reserved_165 @0x2D8 {
                bytes 4;
                field ccf_Probe_T_cdma1_main_Probe_Reserved_165 {
                    bits 32;
                    access rw;
                    hard_reset 'h0;
                }
            }
            register ccf_Probe_T_cdma1_main_Probe_Reserved_166 @0x2DC {
                bytes 4;
                field ccf_Probe_T_cdma1_main_Probe_Reserved_166 {
                    bits 32;
                    access rw;
                    hard_reset 'h0;
                }
            }
            register ccf_Probe_T_cdma1_main_Probe_Reserved_167 @0x2E0 {
                bytes 4;
                field ccf_Probe_T_cdma1_main_Probe_Reserved_167 {
                    bits 32;
                    access rw;
                    hard_reset 'h0;
                }
            }
            register ccf_Probe_T_cdma1_main_Probe_Reserved_168 @0x2E4 {
                bytes 4;
                field ccf_Probe_T_cdma1_main_Probe_Reserved_168 {
                    bits 32;
                    access rw;
                    hard_reset 'h0;
                }
            }
            register ccf_Probe_T_cdma1_main_Probe_Reserved_169 @0x2E8 {
                bytes 4;
                field ccf_Probe_T_cdma1_main_Probe_Reserved_169 {
                    bits 32;
                    access rw;
                    hard_reset 'h0;
                }
            }
            register ccf_Probe_T_cdma1_main_Probe_Reserved_170 @0x2EC {
                bytes 4;
                field ccf_Probe_T_cdma1_main_Probe_Reserved_170 {
                    bits 32;
                    access rw;
                    hard_reset 'h0;
                }
            }
            register ccf_Probe_T_cdma1_main_Probe_Reserved_171 @0x2F0 {
                bytes 4;
                field ccf_Probe_T_cdma1_main_Probe_Reserved_171 {
                    bits 32;
                    access rw;
                    hard_reset 'h0;
                }
            }
            register ccf_Probe_T_cdma1_main_Probe_Reserved_172 @0x2F4 {
                bytes 4;
                field ccf_Probe_T_cdma1_main_Probe_Reserved_172 {
                    bits 32;
                    access rw;
                    hard_reset 'h0;
                }
            }
            register ccf_Probe_T_cdma1_main_Probe_Reserved_173 @0x2F8 {
                bytes 4;
                field ccf_Probe_T_cdma1_main_Probe_Reserved_173 {
                    bits 32;
                    access rw;
                    hard_reset 'h0;
                }
            }
            register ccf_Probe_T_cdma1_main_Probe_Reserved_174 @0x2FC {
                bytes 4;
                field ccf_Probe_T_cdma1_main_Probe_Reserved_174 {
                    bits 32;
                    access rw;
                    hard_reset 'h0;
                }
            }
            register ccf_Probe_T_cdma1_main_Probe_Reserved_175 @0x300 {
                bytes 4;
                field ccf_Probe_T_cdma1_main_Probe_Reserved_175 {
                    bits 32;
                    access rw;
                    hard_reset 'h0;
                }
            }
            register ccf_Probe_T_cdma1_main_Probe_Reserved_176 @0x304 {
                bytes 4;
                field ccf_Probe_T_cdma1_main_Probe_Reserved_176 {
                    bits 32;
                    access rw;
                    hard_reset 'h0;
                }
            }
            register ccf_Probe_T_cdma1_main_Probe_Reserved_177 @0x308 {
                bytes 4;
                field ccf_Probe_T_cdma1_main_Probe_Reserved_177 {
                    bits 32;
                    access rw;
                    hard_reset 'h0;
                }
            }
            register ccf_Probe_T_cdma1_main_Probe_Reserved_178 @0x30C {
                bytes 4;
                field ccf_Probe_T_cdma1_main_Probe_Reserved_178 {
                    bits 32;
                    access rw;
                    hard_reset 'h0;
                }
            }
            register ccf_Probe_T_cdma1_main_Probe_Reserved_179 @0x310 {
                bytes 4;
                field ccf_Probe_T_cdma1_main_Probe_Reserved_179 {
                    bits 32;
                    access rw;
                    hard_reset 'h0;
                }
            }
            register ccf_Probe_T_cdma1_main_Probe_Reserved_180 @0x314 {
                bytes 4;
                field ccf_Probe_T_cdma1_main_Probe_Reserved_180 {
                    bits 32;
                    access rw;
                    hard_reset 'h0;
                }
            }
            register ccf_Probe_T_cdma1_main_Probe_Reserved_181 @0x318 {
                bytes 4;
                field ccf_Probe_T_cdma1_main_Probe_Reserved_181 {
                    bits 32;
                    access rw;
                    hard_reset 'h0;
                }
            }
            register ccf_Probe_T_cdma1_main_Probe_Reserved_182 @0x31C {
                bytes 4;
                field ccf_Probe_T_cdma1_main_Probe_Reserved_182 {
                    bits 32;
                    access rw;
                    hard_reset 'h0;
                }
            }
            register ccf_Probe_T_cdma1_main_Probe_Reserved_183 @0x320 {
                bytes 4;
                field ccf_Probe_T_cdma1_main_Probe_Reserved_183 {
                    bits 32;
                    access rw;
                    hard_reset 'h0;
                }
            }
            register ccf_Probe_T_cdma1_main_Probe_Reserved_184 @0x324 {
                bytes 4;
                field ccf_Probe_T_cdma1_main_Probe_Reserved_184 {
                    bits 32;
                    access rw;
                    hard_reset 'h0;
                }
            }
            register ccf_Probe_T_cdma1_main_Probe_Reserved_185 @0x328 {
                bytes 4;
                field ccf_Probe_T_cdma1_main_Probe_Reserved_185 {
                    bits 32;
                    access rw;
                    hard_reset 'h0;
                }
            }
            register ccf_Probe_T_cdma1_main_Probe_Reserved_186 @0x32C {
                bytes 4;
                field ccf_Probe_T_cdma1_main_Probe_Reserved_186 {
                    bits 32;
                    access rw;
                    hard_reset 'h0;
                }
            }
            register ccf_Probe_T_cdma1_main_Probe_Reserved_187 @0x330 {
                bytes 4;
                field ccf_Probe_T_cdma1_main_Probe_Reserved_187 {
                    bits 32;
                    access rw;
                    hard_reset 'h0;
                }
            }
            register ccf_Probe_T_cdma1_main_Probe_Reserved_188 @0x334 {
                bytes 4;
                field ccf_Probe_T_cdma1_main_Probe_Reserved_188 {
                    bits 32;
                    access rw;
                    hard_reset 'h0;
                }
            }
            register ccf_Probe_T_cdma1_main_Probe_Reserved_189 @0x338 {
                bytes 4;
                field ccf_Probe_T_cdma1_main_Probe_Reserved_189 {
                    bits 32;
                    access rw;
                    hard_reset 'h0;
                }
            }
            register ccf_Probe_T_cdma1_main_Probe_Reserved_190 @0x33C {
                bytes 4;
                field ccf_Probe_T_cdma1_main_Probe_Reserved_190 {
                    bits 32;
                    access rw;
                    hard_reset 'h0;
                }
            }
            register ccf_Probe_T_cdma1_main_Probe_Reserved_191 @0x340 {
                bytes 4;
                field ccf_Probe_T_cdma1_main_Probe_Reserved_191 {
                    bits 32;
                    access rw;
                    hard_reset 'h0;
                }
            }
            register ccf_Probe_T_cdma1_main_Probe_Reserved_192 @0x344 {
                bytes 4;
                field ccf_Probe_T_cdma1_main_Probe_Reserved_192 {
                    bits 32;
                    access rw;
                    hard_reset 'h0;
                }
            }
            register ccf_Probe_T_cdma1_main_Probe_Reserved_193 @0x348 {
                bytes 4;
                field ccf_Probe_T_cdma1_main_Probe_Reserved_193 {
                    bits 32;
                    access rw;
                    hard_reset 'h0;
                }
            }
            register ccf_Probe_T_cdma1_main_Probe_Reserved_194 @0x34C {
                bytes 4;
                field ccf_Probe_T_cdma1_main_Probe_Reserved_194 {
                    bits 32;
                    access rw;
                    hard_reset 'h0;
                }
            }
            register ccf_Probe_T_cdma1_main_Probe_Reserved_195 @0x350 {
                bytes 4;
                field ccf_Probe_T_cdma1_main_Probe_Reserved_195 {
                    bits 32;
                    access rw;
                    hard_reset 'h0;
                }
            }
            register ccf_Probe_T_cdma1_main_Probe_Reserved_196 @0x354 {
                bytes 4;
                field ccf_Probe_T_cdma1_main_Probe_Reserved_196 {
                    bits 32;
                    access rw;
                    hard_reset 'h0;
                }
            }
            register ccf_Probe_T_cdma1_main_Probe_Reserved_197 @0x358 {
                bytes 4;
                field ccf_Probe_T_cdma1_main_Probe_Reserved_197 {
                    bits 32;
                    access rw;
                    hard_reset 'h0;
                }
            }
            register ccf_Probe_T_cdma1_main_Probe_Reserved_198 @0x35C {
                bytes 4;
                field ccf_Probe_T_cdma1_main_Probe_Reserved_198 {
                    bits 32;
                    access rw;
                    hard_reset 'h0;
                }
            }
            register ccf_Probe_T_cdma1_main_Probe_Reserved_199 @0x360 {
                bytes 4;
                field ccf_Probe_T_cdma1_main_Probe_Reserved_199 {
                    bits 32;
                    access rw;
                    hard_reset 'h0;
                }
            }
            register ccf_Probe_T_cdma1_main_Probe_Reserved_200 @0x364 {
                bytes 4;
                field ccf_Probe_T_cdma1_main_Probe_Reserved_200 {
                    bits 32;
                    access rw;
                    hard_reset 'h0;
                }
            }
            register ccf_Probe_T_cdma1_main_Probe_Reserved_201 @0x368 {
                bytes 4;
                field ccf_Probe_T_cdma1_main_Probe_Reserved_201 {
                    bits 32;
                    access rw;
                    hard_reset 'h0;
                }
            }
            register ccf_Probe_T_cdma1_main_Probe_Reserved_202 @0x36C {
                bytes 4;
                field ccf_Probe_T_cdma1_main_Probe_Reserved_202 {
                    bits 32;
                    access rw;
                    hard_reset 'h0;
                }
            }
            register ccf_Probe_T_cdma1_main_Probe_Reserved_203 @0x370 {
                bytes 4;
                field ccf_Probe_T_cdma1_main_Probe_Reserved_203 {
                    bits 32;
                    access rw;
                    hard_reset 'h0;
                }
            }
            register ccf_Probe_T_cdma1_main_Probe_Reserved_204 @0x374 {
                bytes 4;
                field ccf_Probe_T_cdma1_main_Probe_Reserved_204 {
                    bits 32;
                    access rw;
                    hard_reset 'h0;
                }
            }
            register ccf_Probe_T_cdma1_main_Probe_Reserved_205 @0x378 {
                bytes 4;
                field ccf_Probe_T_cdma1_main_Probe_Reserved_205 {
                    bits 32;
                    access rw;
                    hard_reset 'h0;
                }
            }
            register ccf_Probe_T_cdma1_main_Probe_Reserved_206 @0x37C {
                bytes 4;
                field ccf_Probe_T_cdma1_main_Probe_Reserved_206 {
                    bits 32;
                    access rw;
                    hard_reset 'h0;
                }
            }
            register ccf_Probe_T_cdma1_main_Probe_Reserved_207 @0x380 {
                bytes 4;
                field ccf_Probe_T_cdma1_main_Probe_Reserved_207 {
                    bits 32;
                    access rw;
                    hard_reset 'h0;
                }
            }
            register ccf_Probe_T_cdma1_main_Probe_Reserved_208 @0x384 {
                bytes 4;
                field ccf_Probe_T_cdma1_main_Probe_Reserved_208 {
                    bits 32;
                    access rw;
                    hard_reset 'h0;
                }
            }
            register ccf_Probe_T_cdma1_main_Probe_Reserved_209 @0x388 {
                bytes 4;
                field ccf_Probe_T_cdma1_main_Probe_Reserved_209 {
                    bits 32;
                    access rw;
                    hard_reset 'h0;
                }
            }
            register ccf_Probe_T_cdma1_main_Probe_Reserved_210 @0x38C {
                bytes 4;
                field ccf_Probe_T_cdma1_main_Probe_Reserved_210 {
                    bits 32;
                    access rw;
                    hard_reset 'h0;
                }
            }
            register ccf_Probe_T_cdma1_main_Probe_Reserved_211 @0x390 {
                bytes 4;
                field ccf_Probe_T_cdma1_main_Probe_Reserved_211 {
                    bits 32;
                    access rw;
                    hard_reset 'h0;
                }
            }
            register ccf_Probe_T_cdma1_main_Probe_Reserved_212 @0x394 {
                bytes 4;
                field ccf_Probe_T_cdma1_main_Probe_Reserved_212 {
                    bits 32;
                    access rw;
                    hard_reset 'h0;
                }
            }
            register ccf_Probe_T_cdma1_main_Probe_Reserved_213 @0x398 {
                bytes 4;
                field ccf_Probe_T_cdma1_main_Probe_Reserved_213 {
                    bits 32;
                    access rw;
                    hard_reset 'h0;
                }
            }
            register ccf_Probe_T_cdma1_main_Probe_Reserved_214 @0x39C {
                bytes 4;
                field ccf_Probe_T_cdma1_main_Probe_Reserved_214 {
                    bits 32;
                    access rw;
                    hard_reset 'h0;
                }
            }
            register ccf_Probe_T_cdma1_main_Probe_Reserved_215 @0x3A0 {
                bytes 4;
                field ccf_Probe_T_cdma1_main_Probe_Reserved_215 {
                    bits 32;
                    access rw;
                    hard_reset 'h0;
                }
            }
            register ccf_Probe_T_cdma1_main_Probe_Reserved_216 @0x3A4 {
                bytes 4;
                field ccf_Probe_T_cdma1_main_Probe_Reserved_216 {
                    bits 32;
                    access rw;
                    hard_reset 'h0;
                }
            }
            register ccf_Probe_T_cdma1_main_Probe_Reserved_217 @0x3A8 {
                bytes 4;
                field ccf_Probe_T_cdma1_main_Probe_Reserved_217 {
                    bits 32;
                    access rw;
                    hard_reset 'h0;
                }
            }
            register ccf_Probe_T_cdma1_main_Probe_Reserved_218 @0x3AC {
                bytes 4;
                field ccf_Probe_T_cdma1_main_Probe_Reserved_218 {
                    bits 32;
                    access rw;
                    hard_reset 'h0;
                }
            }
            register ccf_Probe_T_cdma1_main_Probe_Reserved_219 @0x3B0 {
                bytes 4;
                field ccf_Probe_T_cdma1_main_Probe_Reserved_219 {
                    bits 32;
                    access rw;
                    hard_reset 'h0;
                }
            }
            register ccf_Probe_T_cdma1_main_Probe_Reserved_220 @0x3B4 {
                bytes 4;
                field ccf_Probe_T_cdma1_main_Probe_Reserved_220 {
                    bits 32;
                    access rw;
                    hard_reset 'h0;
                }
            }
            register ccf_Probe_T_cdma1_main_Probe_Reserved_221 @0x3B8 {
                bytes 4;
                field ccf_Probe_T_cdma1_main_Probe_Reserved_221 {
                    bits 32;
                    access rw;
                    hard_reset 'h0;
                }
            }
            register ccf_Probe_T_cdma1_main_Probe_Reserved_222 @0x3BC {
                bytes 4;
                field ccf_Probe_T_cdma1_main_Probe_Reserved_222 {
                    bits 32;
                    access rw;
                    hard_reset 'h0;
                }
            }
            register ccf_Probe_T_cdma1_main_Probe_Reserved_223 @0x3C0 {
                bytes 4;
                field ccf_Probe_T_cdma1_main_Probe_Reserved_223 {
                    bits 32;
                    access rw;
                    hard_reset 'h0;
                }
            }
            register ccf_Probe_T_cdma1_main_Probe_Reserved_224 @0x3C4 {
                bytes 4;
                field ccf_Probe_T_cdma1_main_Probe_Reserved_224 {
                    bits 32;
                    access rw;
                    hard_reset 'h0;
                }
            }
            register ccf_Probe_T_cdma1_main_Probe_Reserved_225 @0x3C8 {
                bytes 4;
                field ccf_Probe_T_cdma1_main_Probe_Reserved_225 {
                    bits 32;
                    access rw;
                    hard_reset 'h0;
                }
            }
            register ccf_Probe_T_cdma1_main_Probe_Reserved_226 @0x3CC {
                bytes 4;
                field ccf_Probe_T_cdma1_main_Probe_Reserved_226 {
                    bits 32;
                    access rw;
                    hard_reset 'h0;
                }
            }
            register ccf_Probe_T_cdma1_main_Probe_Reserved_227 @0x3D0 {
                bytes 4;
                field ccf_Probe_T_cdma1_main_Probe_Reserved_227 {
                    bits 32;
                    access rw;
                    hard_reset 'h0;
                }
            }
            register ccf_Probe_T_cdma1_main_Probe_Reserved_228 @0x3D4 {
                bytes 4;
                field ccf_Probe_T_cdma1_main_Probe_Reserved_228 {
                    bits 32;
                    access rw;
                    hard_reset 'h0;
                }
            }
            register ccf_Probe_T_cdma1_main_Probe_Reserved_229 @0x3D8 {
                bytes 4;
                field ccf_Probe_T_cdma1_main_Probe_Reserved_229 {
                    bits 32;
                    access rw;
                    hard_reset 'h0;
                }
            }
            register ccf_Probe_T_cdma1_main_Probe_Reserved_230 @0x3DC {
                bytes 4;
                field ccf_Probe_T_cdma1_main_Probe_Reserved_230 {
                    bits 32;
                    access rw;
                    hard_reset 'h0;
                }
            }
            register ccf_Probe_T_cdma1_main_Probe_Reserved_231 @0x3E0 {
                bytes 4;
                field ccf_Probe_T_cdma1_main_Probe_Reserved_231 {
                    bits 32;
                    access rw;
                    hard_reset 'h0;
                }
            }
            register ccf_Probe_T_cdma1_main_Probe_Reserved_232 @0x3E4 {
                bytes 4;
                field ccf_Probe_T_cdma1_main_Probe_Reserved_232 {
                    bits 32;
                    access rw;
                    hard_reset 'h0;
                }
            }
            register ccf_Probe_T_cdma1_main_Probe_Reserved_233 @0x3E8 {
                bytes 4;
                field ccf_Probe_T_cdma1_main_Probe_Reserved_233 {
                    bits 32;
                    access rw;
                    hard_reset 'h0;
                }
            }
            register ccf_Probe_T_cdma1_main_Probe_Reserved_234 @0x3EC {
                bytes 4;
                field ccf_Probe_T_cdma1_main_Probe_Reserved_234 {
                    bits 32;
                    access rw;
                    hard_reset 'h0;
                }
            }
            register ccf_Probe_T_cdma1_main_Probe_Reserved_235 @0x3F0 {
                bytes 4;
                field ccf_Probe_T_cdma1_main_Probe_Reserved_235 {
                    bits 32;
                    access rw;
                    hard_reset 'h0;
                }
            }
            register ccf_Probe_T_cdma1_main_Probe_Reserved_236 @0x3F4 {
                bytes 4;
                field ccf_Probe_T_cdma1_main_Probe_Reserved_236 {
                    bits 32;
                    access rw;
                    hard_reset 'h0;
                }
            }
            register ccf_Probe_T_cdma1_main_Probe_Reserved_237 @0x3F8 {
                bytes 4;
                field ccf_Probe_T_cdma1_main_Probe_Reserved_237 {
                    bits 32;
                    access rw;
                    hard_reset 'h0;
                }
            }
            register ccf_Probe_T_cdma1_main_Probe_Reserved_238 @0x3FC {
                bytes 4;
                field ccf_Probe_T_cdma1_main_Probe_Reserved_238 {
                    bits 32;
                    access rw;
                    hard_reset 'h0;
                }
            }
        }
        block ecf_ccf_axi_ccf_Probe_T_ecf_main_Probe @0xD8800 {
            bytes 4;
            register ccf_Probe_T_ecf_main_Probe_Id_CoreId @0x0 {
                bytes 4;
                field CORETYPEID @'h0 {
                    bits 8;
                    access ro;
                    hard_reset 'h6;
                    doc {
                        Field identifying the type of IP.
                    }
                }
                field CORECHECKSUM @'h8 {
                    bits 24;
                    access ro;
                    hard_reset 'hd64ef4;
                    doc {
                        Field containing a checksum of the parameters of the IP.
                    }
                }
            }
            register ccf_Probe_T_ecf_main_Probe_Id_RevisionId @0x4 {
                bytes 4;
                field USERID @'h0 {
                    bits 8;
                    access ro;
                    hard_reset 'h0;
                    doc {
                        Field containing a user defined value, not used anywhere inside the IP itself.
                    }
                }
                field FLEXNOCID @'h8 {
                    bits 24;
                    access ro;
                    hard_reset 'h84f8c6;
                    doc {
                        Field containing the build revision of the software used to generate the IP HDL code.
                    }
                }
            }
            register ccf_Probe_T_ecf_main_Probe_MainCtl @0x8 {
                bytes 4;
                field ERREN @'h0 {
                    access rw;
                    hard_reset 'h0;
                    doc {
                        Register field ErrEn enables the probe to send on the ObsTx output any packet with Error status, independently of filtering mechanisms, thus constituting a simple supplementary global filter.
                    }
                }
                field TRACEEN @'h1 {
                    access ro;
                    hard_reset 'h0;
                    doc {
                        Register field TraceEn enables the probe to send filtered packets (Trace) on the ObsTx observation output.
                    }
                }
                field PAYLOADEN @'h2 {
                    access rw;
                    hard_reset 'h0;
                    doc {
                        Register field PayloadEn, when set to 1, enables traces to contain headers and payload. When set ot 0, only headers are reported.
                    }
                }
                field STATEN @'h3 {
                    access rw;
                    hard_reset 'h0;
                    doc {
                        When set to 1, register field StatEn enables statistics profiling. The probe sendS statistics results to the output for signal ObsTx. All statistics counters are cleared when the StatEn bit goes from 0 to 1. When set to 0, counters are disabled.
                    }
                }
                field ALARMEN @'h4 {
                    access rw;
                    hard_reset 'h0;
                    doc {
                        When set, register field AlarmEn enables the probe to collect alarm-related information. When the register field bit is null, both TraceAlarm and StatAlarm outputs are driven to 0.
                    }
                }
                field STATCONDDUMP @'h5 {
                    access rw;
                    hard_reset 'h0;
                    doc {
                        When set, register field StatCondDump enables the dump of a statistics frame to the range of counter values set for registers StatAlarmMin, StatAlarmMax, and AlarmMode. This field also renders register StatAlarmStatus inoperative. When parameter statisticsCounterAlarm is set to False, the StatCondDump register bit is reserved.
                    }
                }
                field INTRUSIVEMODE @'h6 {
                    access ro;
                    hard_reset 'h0;
                    doc {
                        When set to 1, register field IntrusiveMode enables trace operation in Intrusive flow-control mode. When set to 0, the register  enables trace operation in Overflow flow-control mode
                    }
                }
                field FILTBYTEALWAYSCHAINABLEEN @'h7 {
                    access rw;
                    hard_reset 'h0;
                    doc {
                        When set to 0, filters are mapped to all statistic counters when counting bytes or enabled bytes. Therefore, only filter events mapped to even counters can be counted using a pair of chained counters.When set to 1, filters are mapped only to even statistic counters when counting bytes or enabled bytes. Thus events from any filter can be counted using a pair of chained counters.
                    }
                }
                doc {
                    Register MainCtl contains probe global control bits. The register has seven bit fields:Register MainCtl contains probe global control bits. The register has seven bit fields:
                }
            }
            register ccf_Probe_T_ecf_main_Probe_CfgCtl @0xC {
                bytes 4;
                field GLOBALEN @'h0 {
                    access rw;
                    hard_reset 'h0;
                }
                field ACTIVE @'h1 {
                    access ro;
                    hard_reset 'h0;
                }
            }
            register ccf_Probe_T_ecf_main_Probe_Reserved_00 @0x10 {
                bytes 4;
                field ccf_Probe_T_ecf_main_Probe_Reserved_00 {
                    bits 32;
                    access rw;
                    hard_reset 'h0;
                }
            }
            register ccf_Probe_T_ecf_main_Probe_Reserved_01 @0x14 {
                bytes 4;
                field ccf_Probe_T_ecf_main_Probe_Reserved_01 {
                    bits 32;
                    access rw;
                    hard_reset 'h0;
                }
            }
            register ccf_Probe_T_ecf_main_Probe_Reserved_02 @0x18 {
                bytes 4;
                field ccf_Probe_T_ecf_main_Probe_Reserved_02 {
                    bits 32;
                    access rw;
                    hard_reset 'h0;
                }
            }
            register ccf_Probe_T_ecf_main_Probe_Reserved_03 @0x1C {
                bytes 4;
                field ccf_Probe_T_ecf_main_Probe_Reserved_03 {
                    bits 32;
                    access rw;
                    hard_reset 'h0;
                }
            }
            register ccf_Probe_T_ecf_main_Probe_Reserved_04 @0x20 {
                bytes 4;
                field ccf_Probe_T_ecf_main_Probe_Reserved_04 {
                    bits 32;
                    access rw;
                    hard_reset 'h0;
                }
            }
            register ccf_Probe_T_ecf_main_Probe_StatPeriod @0x24 {
                bytes 4;
                field STATPERIOD @'h0 {
                    bits 5;
                    access rw;
                    hard_reset 'h0;
                    doc {
                        Register StatPeriod is a 5-bit register that sets a period, within a range of 2 cycles to 2 gigacycles, during which statistics are collected before being dumped automatically. Setting the register implicitly enables automatic mode operation for statistics collection. The period is calculated with the formula: N_Cycle = 2**StatPeriodWhen register StatPeriod is set to its default value 0, automatic dump mode is disabled, and register StatGo is activated for manual mode operation. Note: When parameter statisticsCollection is set to False, StatPeriod is reserved.
                    }
                }
            }
            register ccf_Probe_T_ecf_main_Probe_StatGo @0x28 {
                bytes 4;
                field STATGO @'h0 {
                    access w1c;
                    hard_reset 'h0;
                    doc {
                        Writing a 1 to the 1-bit pulse register StatGo generates a statistics dump.The register is active when statistics collection operates in manual mode, that is, when register StatPeriod is set to 0.NOTE  The written value is not stored in StatGo. A read always returns 0.
                    }
                }
            }
            register ccf_Probe_T_ecf_main_Probe_StatAlarmMin @0x2C {
                bytes 4;
                field STATALARMMIN @'h0 {
                    bits 22;
                    access rw;
                    hard_reset 'h0;
                    doc {
                        Register StatAlarmMin contains the minimum count value used in statistics alarm comparisons. The number of bits is equal to twice the value set forparameter wStatisticsCounter. When parameter statisticsCounterAlarm is set to False, StatAlarmMin is reserved.
                    }
                }
            }
            register ccf_Probe_T_ecf_main_Probe_StatAlarmMax @0x30 {
                bytes 4;
                field STATALARMMAX @'h0 {
                    bits 22;
                    access rw;
                    hard_reset 'h0;
                    doc {
                        Register StatAlarmMax contains the maximum count value used in statistics alarm comparisons.The number of bits is equal to twice the value set for parameter wStatisticsCounter. When parameter statisticsCounterAlarm is set to False, StatAlarmMax is reserved.
                    }
                }
            }
            register ccf_Probe_T_ecf_main_Probe_StatAlarmStatus @0x34 {
                bytes 4;
                field STATALARMSTATUS @'h0 {
                    access ro;
                    hard_reset 'h0;
                    doc {
                        Register StatAlarmStatus is a read-only 1-bit register indicating that at least one statistics counter has exceeded the programmed values for registers StatAlarmMin or StatAlarmMax. Output signal StatAlarm is equal to the values stored in register MainCtl fields StatAlarmStatus and AlarmEn. When parameter statisticsCounterAlarm is set to False, StatAlarmStatus is reserved.
                    }
                }
            }
            register ccf_Probe_T_ecf_main_Probe_StatAlarmClr @0x38 {
                bytes 4;
                field STATALARMCLR @'h0 {
                    access w1c;
                    hard_reset 'h0;
                    doc {
                        Register StatAlarmClr is a 1-bit register. Writing a 1 to this register clears the StatAlarmStatus register bit.When parameter statisticsCounterAlarm is set to False, StatAlarmClr is reserved.NOTE  The written value is not stored in StatAlarmClr. A read always returns 0.
                    }
                }
            }
            register ccf_Probe_T_ecf_main_Probe_StatAlarmEn @0x3C {
                bytes 4;
                field STATALARMEN @'h0 {
                    access rw;
                    hard_reset 'h1;
                    doc {
                        Register StatAlarmEn is a 1-bit register. When set to 0 it masks StatAlarm and CtiTrigOut(1) signal interrupts.
                    }
                }
            }
            register ccf_Probe_T_ecf_main_Probe_Reserved_05 @0x40 {
                bytes 4;
                field ccf_Probe_T_ecf_main_Probe_Reserved_05 {
                    bits 32;
                    access rw;
                    hard_reset 'h0;
                }
            }
            register ccf_Probe_T_ecf_main_Probe_Reserved_06 @0x44 {
                bytes 4;
                field ccf_Probe_T_ecf_main_Probe_Reserved_06 {
                    bits 32;
                    access rw;
                    hard_reset 'h0;
                }
            }
            register ccf_Probe_T_ecf_main_Probe_Reserved_07 @0x48 {
                bytes 4;
                field ccf_Probe_T_ecf_main_Probe_Reserved_07 {
                    bits 32;
                    access rw;
                    hard_reset 'h0;
                }
            }
            register ccf_Probe_T_ecf_main_Probe_Reserved_08 @0x4C {
                bytes 4;
                field ccf_Probe_T_ecf_main_Probe_Reserved_08 {
                    bits 32;
                    access rw;
                    hard_reset 'h0;
                }
            }
            register ccf_Probe_T_ecf_main_Probe_Reserved_09 @0x50 {
                bytes 4;
                field ccf_Probe_T_ecf_main_Probe_Reserved_09 {
                    bits 32;
                    access rw;
                    hard_reset 'h0;
                }
            }
            register ccf_Probe_T_ecf_main_Probe_Reserved_10 @0x54 {
                bytes 4;
                field ccf_Probe_T_ecf_main_Probe_Reserved_10 {
                    bits 32;
                    access rw;
                    hard_reset 'h0;
                }
            }
            register ccf_Probe_T_ecf_main_Probe_Reserved_11 @0x58 {
                bytes 4;
                field ccf_Probe_T_ecf_main_Probe_Reserved_11 {
                    bits 32;
                    access rw;
                    hard_reset 'h0;
                }
            }
            register ccf_Probe_T_ecf_main_Probe_Reserved_12 @0x5C {
                bytes 4;
                field ccf_Probe_T_ecf_main_Probe_Reserved_12 {
                    bits 32;
                    access rw;
                    hard_reset 'h0;
                }
            }
            register ccf_Probe_T_ecf_main_Probe_Reserved_13 @0x60 {
                bytes 4;
                field ccf_Probe_T_ecf_main_Probe_Reserved_13 {
                    bits 32;
                    access rw;
                    hard_reset 'h0;
                }
            }
            register ccf_Probe_T_ecf_main_Probe_Reserved_14 @0x64 {
                bytes 4;
                field ccf_Probe_T_ecf_main_Probe_Reserved_14 {
                    bits 32;
                    access rw;
                    hard_reset 'h0;
                }
            }
            register ccf_Probe_T_ecf_main_Probe_Reserved_15 @0x68 {
                bytes 4;
                field ccf_Probe_T_ecf_main_Probe_Reserved_15 {
                    bits 32;
                    access rw;
                    hard_reset 'h0;
                }
            }
            register ccf_Probe_T_ecf_main_Probe_Reserved_16 @0x6C {
                bytes 4;
                field ccf_Probe_T_ecf_main_Probe_Reserved_16 {
                    bits 32;
                    access rw;
                    hard_reset 'h0;
                }
            }
            register ccf_Probe_T_ecf_main_Probe_Reserved_17 @0x70 {
                bytes 4;
                field ccf_Probe_T_ecf_main_Probe_Reserved_17 {
                    bits 32;
                    access rw;
                    hard_reset 'h0;
                }
            }
            register ccf_Probe_T_ecf_main_Probe_Reserved_18 @0x74 {
                bytes 4;
                field ccf_Probe_T_ecf_main_Probe_Reserved_18 {
                    bits 32;
                    access rw;
                    hard_reset 'h0;
                }
            }
            register ccf_Probe_T_ecf_main_Probe_Reserved_19 @0x78 {
                bytes 4;
                field ccf_Probe_T_ecf_main_Probe_Reserved_19 {
                    bits 32;
                    access rw;
                    hard_reset 'h0;
                }
            }
            register ccf_Probe_T_ecf_main_Probe_Reserved_20 @0x7C {
                bytes 4;
                field ccf_Probe_T_ecf_main_Probe_Reserved_20 {
                    bits 32;
                    access rw;
                    hard_reset 'h0;
                }
            }
            register ccf_Probe_T_ecf_main_Probe_Reserved_21 @0x80 {
                bytes 4;
                field ccf_Probe_T_ecf_main_Probe_Reserved_21 {
                    bits 32;
                    access rw;
                    hard_reset 'h0;
                }
            }
            register ccf_Probe_T_ecf_main_Probe_Reserved_22 @0x84 {
                bytes 4;
                field ccf_Probe_T_ecf_main_Probe_Reserved_22 {
                    bits 32;
                    access rw;
                    hard_reset 'h0;
                }
            }
            register ccf_Probe_T_ecf_main_Probe_Reserved_23 @0x88 {
                bytes 4;
                field ccf_Probe_T_ecf_main_Probe_Reserved_23 {
                    bits 32;
                    access rw;
                    hard_reset 'h0;
                }
            }
            register ccf_Probe_T_ecf_main_Probe_Reserved_24 @0x8C {
                bytes 4;
                field ccf_Probe_T_ecf_main_Probe_Reserved_24 {
                    bits 32;
                    access rw;
                    hard_reset 'h0;
                }
            }
            register ccf_Probe_T_ecf_main_Probe_Reserved_25 @0x90 {
                bytes 4;
                field ccf_Probe_T_ecf_main_Probe_Reserved_25 {
                    bits 32;
                    access rw;
                    hard_reset 'h0;
                }
            }
            register ccf_Probe_T_ecf_main_Probe_Reserved_26 @0x94 {
                bytes 4;
                field ccf_Probe_T_ecf_main_Probe_Reserved_26 {
                    bits 32;
                    access rw;
                    hard_reset 'h0;
                }
            }
            register ccf_Probe_T_ecf_main_Probe_Reserved_27 @0x98 {
                bytes 4;
                field ccf_Probe_T_ecf_main_Probe_Reserved_27 {
                    bits 32;
                    access rw;
                    hard_reset 'h0;
                }
            }
            register ccf_Probe_T_ecf_main_Probe_Reserved_28 @0x9C {
                bytes 4;
                field ccf_Probe_T_ecf_main_Probe_Reserved_28 {
                    bits 32;
                    access rw;
                    hard_reset 'h0;
                }
            }
            register ccf_Probe_T_ecf_main_Probe_Reserved_29 @0xA0 {
                bytes 4;
                field ccf_Probe_T_ecf_main_Probe_Reserved_29 {
                    bits 32;
                    access rw;
                    hard_reset 'h0;
                }
            }
            register ccf_Probe_T_ecf_main_Probe_Reserved_30 @0xA4 {
                bytes 4;
                field ccf_Probe_T_ecf_main_Probe_Reserved_30 {
                    bits 32;
                    access rw;
                    hard_reset 'h0;
                }
            }
            register ccf_Probe_T_ecf_main_Probe_Reserved_31 @0xA8 {
                bytes 4;
                field ccf_Probe_T_ecf_main_Probe_Reserved_31 {
                    bits 32;
                    access rw;
                    hard_reset 'h0;
                }
            }
            register ccf_Probe_T_ecf_main_Probe_Reserved_32 @0xAC {
                bytes 4;
                field ccf_Probe_T_ecf_main_Probe_Reserved_32 {
                    bits 32;
                    access rw;
                    hard_reset 'h0;
                }
            }
            register ccf_Probe_T_ecf_main_Probe_Reserved_33 @0xB0 {
                bytes 4;
                field ccf_Probe_T_ecf_main_Probe_Reserved_33 {
                    bits 32;
                    access rw;
                    hard_reset 'h0;
                }
            }
            register ccf_Probe_T_ecf_main_Probe_Reserved_34 @0xB4 {
                bytes 4;
                field ccf_Probe_T_ecf_main_Probe_Reserved_34 {
                    bits 32;
                    access rw;
                    hard_reset 'h0;
                }
            }
            register ccf_Probe_T_ecf_main_Probe_Reserved_35 @0xB8 {
                bytes 4;
                field ccf_Probe_T_ecf_main_Probe_Reserved_35 {
                    bits 32;
                    access rw;
                    hard_reset 'h0;
                }
            }
            register ccf_Probe_T_ecf_main_Probe_Reserved_36 @0xBC {
                bytes 4;
                field ccf_Probe_T_ecf_main_Probe_Reserved_36 {
                    bits 32;
                    access rw;
                    hard_reset 'h0;
                }
            }
            register ccf_Probe_T_ecf_main_Probe_Reserved_37 @0xC0 {
                bytes 4;
                field ccf_Probe_T_ecf_main_Probe_Reserved_37 {
                    bits 32;
                    access rw;
                    hard_reset 'h0;
                }
            }
            register ccf_Probe_T_ecf_main_Probe_Reserved_38 @0xC4 {
                bytes 4;
                field ccf_Probe_T_ecf_main_Probe_Reserved_38 {
                    bits 32;
                    access rw;
                    hard_reset 'h0;
                }
            }
            register ccf_Probe_T_ecf_main_Probe_Reserved_39 @0xC8 {
                bytes 4;
                field ccf_Probe_T_ecf_main_Probe_Reserved_39 {
                    bits 32;
                    access rw;
                    hard_reset 'h0;
                }
            }
            register ccf_Probe_T_ecf_main_Probe_Reserved_40 @0xCC {
                bytes 4;
                field ccf_Probe_T_ecf_main_Probe_Reserved_40 {
                    bits 32;
                    access rw;
                    hard_reset 'h0;
                }
            }
            register ccf_Probe_T_ecf_main_Probe_Reserved_41 @0xD0 {
                bytes 4;
                field ccf_Probe_T_ecf_main_Probe_Reserved_41 {
                    bits 32;
                    access rw;
                    hard_reset 'h0;
                }
            }
            register ccf_Probe_T_ecf_main_Probe_Reserved_42 @0xD4 {
                bytes 4;
                field ccf_Probe_T_ecf_main_Probe_Reserved_42 {
                    bits 32;
                    access rw;
                    hard_reset 'h0;
                }
            }
            register ccf_Probe_T_ecf_main_Probe_Reserved_43 @0xD8 {
                bytes 4;
                field ccf_Probe_T_ecf_main_Probe_Reserved_43 {
                    bits 32;
                    access rw;
                    hard_reset 'h0;
                }
            }
            register ccf_Probe_T_ecf_main_Probe_Reserved_44 @0xDC {
                bytes 4;
                field ccf_Probe_T_ecf_main_Probe_Reserved_44 {
                    bits 32;
                    access rw;
                    hard_reset 'h0;
                }
            }
            register ccf_Probe_T_ecf_main_Probe_Reserved_45 @0xE0 {
                bytes 4;
                field ccf_Probe_T_ecf_main_Probe_Reserved_45 {
                    bits 32;
                    access rw;
                    hard_reset 'h0;
                }
            }
            register ccf_Probe_T_ecf_main_Probe_Reserved_46 @0xE4 {
                bytes 4;
                field ccf_Probe_T_ecf_main_Probe_Reserved_46 {
                    bits 32;
                    access rw;
                    hard_reset 'h0;
                }
            }
            register ccf_Probe_T_ecf_main_Probe_Reserved_47 @0xE8 {
                bytes 4;
                field ccf_Probe_T_ecf_main_Probe_Reserved_47 {
                    bits 32;
                    access rw;
                    hard_reset 'h0;
                }
            }
            register ccf_Probe_T_ecf_main_Probe_Reserved_48 @0xEC {
                bytes 4;
                field ccf_Probe_T_ecf_main_Probe_Reserved_48 {
                    bits 32;
                    access rw;
                    hard_reset 'h0;
                }
            }
            register ccf_Probe_T_ecf_main_Probe_Reserved_49 @0xF0 {
                bytes 4;
                field ccf_Probe_T_ecf_main_Probe_Reserved_49 {
                    bits 32;
                    access rw;
                    hard_reset 'h0;
                }
            }
            register ccf_Probe_T_ecf_main_Probe_Reserved_50 @0xF4 {
                bytes 4;
                field ccf_Probe_T_ecf_main_Probe_Reserved_50 {
                    bits 32;
                    access rw;
                    hard_reset 'h0;
                }
            }
            register ccf_Probe_T_ecf_main_Probe_Reserved_51 @0xF8 {
                bytes 4;
                field ccf_Probe_T_ecf_main_Probe_Reserved_51 {
                    bits 32;
                    access rw;
                    hard_reset 'h0;
                }
            }
            register ccf_Probe_T_ecf_main_Probe_Reserved_52 @0xFC {
                bytes 4;
                field ccf_Probe_T_ecf_main_Probe_Reserved_52 {
                    bits 32;
                    access rw;
                    hard_reset 'h0;
                }
            }
            register ccf_Probe_T_ecf_main_Probe_Reserved_53 @0x100 {
                bytes 4;
                field ccf_Probe_T_ecf_main_Probe_Reserved_53 {
                    bits 32;
                    access rw;
                    hard_reset 'h0;
                }
            }
            register ccf_Probe_T_ecf_main_Probe_Reserved_54 @0x104 {
                bytes 4;
                field ccf_Probe_T_ecf_main_Probe_Reserved_54 {
                    bits 32;
                    access rw;
                    hard_reset 'h0;
                }
            }
            register ccf_Probe_T_ecf_main_Probe_Reserved_55 @0x108 {
                bytes 4;
                field ccf_Probe_T_ecf_main_Probe_Reserved_55 {
                    bits 32;
                    access rw;
                    hard_reset 'h0;
                }
            }
            register ccf_Probe_T_ecf_main_Probe_Reserved_56 @0x10C {
                bytes 4;
                field ccf_Probe_T_ecf_main_Probe_Reserved_56 {
                    bits 32;
                    access rw;
                    hard_reset 'h0;
                }
            }
            register ccf_Probe_T_ecf_main_Probe_Reserved_57 @0x110 {
                bytes 4;
                field ccf_Probe_T_ecf_main_Probe_Reserved_57 {
                    bits 32;
                    access rw;
                    hard_reset 'h0;
                }
            }
            register ccf_Probe_T_ecf_main_Probe_Reserved_58 @0x114 {
                bytes 4;
                field ccf_Probe_T_ecf_main_Probe_Reserved_58 {
                    bits 32;
                    access rw;
                    hard_reset 'h0;
                }
            }
            register ccf_Probe_T_ecf_main_Probe_Reserved_59 @0x118 {
                bytes 4;
                field ccf_Probe_T_ecf_main_Probe_Reserved_59 {
                    bits 32;
                    access rw;
                    hard_reset 'h0;
                }
            }
            register ccf_Probe_T_ecf_main_Probe_Reserved_60 @0x11C {
                bytes 4;
                field ccf_Probe_T_ecf_main_Probe_Reserved_60 {
                    bits 32;
                    access rw;
                    hard_reset 'h0;
                }
            }
            register ccf_Probe_T_ecf_main_Probe_Reserved_61 @0x120 {
                bytes 4;
                field ccf_Probe_T_ecf_main_Probe_Reserved_61 {
                    bits 32;
                    access rw;
                    hard_reset 'h0;
                }
            }
            register ccf_Probe_T_ecf_main_Probe_Reserved_62 @0x124 {
                bytes 4;
                field ccf_Probe_T_ecf_main_Probe_Reserved_62 {
                    bits 32;
                    access rw;
                    hard_reset 'h0;
                }
            }
            register ccf_Probe_T_ecf_main_Probe_Reserved_63 @0x128 {
                bytes 4;
                field ccf_Probe_T_ecf_main_Probe_Reserved_63 {
                    bits 32;
                    access rw;
                    hard_reset 'h0;
                }
            }
            register ccf_Probe_T_ecf_main_Probe_Reserved_64 @0x12C {
                bytes 4;
                field ccf_Probe_T_ecf_main_Probe_Reserved_64 {
                    bits 32;
                    access rw;
                    hard_reset 'h0;
                }
            }
            register ccf_Probe_T_ecf_main_Probe_Reserved_65 @0x130 {
                bytes 4;
                field ccf_Probe_T_ecf_main_Probe_Reserved_65 {
                    bits 32;
                    access rw;
                    hard_reset 'h0;
                }
            }
            register ccf_Probe_T_ecf_main_Probe_Reserved_66 @0x134 {
                bytes 4;
                field ccf_Probe_T_ecf_main_Probe_Reserved_66 {
                    bits 32;
                    access rw;
                    hard_reset 'h0;
                }
            }
            register ccf_Probe_T_ecf_main_Probe_Counters_0_Src @0x138 {
                bytes 4;
                field INTEVENT @'h0 {
                    bits 5;
                    access rw;
                    hard_reset 'h0;
                    enum { OFF = 0, CYCLE = 1, IDLE = 2, XFER = 3, BUSY = 4, WAIT = 5, PKT = 6, LUT = 7, BYTE = 8, PRESS0 = 9, PRESS1 = 10, PRESS2 = 11, FILT0 = 12, FILT1 = 13, FILT2 = 14, FILT3 = 15, CHAIN = 16, LUT_BYTE_EN = 17, LUT_BYTE = 18, FILT_BYTE_EN = 19, FILT_BYTE = 20, PRESS3 = 21, PRESS4 = 22, PRESS5 = 23, PRESS6 = 24, RSV_0 = 25, RSV_1 = 26, RSV_2 = 27, RSV_3 = 28, RSV_4 = 29, RSV_5 = 30, RSV_6 = 31 };
                    doc {
                        Internal packet event
                    }
                }
                field EXTEVENT @'h5 {
                    access rw;
                    hard_reset 'h0;
                    doc {
                        When greater than 0, the entire register value is used to select an external hardware event source. The index of the external event is equal to {ExtEvent,IntEvent}.
                    }
                }
                doc {
                    Register CntSrc indicates the event source used to increment the counter. Unassigned values (non-existing Press level or ExtEvent index, or unimplemented Filter) are equivalent to OFF.
	Register CntSrc indicates the event source used to increment the counter. Unassigned values (non-existing Press level or ExtEvent index, or unimplemented Filter) are equivalent to OFF.
	
                }
            }
            register ccf_Probe_T_ecf_main_Probe_Counters_0_AlarmMode @0x13C {
                bytes 4;
                field COUNTERS_0_ALARMMODE @'h0 {
                    bits 2;
                    access rw;
                    hard_reset 'h0;
                    enum { OFF = 0, MIN = 1, MAX = 2, MIN_MAX = 3 };
                    doc {
                        Register AlarmMode is a 2-bit register that is present when parameter statisticsCounterAlarm is set to True. The register defines the statistics-alarm behavior of the counter.
                    }
                }
            }
            register ccf_Probe_T_ecf_main_Probe_Counters_0_Val @0x140 {
                bytes 4;
                field COUNTERS_0_VAL @'h0 {
                    bits 11;
                    access ro;
                    hard_reset 'h0;
                    doc {
                        Register Val is a read-only register that is always present. The register containsthe statistics counter value either pending StatAlarm output, or when statisticscollection is suspended subsequent to triggers or signal statSuspend.
                    }
                }
            }
            register ccf_Probe_T_ecf_main_Probe_Reserved_67 @0x144 {
                bytes 4;
                field ccf_Probe_T_ecf_main_Probe_Reserved_67 {
                    bits 32;
                    access rw;
                    hard_reset 'h0;
                }
            }
            register ccf_Probe_T_ecf_main_Probe_Reserved_68 @0x148 {
                bytes 4;
                field ccf_Probe_T_ecf_main_Probe_Reserved_68 {
                    bits 32;
                    access rw;
                    hard_reset 'h0;
                }
            }
            register ccf_Probe_T_ecf_main_Probe_Counters_1_Src @0x14C {
                bytes 4;
                field INTEVENT @'h0 {
                    bits 5;
                    access rw;
                    hard_reset 'h0;
                    enum { OFF = 0, CYCLE = 1, IDLE = 2, XFER = 3, BUSY = 4, WAIT = 5, PKT = 6, LUT = 7, BYTE = 8, PRESS0 = 9, PRESS1 = 10, PRESS2 = 11, FILT0 = 12, FILT1 = 13, FILT2 = 14, FILT3 = 15, CHAIN = 16, LUT_BYTE_EN = 17, LUT_BYTE = 18, FILT_BYTE_EN = 19, FILT_BYTE = 20, PRESS3 = 21, PRESS4 = 22, PRESS5 = 23, PRESS6 = 24, RSV_0 = 25, RSV_1 = 26, RSV_2 = 27, RSV_3 = 28, RSV_4 = 29, RSV_5 = 30, RSV_6 = 31 };
                    doc {
                        Internal packet event
                    }
                }
                field EXTEVENT @'h5 {
                    access rw;
                    hard_reset 'h0;
                    doc {
                        When greater than 0, the entire register value is used to select an external hardware event source. The index of the external event is equal to {ExtEvent,IntEvent}.
                    }
                }
                doc {
                    Register CntSrc indicates the event source used to increment the counter. Unassigned values (non-existing Press level or ExtEvent index, or unimplemented Filter) are equivalent to OFF.
	Register CntSrc indicates the event source used to increment the counter. Unassigned values (non-existing Press level or ExtEvent index, or unimplemented Filter) are equivalent to OFF.
	
                }
            }
            register ccf_Probe_T_ecf_main_Probe_Counters_1_AlarmMode @0x150 {
                bytes 4;
                field COUNTERS_1_ALARMMODE @'h0 {
                    bits 2;
                    access rw;
                    hard_reset 'h0;
                    enum { OFF = 0, MIN = 1, MAX = 2, MIN_MAX = 3 };
                    doc {
                        Register AlarmMode is a 2-bit register that is present when parameter statisticsCounterAlarm is set to True. The register defines the statistics-alarm behavior of the counter.
                    }
                }
            }
            register ccf_Probe_T_ecf_main_Probe_Counters_1_Val @0x154 {
                bytes 4;
                field COUNTERS_1_VAL @'h0 {
                    bits 11;
                    access ro;
                    hard_reset 'h0;
                    doc {
                        Register Val is a read-only register that is always present. The register containsthe statistics counter value either pending StatAlarm output, or when statisticscollection is suspended subsequent to triggers or signal statSuspend.
                    }
                }
            }
            register ccf_Probe_T_ecf_main_Probe_Reserved_69 @0x158 {
                bytes 4;
                field ccf_Probe_T_ecf_main_Probe_Reserved_69 {
                    bits 32;
                    access rw;
                    hard_reset 'h0;
                }
            }
            register ccf_Probe_T_ecf_main_Probe_Reserved_70 @0x15C {
                bytes 4;
                field ccf_Probe_T_ecf_main_Probe_Reserved_70 {
                    bits 32;
                    access rw;
                    hard_reset 'h0;
                }
            }
            register ccf_Probe_T_ecf_main_Probe_Reserved_71 @0x160 {
                bytes 4;
                field ccf_Probe_T_ecf_main_Probe_Reserved_71 {
                    bits 32;
                    access rw;
                    hard_reset 'h0;
                }
            }
            register ccf_Probe_T_ecf_main_Probe_Reserved_72 @0x164 {
                bytes 4;
                field ccf_Probe_T_ecf_main_Probe_Reserved_72 {
                    bits 32;
                    access rw;
                    hard_reset 'h0;
                }
            }
            register ccf_Probe_T_ecf_main_Probe_Reserved_73 @0x168 {
                bytes 4;
                field ccf_Probe_T_ecf_main_Probe_Reserved_73 {
                    bits 32;
                    access rw;
                    hard_reset 'h0;
                }
            }
            register ccf_Probe_T_ecf_main_Probe_Reserved_74 @0x16C {
                bytes 4;
                field ccf_Probe_T_ecf_main_Probe_Reserved_74 {
                    bits 32;
                    access rw;
                    hard_reset 'h0;
                }
            }
            register ccf_Probe_T_ecf_main_Probe_Reserved_75 @0x170 {
                bytes 4;
                field ccf_Probe_T_ecf_main_Probe_Reserved_75 {
                    bits 32;
                    access rw;
                    hard_reset 'h0;
                }
            }
            register ccf_Probe_T_ecf_main_Probe_Reserved_76 @0x174 {
                bytes 4;
                field ccf_Probe_T_ecf_main_Probe_Reserved_76 {
                    bits 32;
                    access rw;
                    hard_reset 'h0;
                }
            }
            register ccf_Probe_T_ecf_main_Probe_Reserved_77 @0x178 {
                bytes 4;
                field ccf_Probe_T_ecf_main_Probe_Reserved_77 {
                    bits 32;
                    access rw;
                    hard_reset 'h0;
                }
            }
            register ccf_Probe_T_ecf_main_Probe_Reserved_78 @0x17C {
                bytes 4;
                field ccf_Probe_T_ecf_main_Probe_Reserved_78 {
                    bits 32;
                    access rw;
                    hard_reset 'h0;
                }
            }
            register ccf_Probe_T_ecf_main_Probe_Reserved_79 @0x180 {
                bytes 4;
                field ccf_Probe_T_ecf_main_Probe_Reserved_79 {
                    bits 32;
                    access rw;
                    hard_reset 'h0;
                }
            }
            register ccf_Probe_T_ecf_main_Probe_Reserved_80 @0x184 {
                bytes 4;
                field ccf_Probe_T_ecf_main_Probe_Reserved_80 {
                    bits 32;
                    access rw;
                    hard_reset 'h0;
                }
            }
            register ccf_Probe_T_ecf_main_Probe_Reserved_81 @0x188 {
                bytes 4;
                field ccf_Probe_T_ecf_main_Probe_Reserved_81 {
                    bits 32;
                    access rw;
                    hard_reset 'h0;
                }
            }
            register ccf_Probe_T_ecf_main_Probe_Reserved_82 @0x18C {
                bytes 4;
                field ccf_Probe_T_ecf_main_Probe_Reserved_82 {
                    bits 32;
                    access rw;
                    hard_reset 'h0;
                }
            }
            register ccf_Probe_T_ecf_main_Probe_Reserved_83 @0x190 {
                bytes 4;
                field ccf_Probe_T_ecf_main_Probe_Reserved_83 {
                    bits 32;
                    access rw;
                    hard_reset 'h0;
                }
            }
            register ccf_Probe_T_ecf_main_Probe_Reserved_84 @0x194 {
                bytes 4;
                field ccf_Probe_T_ecf_main_Probe_Reserved_84 {
                    bits 32;
                    access rw;
                    hard_reset 'h0;
                }
            }
            register ccf_Probe_T_ecf_main_Probe_Reserved_85 @0x198 {
                bytes 4;
                field ccf_Probe_T_ecf_main_Probe_Reserved_85 {
                    bits 32;
                    access rw;
                    hard_reset 'h0;
                }
            }
            register ccf_Probe_T_ecf_main_Probe_Reserved_86 @0x19C {
                bytes 4;
                field ccf_Probe_T_ecf_main_Probe_Reserved_86 {
                    bits 32;
                    access rw;
                    hard_reset 'h0;
                }
            }
            register ccf_Probe_T_ecf_main_Probe_Reserved_87 @0x1A0 {
                bytes 4;
                field ccf_Probe_T_ecf_main_Probe_Reserved_87 {
                    bits 32;
                    access rw;
                    hard_reset 'h0;
                }
            }
            register ccf_Probe_T_ecf_main_Probe_Reserved_88 @0x1A4 {
                bytes 4;
                field ccf_Probe_T_ecf_main_Probe_Reserved_88 {
                    bits 32;
                    access rw;
                    hard_reset 'h0;
                }
            }
            register ccf_Probe_T_ecf_main_Probe_Reserved_89 @0x1A8 {
                bytes 4;
                field ccf_Probe_T_ecf_main_Probe_Reserved_89 {
                    bits 32;
                    access rw;
                    hard_reset 'h0;
                }
            }
            register ccf_Probe_T_ecf_main_Probe_Reserved_90 @0x1AC {
                bytes 4;
                field ccf_Probe_T_ecf_main_Probe_Reserved_90 {
                    bits 32;
                    access rw;
                    hard_reset 'h0;
                }
            }
            register ccf_Probe_T_ecf_main_Probe_Reserved_91 @0x1B0 {
                bytes 4;
                field ccf_Probe_T_ecf_main_Probe_Reserved_91 {
                    bits 32;
                    access rw;
                    hard_reset 'h0;
                }
            }
            register ccf_Probe_T_ecf_main_Probe_Reserved_92 @0x1B4 {
                bytes 4;
                field ccf_Probe_T_ecf_main_Probe_Reserved_92 {
                    bits 32;
                    access rw;
                    hard_reset 'h0;
                }
            }
            register ccf_Probe_T_ecf_main_Probe_Reserved_93 @0x1B8 {
                bytes 4;
                field ccf_Probe_T_ecf_main_Probe_Reserved_93 {
                    bits 32;
                    access rw;
                    hard_reset 'h0;
                }
            }
            register ccf_Probe_T_ecf_main_Probe_Reserved_94 @0x1BC {
                bytes 4;
                field ccf_Probe_T_ecf_main_Probe_Reserved_94 {
                    bits 32;
                    access rw;
                    hard_reset 'h0;
                }
            }
            register ccf_Probe_T_ecf_main_Probe_Reserved_95 @0x1C0 {
                bytes 4;
                field ccf_Probe_T_ecf_main_Probe_Reserved_95 {
                    bits 32;
                    access rw;
                    hard_reset 'h0;
                }
            }
            register ccf_Probe_T_ecf_main_Probe_Reserved_96 @0x1C4 {
                bytes 4;
                field ccf_Probe_T_ecf_main_Probe_Reserved_96 {
                    bits 32;
                    access rw;
                    hard_reset 'h0;
                }
            }
            register ccf_Probe_T_ecf_main_Probe_Reserved_97 @0x1C8 {
                bytes 4;
                field ccf_Probe_T_ecf_main_Probe_Reserved_97 {
                    bits 32;
                    access rw;
                    hard_reset 'h0;
                }
            }
            register ccf_Probe_T_ecf_main_Probe_Reserved_98 @0x1CC {
                bytes 4;
                field ccf_Probe_T_ecf_main_Probe_Reserved_98 {
                    bits 32;
                    access rw;
                    hard_reset 'h0;
                }
            }
            register ccf_Probe_T_ecf_main_Probe_Reserved_99 @0x1D0 {
                bytes 4;
                field ccf_Probe_T_ecf_main_Probe_Reserved_99 {
                    bits 32;
                    access rw;
                    hard_reset 'h0;
                }
            }
            register ccf_Probe_T_ecf_main_Probe_Reserved_100 @0x1D4 {
                bytes 4;
                field ccf_Probe_T_ecf_main_Probe_Reserved_100 {
                    bits 32;
                    access rw;
                    hard_reset 'h0;
                }
            }
            register ccf_Probe_T_ecf_main_Probe_Reserved_101 @0x1D8 {
                bytes 4;
                field ccf_Probe_T_ecf_main_Probe_Reserved_101 {
                    bits 32;
                    access rw;
                    hard_reset 'h0;
                }
            }
            register ccf_Probe_T_ecf_main_Probe_Reserved_102 @0x1DC {
                bytes 4;
                field ccf_Probe_T_ecf_main_Probe_Reserved_102 {
                    bits 32;
                    access rw;
                    hard_reset 'h0;
                }
            }
            register ccf_Probe_T_ecf_main_Probe_Reserved_103 @0x1E0 {
                bytes 4;
                field ccf_Probe_T_ecf_main_Probe_Reserved_103 {
                    bits 32;
                    access rw;
                    hard_reset 'h0;
                }
            }
            register ccf_Probe_T_ecf_main_Probe_Reserved_104 @0x1E4 {
                bytes 4;
                field ccf_Probe_T_ecf_main_Probe_Reserved_104 {
                    bits 32;
                    access rw;
                    hard_reset 'h0;
                }
            }
            register ccf_Probe_T_ecf_main_Probe_Reserved_105 @0x1E8 {
                bytes 4;
                field ccf_Probe_T_ecf_main_Probe_Reserved_105 {
                    bits 32;
                    access rw;
                    hard_reset 'h0;
                }
            }
            register ccf_Probe_T_ecf_main_Probe_Reserved_106 @0x1EC {
                bytes 4;
                field ccf_Probe_T_ecf_main_Probe_Reserved_106 {
                    bits 32;
                    access rw;
                    hard_reset 'h0;
                }
            }
            register ccf_Probe_T_ecf_main_Probe_Reserved_107 @0x1F0 {
                bytes 4;
                field ccf_Probe_T_ecf_main_Probe_Reserved_107 {
                    bits 32;
                    access rw;
                    hard_reset 'h0;
                }
            }
            register ccf_Probe_T_ecf_main_Probe_Reserved_108 @0x1F4 {
                bytes 4;
                field ccf_Probe_T_ecf_main_Probe_Reserved_108 {
                    bits 32;
                    access rw;
                    hard_reset 'h0;
                }
            }
            register ccf_Probe_T_ecf_main_Probe_Reserved_109 @0x1F8 {
                bytes 4;
                field ccf_Probe_T_ecf_main_Probe_Reserved_109 {
                    bits 32;
                    access rw;
                    hard_reset 'h0;
                }
            }
            register ccf_Probe_T_ecf_main_Probe_Reserved_110 @0x1FC {
                bytes 4;
                field ccf_Probe_T_ecf_main_Probe_Reserved_110 {
                    bits 32;
                    access rw;
                    hard_reset 'h0;
                }
            }
            register ccf_Probe_T_ecf_main_Probe_Reserved_111 @0x200 {
                bytes 4;
                field ccf_Probe_T_ecf_main_Probe_Reserved_111 {
                    bits 32;
                    access rw;
                    hard_reset 'h0;
                }
            }
            register ccf_Probe_T_ecf_main_Probe_Reserved_112 @0x204 {
                bytes 4;
                field ccf_Probe_T_ecf_main_Probe_Reserved_112 {
                    bits 32;
                    access rw;
                    hard_reset 'h0;
                }
            }
            register ccf_Probe_T_ecf_main_Probe_Reserved_113 @0x208 {
                bytes 4;
                field ccf_Probe_T_ecf_main_Probe_Reserved_113 {
                    bits 32;
                    access rw;
                    hard_reset 'h0;
                }
            }
            register ccf_Probe_T_ecf_main_Probe_Reserved_114 @0x20C {
                bytes 4;
                field ccf_Probe_T_ecf_main_Probe_Reserved_114 {
                    bits 32;
                    access rw;
                    hard_reset 'h0;
                }
            }
            register ccf_Probe_T_ecf_main_Probe_Reserved_115 @0x210 {
                bytes 4;
                field ccf_Probe_T_ecf_main_Probe_Reserved_115 {
                    bits 32;
                    access rw;
                    hard_reset 'h0;
                }
            }
            register ccf_Probe_T_ecf_main_Probe_Reserved_116 @0x214 {
                bytes 4;
                field ccf_Probe_T_ecf_main_Probe_Reserved_116 {
                    bits 32;
                    access rw;
                    hard_reset 'h0;
                }
            }
            register ccf_Probe_T_ecf_main_Probe_Reserved_117 @0x218 {
                bytes 4;
                field ccf_Probe_T_ecf_main_Probe_Reserved_117 {
                    bits 32;
                    access rw;
                    hard_reset 'h0;
                }
            }
            register ccf_Probe_T_ecf_main_Probe_Reserved_118 @0x21C {
                bytes 4;
                field ccf_Probe_T_ecf_main_Probe_Reserved_118 {
                    bits 32;
                    access rw;
                    hard_reset 'h0;
                }
            }
            register ccf_Probe_T_ecf_main_Probe_Reserved_119 @0x220 {
                bytes 4;
                field ccf_Probe_T_ecf_main_Probe_Reserved_119 {
                    bits 32;
                    access rw;
                    hard_reset 'h0;
                }
            }
            register ccf_Probe_T_ecf_main_Probe_Reserved_120 @0x224 {
                bytes 4;
                field ccf_Probe_T_ecf_main_Probe_Reserved_120 {
                    bits 32;
                    access rw;
                    hard_reset 'h0;
                }
            }
            register ccf_Probe_T_ecf_main_Probe_Reserved_121 @0x228 {
                bytes 4;
                field ccf_Probe_T_ecf_main_Probe_Reserved_121 {
                    bits 32;
                    access rw;
                    hard_reset 'h0;
                }
            }
            register ccf_Probe_T_ecf_main_Probe_Reserved_122 @0x22C {
                bytes 4;
                field ccf_Probe_T_ecf_main_Probe_Reserved_122 {
                    bits 32;
                    access rw;
                    hard_reset 'h0;
                }
            }
            register ccf_Probe_T_ecf_main_Probe_Reserved_123 @0x230 {
                bytes 4;
                field ccf_Probe_T_ecf_main_Probe_Reserved_123 {
                    bits 32;
                    access rw;
                    hard_reset 'h0;
                }
            }
            register ccf_Probe_T_ecf_main_Probe_Reserved_124 @0x234 {
                bytes 4;
                field ccf_Probe_T_ecf_main_Probe_Reserved_124 {
                    bits 32;
                    access rw;
                    hard_reset 'h0;
                }
            }
            register ccf_Probe_T_ecf_main_Probe_Reserved_125 @0x238 {
                bytes 4;
                field ccf_Probe_T_ecf_main_Probe_Reserved_125 {
                    bits 32;
                    access rw;
                    hard_reset 'h0;
                }
            }
            register ccf_Probe_T_ecf_main_Probe_Reserved_126 @0x23C {
                bytes 4;
                field ccf_Probe_T_ecf_main_Probe_Reserved_126 {
                    bits 32;
                    access rw;
                    hard_reset 'h0;
                }
            }
            register ccf_Probe_T_ecf_main_Probe_Reserved_127 @0x240 {
                bytes 4;
                field ccf_Probe_T_ecf_main_Probe_Reserved_127 {
                    bits 32;
                    access rw;
                    hard_reset 'h0;
                }
            }
            register ccf_Probe_T_ecf_main_Probe_Reserved_128 @0x244 {
                bytes 4;
                field ccf_Probe_T_ecf_main_Probe_Reserved_128 {
                    bits 32;
                    access rw;
                    hard_reset 'h0;
                }
            }
            register ccf_Probe_T_ecf_main_Probe_Reserved_129 @0x248 {
                bytes 4;
                field ccf_Probe_T_ecf_main_Probe_Reserved_129 {
                    bits 32;
                    access rw;
                    hard_reset 'h0;
                }
            }
            register ccf_Probe_T_ecf_main_Probe_Reserved_130 @0x24C {
                bytes 4;
                field ccf_Probe_T_ecf_main_Probe_Reserved_130 {
                    bits 32;
                    access rw;
                    hard_reset 'h0;
                }
            }
            register ccf_Probe_T_ecf_main_Probe_Reserved_131 @0x250 {
                bytes 4;
                field ccf_Probe_T_ecf_main_Probe_Reserved_131 {
                    bits 32;
                    access rw;
                    hard_reset 'h0;
                }
            }
            register ccf_Probe_T_ecf_main_Probe_Reserved_132 @0x254 {
                bytes 4;
                field ccf_Probe_T_ecf_main_Probe_Reserved_132 {
                    bits 32;
                    access rw;
                    hard_reset 'h0;
                }
            }
            register ccf_Probe_T_ecf_main_Probe_Reserved_133 @0x258 {
                bytes 4;
                field ccf_Probe_T_ecf_main_Probe_Reserved_133 {
                    bits 32;
                    access rw;
                    hard_reset 'h0;
                }
            }
            register ccf_Probe_T_ecf_main_Probe_Reserved_134 @0x25C {
                bytes 4;
                field ccf_Probe_T_ecf_main_Probe_Reserved_134 {
                    bits 32;
                    access rw;
                    hard_reset 'h0;
                }
            }
            register ccf_Probe_T_ecf_main_Probe_Reserved_135 @0x260 {
                bytes 4;
                field ccf_Probe_T_ecf_main_Probe_Reserved_135 {
                    bits 32;
                    access rw;
                    hard_reset 'h0;
                }
            }
            register ccf_Probe_T_ecf_main_Probe_Reserved_136 @0x264 {
                bytes 4;
                field ccf_Probe_T_ecf_main_Probe_Reserved_136 {
                    bits 32;
                    access rw;
                    hard_reset 'h0;
                }
            }
            register ccf_Probe_T_ecf_main_Probe_Reserved_137 @0x268 {
                bytes 4;
                field ccf_Probe_T_ecf_main_Probe_Reserved_137 {
                    bits 32;
                    access rw;
                    hard_reset 'h0;
                }
            }
            register ccf_Probe_T_ecf_main_Probe_Reserved_138 @0x26C {
                bytes 4;
                field ccf_Probe_T_ecf_main_Probe_Reserved_138 {
                    bits 32;
                    access rw;
                    hard_reset 'h0;
                }
            }
            register ccf_Probe_T_ecf_main_Probe_Reserved_139 @0x270 {
                bytes 4;
                field ccf_Probe_T_ecf_main_Probe_Reserved_139 {
                    bits 32;
                    access rw;
                    hard_reset 'h0;
                }
            }
            register ccf_Probe_T_ecf_main_Probe_Reserved_140 @0x274 {
                bytes 4;
                field ccf_Probe_T_ecf_main_Probe_Reserved_140 {
                    bits 32;
                    access rw;
                    hard_reset 'h0;
                }
            }
            register ccf_Probe_T_ecf_main_Probe_Reserved_141 @0x278 {
                bytes 4;
                field ccf_Probe_T_ecf_main_Probe_Reserved_141 {
                    bits 32;
                    access rw;
                    hard_reset 'h0;
                }
            }
            register ccf_Probe_T_ecf_main_Probe_Reserved_142 @0x27C {
                bytes 4;
                field ccf_Probe_T_ecf_main_Probe_Reserved_142 {
                    bits 32;
                    access rw;
                    hard_reset 'h0;
                }
            }
            register ccf_Probe_T_ecf_main_Probe_Reserved_143 @0x280 {
                bytes 4;
                field ccf_Probe_T_ecf_main_Probe_Reserved_143 {
                    bits 32;
                    access rw;
                    hard_reset 'h0;
                }
            }
            register ccf_Probe_T_ecf_main_Probe_Reserved_144 @0x284 {
                bytes 4;
                field ccf_Probe_T_ecf_main_Probe_Reserved_144 {
                    bits 32;
                    access rw;
                    hard_reset 'h0;
                }
            }
            register ccf_Probe_T_ecf_main_Probe_Reserved_145 @0x288 {
                bytes 4;
                field ccf_Probe_T_ecf_main_Probe_Reserved_145 {
                    bits 32;
                    access rw;
                    hard_reset 'h0;
                }
            }
            register ccf_Probe_T_ecf_main_Probe_Reserved_146 @0x28C {
                bytes 4;
                field ccf_Probe_T_ecf_main_Probe_Reserved_146 {
                    bits 32;
                    access rw;
                    hard_reset 'h0;
                }
            }
            register ccf_Probe_T_ecf_main_Probe_Reserved_147 @0x290 {
                bytes 4;
                field ccf_Probe_T_ecf_main_Probe_Reserved_147 {
                    bits 32;
                    access rw;
                    hard_reset 'h0;
                }
            }
            register ccf_Probe_T_ecf_main_Probe_Reserved_148 @0x294 {
                bytes 4;
                field ccf_Probe_T_ecf_main_Probe_Reserved_148 {
                    bits 32;
                    access rw;
                    hard_reset 'h0;
                }
            }
            register ccf_Probe_T_ecf_main_Probe_Reserved_149 @0x298 {
                bytes 4;
                field ccf_Probe_T_ecf_main_Probe_Reserved_149 {
                    bits 32;
                    access rw;
                    hard_reset 'h0;
                }
            }
            register ccf_Probe_T_ecf_main_Probe_Reserved_150 @0x29C {
                bytes 4;
                field ccf_Probe_T_ecf_main_Probe_Reserved_150 {
                    bits 32;
                    access rw;
                    hard_reset 'h0;
                }
            }
            register ccf_Probe_T_ecf_main_Probe_Reserved_151 @0x2A0 {
                bytes 4;
                field ccf_Probe_T_ecf_main_Probe_Reserved_151 {
                    bits 32;
                    access rw;
                    hard_reset 'h0;
                }
            }
            register ccf_Probe_T_ecf_main_Probe_Reserved_152 @0x2A4 {
                bytes 4;
                field ccf_Probe_T_ecf_main_Probe_Reserved_152 {
                    bits 32;
                    access rw;
                    hard_reset 'h0;
                }
            }
            register ccf_Probe_T_ecf_main_Probe_Reserved_153 @0x2A8 {
                bytes 4;
                field ccf_Probe_T_ecf_main_Probe_Reserved_153 {
                    bits 32;
                    access rw;
                    hard_reset 'h0;
                }
            }
            register ccf_Probe_T_ecf_main_Probe_Reserved_154 @0x2AC {
                bytes 4;
                field ccf_Probe_T_ecf_main_Probe_Reserved_154 {
                    bits 32;
                    access rw;
                    hard_reset 'h0;
                }
            }
            register ccf_Probe_T_ecf_main_Probe_Reserved_155 @0x2B0 {
                bytes 4;
                field ccf_Probe_T_ecf_main_Probe_Reserved_155 {
                    bits 32;
                    access rw;
                    hard_reset 'h0;
                }
            }
            register ccf_Probe_T_ecf_main_Probe_Reserved_156 @0x2B4 {
                bytes 4;
                field ccf_Probe_T_ecf_main_Probe_Reserved_156 {
                    bits 32;
                    access rw;
                    hard_reset 'h0;
                }
            }
            register ccf_Probe_T_ecf_main_Probe_Reserved_157 @0x2B8 {
                bytes 4;
                field ccf_Probe_T_ecf_main_Probe_Reserved_157 {
                    bits 32;
                    access rw;
                    hard_reset 'h0;
                }
            }
            register ccf_Probe_T_ecf_main_Probe_Reserved_158 @0x2BC {
                bytes 4;
                field ccf_Probe_T_ecf_main_Probe_Reserved_158 {
                    bits 32;
                    access rw;
                    hard_reset 'h0;
                }
            }
            register ccf_Probe_T_ecf_main_Probe_Reserved_159 @0x2C0 {
                bytes 4;
                field ccf_Probe_T_ecf_main_Probe_Reserved_159 {
                    bits 32;
                    access rw;
                    hard_reset 'h0;
                }
            }
            register ccf_Probe_T_ecf_main_Probe_Reserved_160 @0x2C4 {
                bytes 4;
                field ccf_Probe_T_ecf_main_Probe_Reserved_160 {
                    bits 32;
                    access rw;
                    hard_reset 'h0;
                }
            }
            register ccf_Probe_T_ecf_main_Probe_Reserved_161 @0x2C8 {
                bytes 4;
                field ccf_Probe_T_ecf_main_Probe_Reserved_161 {
                    bits 32;
                    access rw;
                    hard_reset 'h0;
                }
            }
            register ccf_Probe_T_ecf_main_Probe_Reserved_162 @0x2CC {
                bytes 4;
                field ccf_Probe_T_ecf_main_Probe_Reserved_162 {
                    bits 32;
                    access rw;
                    hard_reset 'h0;
                }
            }
            register ccf_Probe_T_ecf_main_Probe_Reserved_163 @0x2D0 {
                bytes 4;
                field ccf_Probe_T_ecf_main_Probe_Reserved_163 {
                    bits 32;
                    access rw;
                    hard_reset 'h0;
                }
            }
            register ccf_Probe_T_ecf_main_Probe_Reserved_164 @0x2D4 {
                bytes 4;
                field ccf_Probe_T_ecf_main_Probe_Reserved_164 {
                    bits 32;
                    access rw;
                    hard_reset 'h0;
                }
            }
            register ccf_Probe_T_ecf_main_Probe_Reserved_165 @0x2D8 {
                bytes 4;
                field ccf_Probe_T_ecf_main_Probe_Reserved_165 {
                    bits 32;
                    access rw;
                    hard_reset 'h0;
                }
            }
            register ccf_Probe_T_ecf_main_Probe_Reserved_166 @0x2DC {
                bytes 4;
                field ccf_Probe_T_ecf_main_Probe_Reserved_166 {
                    bits 32;
                    access rw;
                    hard_reset 'h0;
                }
            }
            register ccf_Probe_T_ecf_main_Probe_Reserved_167 @0x2E0 {
                bytes 4;
                field ccf_Probe_T_ecf_main_Probe_Reserved_167 {
                    bits 32;
                    access rw;
                    hard_reset 'h0;
                }
            }
            register ccf_Probe_T_ecf_main_Probe_Reserved_168 @0x2E4 {
                bytes 4;
                field ccf_Probe_T_ecf_main_Probe_Reserved_168 {
                    bits 32;
                    access rw;
                    hard_reset 'h0;
                }
            }
            register ccf_Probe_T_ecf_main_Probe_Reserved_169 @0x2E8 {
                bytes 4;
                field ccf_Probe_T_ecf_main_Probe_Reserved_169 {
                    bits 32;
                    access rw;
                    hard_reset 'h0;
                }
            }
            register ccf_Probe_T_ecf_main_Probe_Reserved_170 @0x2EC {
                bytes 4;
                field ccf_Probe_T_ecf_main_Probe_Reserved_170 {
                    bits 32;
                    access rw;
                    hard_reset 'h0;
                }
            }
            register ccf_Probe_T_ecf_main_Probe_Reserved_171 @0x2F0 {
                bytes 4;
                field ccf_Probe_T_ecf_main_Probe_Reserved_171 {
                    bits 32;
                    access rw;
                    hard_reset 'h0;
                }
            }
            register ccf_Probe_T_ecf_main_Probe_Reserved_172 @0x2F4 {
                bytes 4;
                field ccf_Probe_T_ecf_main_Probe_Reserved_172 {
                    bits 32;
                    access rw;
                    hard_reset 'h0;
                }
            }
            register ccf_Probe_T_ecf_main_Probe_Reserved_173 @0x2F8 {
                bytes 4;
                field ccf_Probe_T_ecf_main_Probe_Reserved_173 {
                    bits 32;
                    access rw;
                    hard_reset 'h0;
                }
            }
            register ccf_Probe_T_ecf_main_Probe_Reserved_174 @0x2FC {
                bytes 4;
                field ccf_Probe_T_ecf_main_Probe_Reserved_174 {
                    bits 32;
                    access rw;
                    hard_reset 'h0;
                }
            }
            register ccf_Probe_T_ecf_main_Probe_Reserved_175 @0x300 {
                bytes 4;
                field ccf_Probe_T_ecf_main_Probe_Reserved_175 {
                    bits 32;
                    access rw;
                    hard_reset 'h0;
                }
            }
            register ccf_Probe_T_ecf_main_Probe_Reserved_176 @0x304 {
                bytes 4;
                field ccf_Probe_T_ecf_main_Probe_Reserved_176 {
                    bits 32;
                    access rw;
                    hard_reset 'h0;
                }
            }
            register ccf_Probe_T_ecf_main_Probe_Reserved_177 @0x308 {
                bytes 4;
                field ccf_Probe_T_ecf_main_Probe_Reserved_177 {
                    bits 32;
                    access rw;
                    hard_reset 'h0;
                }
            }
            register ccf_Probe_T_ecf_main_Probe_Reserved_178 @0x30C {
                bytes 4;
                field ccf_Probe_T_ecf_main_Probe_Reserved_178 {
                    bits 32;
                    access rw;
                    hard_reset 'h0;
                }
            }
            register ccf_Probe_T_ecf_main_Probe_Reserved_179 @0x310 {
                bytes 4;
                field ccf_Probe_T_ecf_main_Probe_Reserved_179 {
                    bits 32;
                    access rw;
                    hard_reset 'h0;
                }
            }
            register ccf_Probe_T_ecf_main_Probe_Reserved_180 @0x314 {
                bytes 4;
                field ccf_Probe_T_ecf_main_Probe_Reserved_180 {
                    bits 32;
                    access rw;
                    hard_reset 'h0;
                }
            }
            register ccf_Probe_T_ecf_main_Probe_Reserved_181 @0x318 {
                bytes 4;
                field ccf_Probe_T_ecf_main_Probe_Reserved_181 {
                    bits 32;
                    access rw;
                    hard_reset 'h0;
                }
            }
            register ccf_Probe_T_ecf_main_Probe_Reserved_182 @0x31C {
                bytes 4;
                field ccf_Probe_T_ecf_main_Probe_Reserved_182 {
                    bits 32;
                    access rw;
                    hard_reset 'h0;
                }
            }
            register ccf_Probe_T_ecf_main_Probe_Reserved_183 @0x320 {
                bytes 4;
                field ccf_Probe_T_ecf_main_Probe_Reserved_183 {
                    bits 32;
                    access rw;
                    hard_reset 'h0;
                }
            }
            register ccf_Probe_T_ecf_main_Probe_Reserved_184 @0x324 {
                bytes 4;
                field ccf_Probe_T_ecf_main_Probe_Reserved_184 {
                    bits 32;
                    access rw;
                    hard_reset 'h0;
                }
            }
            register ccf_Probe_T_ecf_main_Probe_Reserved_185 @0x328 {
                bytes 4;
                field ccf_Probe_T_ecf_main_Probe_Reserved_185 {
                    bits 32;
                    access rw;
                    hard_reset 'h0;
                }
            }
            register ccf_Probe_T_ecf_main_Probe_Reserved_186 @0x32C {
                bytes 4;
                field ccf_Probe_T_ecf_main_Probe_Reserved_186 {
                    bits 32;
                    access rw;
                    hard_reset 'h0;
                }
            }
            register ccf_Probe_T_ecf_main_Probe_Reserved_187 @0x330 {
                bytes 4;
                field ccf_Probe_T_ecf_main_Probe_Reserved_187 {
                    bits 32;
                    access rw;
                    hard_reset 'h0;
                }
            }
            register ccf_Probe_T_ecf_main_Probe_Reserved_188 @0x334 {
                bytes 4;
                field ccf_Probe_T_ecf_main_Probe_Reserved_188 {
                    bits 32;
                    access rw;
                    hard_reset 'h0;
                }
            }
            register ccf_Probe_T_ecf_main_Probe_Reserved_189 @0x338 {
                bytes 4;
                field ccf_Probe_T_ecf_main_Probe_Reserved_189 {
                    bits 32;
                    access rw;
                    hard_reset 'h0;
                }
            }
            register ccf_Probe_T_ecf_main_Probe_Reserved_190 @0x33C {
                bytes 4;
                field ccf_Probe_T_ecf_main_Probe_Reserved_190 {
                    bits 32;
                    access rw;
                    hard_reset 'h0;
                }
            }
            register ccf_Probe_T_ecf_main_Probe_Reserved_191 @0x340 {
                bytes 4;
                field ccf_Probe_T_ecf_main_Probe_Reserved_191 {
                    bits 32;
                    access rw;
                    hard_reset 'h0;
                }
            }
            register ccf_Probe_T_ecf_main_Probe_Reserved_192 @0x344 {
                bytes 4;
                field ccf_Probe_T_ecf_main_Probe_Reserved_192 {
                    bits 32;
                    access rw;
                    hard_reset 'h0;
                }
            }
            register ccf_Probe_T_ecf_main_Probe_Reserved_193 @0x348 {
                bytes 4;
                field ccf_Probe_T_ecf_main_Probe_Reserved_193 {
                    bits 32;
                    access rw;
                    hard_reset 'h0;
                }
            }
            register ccf_Probe_T_ecf_main_Probe_Reserved_194 @0x34C {
                bytes 4;
                field ccf_Probe_T_ecf_main_Probe_Reserved_194 {
                    bits 32;
                    access rw;
                    hard_reset 'h0;
                }
            }
            register ccf_Probe_T_ecf_main_Probe_Reserved_195 @0x350 {
                bytes 4;
                field ccf_Probe_T_ecf_main_Probe_Reserved_195 {
                    bits 32;
                    access rw;
                    hard_reset 'h0;
                }
            }
            register ccf_Probe_T_ecf_main_Probe_Reserved_196 @0x354 {
                bytes 4;
                field ccf_Probe_T_ecf_main_Probe_Reserved_196 {
                    bits 32;
                    access rw;
                    hard_reset 'h0;
                }
            }
            register ccf_Probe_T_ecf_main_Probe_Reserved_197 @0x358 {
                bytes 4;
                field ccf_Probe_T_ecf_main_Probe_Reserved_197 {
                    bits 32;
                    access rw;
                    hard_reset 'h0;
                }
            }
            register ccf_Probe_T_ecf_main_Probe_Reserved_198 @0x35C {
                bytes 4;
                field ccf_Probe_T_ecf_main_Probe_Reserved_198 {
                    bits 32;
                    access rw;
                    hard_reset 'h0;
                }
            }
            register ccf_Probe_T_ecf_main_Probe_Reserved_199 @0x360 {
                bytes 4;
                field ccf_Probe_T_ecf_main_Probe_Reserved_199 {
                    bits 32;
                    access rw;
                    hard_reset 'h0;
                }
            }
            register ccf_Probe_T_ecf_main_Probe_Reserved_200 @0x364 {
                bytes 4;
                field ccf_Probe_T_ecf_main_Probe_Reserved_200 {
                    bits 32;
                    access rw;
                    hard_reset 'h0;
                }
            }
            register ccf_Probe_T_ecf_main_Probe_Reserved_201 @0x368 {
                bytes 4;
                field ccf_Probe_T_ecf_main_Probe_Reserved_201 {
                    bits 32;
                    access rw;
                    hard_reset 'h0;
                }
            }
            register ccf_Probe_T_ecf_main_Probe_Reserved_202 @0x36C {
                bytes 4;
                field ccf_Probe_T_ecf_main_Probe_Reserved_202 {
                    bits 32;
                    access rw;
                    hard_reset 'h0;
                }
            }
            register ccf_Probe_T_ecf_main_Probe_Reserved_203 @0x370 {
                bytes 4;
                field ccf_Probe_T_ecf_main_Probe_Reserved_203 {
                    bits 32;
                    access rw;
                    hard_reset 'h0;
                }
            }
            register ccf_Probe_T_ecf_main_Probe_Reserved_204 @0x374 {
                bytes 4;
                field ccf_Probe_T_ecf_main_Probe_Reserved_204 {
                    bits 32;
                    access rw;
                    hard_reset 'h0;
                }
            }
            register ccf_Probe_T_ecf_main_Probe_Reserved_205 @0x378 {
                bytes 4;
                field ccf_Probe_T_ecf_main_Probe_Reserved_205 {
                    bits 32;
                    access rw;
                    hard_reset 'h0;
                }
            }
            register ccf_Probe_T_ecf_main_Probe_Reserved_206 @0x37C {
                bytes 4;
                field ccf_Probe_T_ecf_main_Probe_Reserved_206 {
                    bits 32;
                    access rw;
                    hard_reset 'h0;
                }
            }
            register ccf_Probe_T_ecf_main_Probe_Reserved_207 @0x380 {
                bytes 4;
                field ccf_Probe_T_ecf_main_Probe_Reserved_207 {
                    bits 32;
                    access rw;
                    hard_reset 'h0;
                }
            }
            register ccf_Probe_T_ecf_main_Probe_Reserved_208 @0x384 {
                bytes 4;
                field ccf_Probe_T_ecf_main_Probe_Reserved_208 {
                    bits 32;
                    access rw;
                    hard_reset 'h0;
                }
            }
            register ccf_Probe_T_ecf_main_Probe_Reserved_209 @0x388 {
                bytes 4;
                field ccf_Probe_T_ecf_main_Probe_Reserved_209 {
                    bits 32;
                    access rw;
                    hard_reset 'h0;
                }
            }
            register ccf_Probe_T_ecf_main_Probe_Reserved_210 @0x38C {
                bytes 4;
                field ccf_Probe_T_ecf_main_Probe_Reserved_210 {
                    bits 32;
                    access rw;
                    hard_reset 'h0;
                }
            }
            register ccf_Probe_T_ecf_main_Probe_Reserved_211 @0x390 {
                bytes 4;
                field ccf_Probe_T_ecf_main_Probe_Reserved_211 {
                    bits 32;
                    access rw;
                    hard_reset 'h0;
                }
            }
            register ccf_Probe_T_ecf_main_Probe_Reserved_212 @0x394 {
                bytes 4;
                field ccf_Probe_T_ecf_main_Probe_Reserved_212 {
                    bits 32;
                    access rw;
                    hard_reset 'h0;
                }
            }
            register ccf_Probe_T_ecf_main_Probe_Reserved_213 @0x398 {
                bytes 4;
                field ccf_Probe_T_ecf_main_Probe_Reserved_213 {
                    bits 32;
                    access rw;
                    hard_reset 'h0;
                }
            }
            register ccf_Probe_T_ecf_main_Probe_Reserved_214 @0x39C {
                bytes 4;
                field ccf_Probe_T_ecf_main_Probe_Reserved_214 {
                    bits 32;
                    access rw;
                    hard_reset 'h0;
                }
            }
            register ccf_Probe_T_ecf_main_Probe_Reserved_215 @0x3A0 {
                bytes 4;
                field ccf_Probe_T_ecf_main_Probe_Reserved_215 {
                    bits 32;
                    access rw;
                    hard_reset 'h0;
                }
            }
            register ccf_Probe_T_ecf_main_Probe_Reserved_216 @0x3A4 {
                bytes 4;
                field ccf_Probe_T_ecf_main_Probe_Reserved_216 {
                    bits 32;
                    access rw;
                    hard_reset 'h0;
                }
            }
            register ccf_Probe_T_ecf_main_Probe_Reserved_217 @0x3A8 {
                bytes 4;
                field ccf_Probe_T_ecf_main_Probe_Reserved_217 {
                    bits 32;
                    access rw;
                    hard_reset 'h0;
                }
            }
            register ccf_Probe_T_ecf_main_Probe_Reserved_218 @0x3AC {
                bytes 4;
                field ccf_Probe_T_ecf_main_Probe_Reserved_218 {
                    bits 32;
                    access rw;
                    hard_reset 'h0;
                }
            }
            register ccf_Probe_T_ecf_main_Probe_Reserved_219 @0x3B0 {
                bytes 4;
                field ccf_Probe_T_ecf_main_Probe_Reserved_219 {
                    bits 32;
                    access rw;
                    hard_reset 'h0;
                }
            }
            register ccf_Probe_T_ecf_main_Probe_Reserved_220 @0x3B4 {
                bytes 4;
                field ccf_Probe_T_ecf_main_Probe_Reserved_220 {
                    bits 32;
                    access rw;
                    hard_reset 'h0;
                }
            }
            register ccf_Probe_T_ecf_main_Probe_Reserved_221 @0x3B8 {
                bytes 4;
                field ccf_Probe_T_ecf_main_Probe_Reserved_221 {
                    bits 32;
                    access rw;
                    hard_reset 'h0;
                }
            }
            register ccf_Probe_T_ecf_main_Probe_Reserved_222 @0x3BC {
                bytes 4;
                field ccf_Probe_T_ecf_main_Probe_Reserved_222 {
                    bits 32;
                    access rw;
                    hard_reset 'h0;
                }
            }
            register ccf_Probe_T_ecf_main_Probe_Reserved_223 @0x3C0 {
                bytes 4;
                field ccf_Probe_T_ecf_main_Probe_Reserved_223 {
                    bits 32;
                    access rw;
                    hard_reset 'h0;
                }
            }
            register ccf_Probe_T_ecf_main_Probe_Reserved_224 @0x3C4 {
                bytes 4;
                field ccf_Probe_T_ecf_main_Probe_Reserved_224 {
                    bits 32;
                    access rw;
                    hard_reset 'h0;
                }
            }
            register ccf_Probe_T_ecf_main_Probe_Reserved_225 @0x3C8 {
                bytes 4;
                field ccf_Probe_T_ecf_main_Probe_Reserved_225 {
                    bits 32;
                    access rw;
                    hard_reset 'h0;
                }
            }
            register ccf_Probe_T_ecf_main_Probe_Reserved_226 @0x3CC {
                bytes 4;
                field ccf_Probe_T_ecf_main_Probe_Reserved_226 {
                    bits 32;
                    access rw;
                    hard_reset 'h0;
                }
            }
            register ccf_Probe_T_ecf_main_Probe_Reserved_227 @0x3D0 {
                bytes 4;
                field ccf_Probe_T_ecf_main_Probe_Reserved_227 {
                    bits 32;
                    access rw;
                    hard_reset 'h0;
                }
            }
            register ccf_Probe_T_ecf_main_Probe_Reserved_228 @0x3D4 {
                bytes 4;
                field ccf_Probe_T_ecf_main_Probe_Reserved_228 {
                    bits 32;
                    access rw;
                    hard_reset 'h0;
                }
            }
            register ccf_Probe_T_ecf_main_Probe_Reserved_229 @0x3D8 {
                bytes 4;
                field ccf_Probe_T_ecf_main_Probe_Reserved_229 {
                    bits 32;
                    access rw;
                    hard_reset 'h0;
                }
            }
            register ccf_Probe_T_ecf_main_Probe_Reserved_230 @0x3DC {
                bytes 4;
                field ccf_Probe_T_ecf_main_Probe_Reserved_230 {
                    bits 32;
                    access rw;
                    hard_reset 'h0;
                }
            }
            register ccf_Probe_T_ecf_main_Probe_Reserved_231 @0x3E0 {
                bytes 4;
                field ccf_Probe_T_ecf_main_Probe_Reserved_231 {
                    bits 32;
                    access rw;
                    hard_reset 'h0;
                }
            }
            register ccf_Probe_T_ecf_main_Probe_Reserved_232 @0x3E4 {
                bytes 4;
                field ccf_Probe_T_ecf_main_Probe_Reserved_232 {
                    bits 32;
                    access rw;
                    hard_reset 'h0;
                }
            }
            register ccf_Probe_T_ecf_main_Probe_Reserved_233 @0x3E8 {
                bytes 4;
                field ccf_Probe_T_ecf_main_Probe_Reserved_233 {
                    bits 32;
                    access rw;
                    hard_reset 'h0;
                }
            }
            register ccf_Probe_T_ecf_main_Probe_Reserved_234 @0x3EC {
                bytes 4;
                field ccf_Probe_T_ecf_main_Probe_Reserved_234 {
                    bits 32;
                    access rw;
                    hard_reset 'h0;
                }
            }
            register ccf_Probe_T_ecf_main_Probe_Reserved_235 @0x3F0 {
                bytes 4;
                field ccf_Probe_T_ecf_main_Probe_Reserved_235 {
                    bits 32;
                    access rw;
                    hard_reset 'h0;
                }
            }
            register ccf_Probe_T_ecf_main_Probe_Reserved_236 @0x3F4 {
                bytes 4;
                field ccf_Probe_T_ecf_main_Probe_Reserved_236 {
                    bits 32;
                    access rw;
                    hard_reset 'h0;
                }
            }
            register ccf_Probe_T_ecf_main_Probe_Reserved_237 @0x3F8 {
                bytes 4;
                field ccf_Probe_T_ecf_main_Probe_Reserved_237 {
                    bits 32;
                    access rw;
                    hard_reset 'h0;
                }
            }
            register ccf_Probe_T_ecf_main_Probe_Reserved_238 @0x3FC {
                bytes 4;
                field ccf_Probe_T_ecf_main_Probe_Reserved_238 {
                    bits 32;
                    access rw;
                    hard_reset 'h0;
                }
            }
        }
        block ecf_ccf_axi_ccf_Probe_T_jtag_main_Probe @0xD8C00 {
            bytes 4;
            register ccf_Probe_T_jtag_main_Probe_Id_CoreId @0x0 {
                bytes 4;
                field CORETYPEID @'h0 {
                    bits 8;
                    access ro;
                    hard_reset 'h6;
                    doc {
                        Field identifying the type of IP.
                    }
                }
                field CORECHECKSUM @'h8 {
                    bits 24;
                    access ro;
                    hard_reset 'h5f10e4;
                    doc {
                        Field containing a checksum of the parameters of the IP.
                    }
                }
            }
            register ccf_Probe_T_jtag_main_Probe_Id_RevisionId @0x4 {
                bytes 4;
                field USERID @'h0 {
                    bits 8;
                    access ro;
                    hard_reset 'h0;
                    doc {
                        Field containing a user defined value, not used anywhere inside the IP itself.
                    }
                }
                field FLEXNOCID @'h8 {
                    bits 24;
                    access ro;
                    hard_reset 'h84f8c6;
                    doc {
                        Field containing the build revision of the software used to generate the IP HDL code.
                    }
                }
            }
            register ccf_Probe_T_jtag_main_Probe_MainCtl @0x8 {
                bytes 4;
                field ERREN @'h0 {
                    access rw;
                    hard_reset 'h0;
                    doc {
                        Register field ErrEn enables the probe to send on the ObsTx output any packet with Error status, independently of filtering mechanisms, thus constituting a simple supplementary global filter.
                    }
                }
                field TRACEEN @'h1 {
                    access ro;
                    hard_reset 'h0;
                    doc {
                        Register field TraceEn enables the probe to send filtered packets (Trace) on the ObsTx observation output.
                    }
                }
                field PAYLOADEN @'h2 {
                    access rw;
                    hard_reset 'h0;
                    doc {
                        Register field PayloadEn, when set to 1, enables traces to contain headers and payload. When set ot 0, only headers are reported.
                    }
                }
                field STATEN @'h3 {
                    access rw;
                    hard_reset 'h0;
                    doc {
                        When set to 1, register field StatEn enables statistics profiling. The probe sendS statistics results to the output for signal ObsTx. All statistics counters are cleared when the StatEn bit goes from 0 to 1. When set to 0, counters are disabled.
                    }
                }
                field ALARMEN @'h4 {
                    access rw;
                    hard_reset 'h0;
                    doc {
                        When set, register field AlarmEn enables the probe to collect alarm-related information. When the register field bit is null, both TraceAlarm and StatAlarm outputs are driven to 0.
                    }
                }
                field STATCONDDUMP @'h5 {
                    access rw;
                    hard_reset 'h0;
                    doc {
                        When set, register field StatCondDump enables the dump of a statistics frame to the range of counter values set for registers StatAlarmMin, StatAlarmMax, and AlarmMode. This field also renders register StatAlarmStatus inoperative. When parameter statisticsCounterAlarm is set to False, the StatCondDump register bit is reserved.
                    }
                }
                field INTRUSIVEMODE @'h6 {
                    access ro;
                    hard_reset 'h0;
                    doc {
                        When set to 1, register field IntrusiveMode enables trace operation in Intrusive flow-control mode. When set to 0, the register  enables trace operation in Overflow flow-control mode
                    }
                }
                field FILTBYTEALWAYSCHAINABLEEN @'h7 {
                    access rw;
                    hard_reset 'h0;
                    doc {
                        When set to 0, filters are mapped to all statistic counters when counting bytes or enabled bytes. Therefore, only filter events mapped to even counters can be counted using a pair of chained counters.When set to 1, filters are mapped only to even statistic counters when counting bytes or enabled bytes. Thus events from any filter can be counted using a pair of chained counters.
                    }
                }
                doc {
                    Register MainCtl contains probe global control bits. The register has seven bit fields:Register MainCtl contains probe global control bits. The register has seven bit fields:
                }
            }
            register ccf_Probe_T_jtag_main_Probe_CfgCtl @0xC {
                bytes 4;
                field GLOBALEN @'h0 {
                    access rw;
                    hard_reset 'h0;
                }
                field ACTIVE @'h1 {
                    access ro;
                    hard_reset 'h0;
                }
            }
            register ccf_Probe_T_jtag_main_Probe_Reserved_00 @0x10 {
                bytes 4;
                field ccf_Probe_T_jtag_main_Probe_Reserved_00 {
                    bits 32;
                    access rw;
                    hard_reset 'h0;
                }
            }
            register ccf_Probe_T_jtag_main_Probe_Reserved_01 @0x14 {
                bytes 4;
                field ccf_Probe_T_jtag_main_Probe_Reserved_01 {
                    bits 32;
                    access rw;
                    hard_reset 'h0;
                }
            }
            register ccf_Probe_T_jtag_main_Probe_Reserved_02 @0x18 {
                bytes 4;
                field ccf_Probe_T_jtag_main_Probe_Reserved_02 {
                    bits 32;
                    access rw;
                    hard_reset 'h0;
                }
            }
            register ccf_Probe_T_jtag_main_Probe_Reserved_03 @0x1C {
                bytes 4;
                field ccf_Probe_T_jtag_main_Probe_Reserved_03 {
                    bits 32;
                    access rw;
                    hard_reset 'h0;
                }
            }
            register ccf_Probe_T_jtag_main_Probe_Reserved_04 @0x20 {
                bytes 4;
                field ccf_Probe_T_jtag_main_Probe_Reserved_04 {
                    bits 32;
                    access rw;
                    hard_reset 'h0;
                }
            }
            register ccf_Probe_T_jtag_main_Probe_StatPeriod @0x24 {
                bytes 4;
                field STATPERIOD @'h0 {
                    bits 5;
                    access rw;
                    hard_reset 'h0;
                    doc {
                        Register StatPeriod is a 5-bit register that sets a period, within a range of 2 cycles to 2 gigacycles, during which statistics are collected before being dumped automatically. Setting the register implicitly enables automatic mode operation for statistics collection. The period is calculated with the formula: N_Cycle = 2**StatPeriodWhen register StatPeriod is set to its default value 0, automatic dump mode is disabled, and register StatGo is activated for manual mode operation. Note: When parameter statisticsCollection is set to False, StatPeriod is reserved.
                    }
                }
            }
            register ccf_Probe_T_jtag_main_Probe_StatGo @0x28 {
                bytes 4;
                field STATGO @'h0 {
                    access w1c;
                    hard_reset 'h0;
                    doc {
                        Writing a 1 to the 1-bit pulse register StatGo generates a statistics dump.The register is active when statistics collection operates in manual mode, that is, when register StatPeriod is set to 0.NOTE  The written value is not stored in StatGo. A read always returns 0.
                    }
                }
            }
            register ccf_Probe_T_jtag_main_Probe_StatAlarmMin @0x2C {
                bytes 4;
                field STATALARMMIN @'h0 {
                    bits 22;
                    access rw;
                    hard_reset 'h0;
                    doc {
                        Register StatAlarmMin contains the minimum count value used in statistics alarm comparisons. The number of bits is equal to twice the value set forparameter wStatisticsCounter. When parameter statisticsCounterAlarm is set to False, StatAlarmMin is reserved.
                    }
                }
            }
            register ccf_Probe_T_jtag_main_Probe_StatAlarmMax @0x30 {
                bytes 4;
                field STATALARMMAX @'h0 {
                    bits 22;
                    access rw;
                    hard_reset 'h0;
                    doc {
                        Register StatAlarmMax contains the maximum count value used in statistics alarm comparisons.The number of bits is equal to twice the value set for parameter wStatisticsCounter. When parameter statisticsCounterAlarm is set to False, StatAlarmMax is reserved.
                    }
                }
            }
            register ccf_Probe_T_jtag_main_Probe_StatAlarmStatus @0x34 {
                bytes 4;
                field STATALARMSTATUS @'h0 {
                    access ro;
                    hard_reset 'h0;
                    doc {
                        Register StatAlarmStatus is a read-only 1-bit register indicating that at least one statistics counter has exceeded the programmed values for registers StatAlarmMin or StatAlarmMax. Output signal StatAlarm is equal to the values stored in register MainCtl fields StatAlarmStatus and AlarmEn. When parameter statisticsCounterAlarm is set to False, StatAlarmStatus is reserved.
                    }
                }
            }
            register ccf_Probe_T_jtag_main_Probe_StatAlarmClr @0x38 {
                bytes 4;
                field STATALARMCLR @'h0 {
                    access w1c;
                    hard_reset 'h0;
                    doc {
                        Register StatAlarmClr is a 1-bit register. Writing a 1 to this register clears the StatAlarmStatus register bit.When parameter statisticsCounterAlarm is set to False, StatAlarmClr is reserved.NOTE  The written value is not stored in StatAlarmClr. A read always returns 0.
                    }
                }
            }
            register ccf_Probe_T_jtag_main_Probe_StatAlarmEn @0x3C {
                bytes 4;
                field STATALARMEN @'h0 {
                    access rw;
                    hard_reset 'h1;
                    doc {
                        Register StatAlarmEn is a 1-bit register. When set to 0 it masks StatAlarm and CtiTrigOut(1) signal interrupts.
                    }
                }
            }
            register ccf_Probe_T_jtag_main_Probe_Reserved_05 @0x40 {
                bytes 4;
                field ccf_Probe_T_jtag_main_Probe_Reserved_05 {
                    bits 32;
                    access rw;
                    hard_reset 'h0;
                }
            }
            register ccf_Probe_T_jtag_main_Probe_Reserved_06 @0x44 {
                bytes 4;
                field ccf_Probe_T_jtag_main_Probe_Reserved_06 {
                    bits 32;
                    access rw;
                    hard_reset 'h0;
                }
            }
            register ccf_Probe_T_jtag_main_Probe_Reserved_07 @0x48 {
                bytes 4;
                field ccf_Probe_T_jtag_main_Probe_Reserved_07 {
                    bits 32;
                    access rw;
                    hard_reset 'h0;
                }
            }
            register ccf_Probe_T_jtag_main_Probe_Reserved_08 @0x4C {
                bytes 4;
                field ccf_Probe_T_jtag_main_Probe_Reserved_08 {
                    bits 32;
                    access rw;
                    hard_reset 'h0;
                }
            }
            register ccf_Probe_T_jtag_main_Probe_Reserved_09 @0x50 {
                bytes 4;
                field ccf_Probe_T_jtag_main_Probe_Reserved_09 {
                    bits 32;
                    access rw;
                    hard_reset 'h0;
                }
            }
            register ccf_Probe_T_jtag_main_Probe_Reserved_10 @0x54 {
                bytes 4;
                field ccf_Probe_T_jtag_main_Probe_Reserved_10 {
                    bits 32;
                    access rw;
                    hard_reset 'h0;
                }
            }
            register ccf_Probe_T_jtag_main_Probe_Reserved_11 @0x58 {
                bytes 4;
                field ccf_Probe_T_jtag_main_Probe_Reserved_11 {
                    bits 32;
                    access rw;
                    hard_reset 'h0;
                }
            }
            register ccf_Probe_T_jtag_main_Probe_Reserved_12 @0x5C {
                bytes 4;
                field ccf_Probe_T_jtag_main_Probe_Reserved_12 {
                    bits 32;
                    access rw;
                    hard_reset 'h0;
                }
            }
            register ccf_Probe_T_jtag_main_Probe_Reserved_13 @0x60 {
                bytes 4;
                field ccf_Probe_T_jtag_main_Probe_Reserved_13 {
                    bits 32;
                    access rw;
                    hard_reset 'h0;
                }
            }
            register ccf_Probe_T_jtag_main_Probe_Reserved_14 @0x64 {
                bytes 4;
                field ccf_Probe_T_jtag_main_Probe_Reserved_14 {
                    bits 32;
                    access rw;
                    hard_reset 'h0;
                }
            }
            register ccf_Probe_T_jtag_main_Probe_Reserved_15 @0x68 {
                bytes 4;
                field ccf_Probe_T_jtag_main_Probe_Reserved_15 {
                    bits 32;
                    access rw;
                    hard_reset 'h0;
                }
            }
            register ccf_Probe_T_jtag_main_Probe_Reserved_16 @0x6C {
                bytes 4;
                field ccf_Probe_T_jtag_main_Probe_Reserved_16 {
                    bits 32;
                    access rw;
                    hard_reset 'h0;
                }
            }
            register ccf_Probe_T_jtag_main_Probe_Reserved_17 @0x70 {
                bytes 4;
                field ccf_Probe_T_jtag_main_Probe_Reserved_17 {
                    bits 32;
                    access rw;
                    hard_reset 'h0;
                }
            }
            register ccf_Probe_T_jtag_main_Probe_Reserved_18 @0x74 {
                bytes 4;
                field ccf_Probe_T_jtag_main_Probe_Reserved_18 {
                    bits 32;
                    access rw;
                    hard_reset 'h0;
                }
            }
            register ccf_Probe_T_jtag_main_Probe_Reserved_19 @0x78 {
                bytes 4;
                field ccf_Probe_T_jtag_main_Probe_Reserved_19 {
                    bits 32;
                    access rw;
                    hard_reset 'h0;
                }
            }
            register ccf_Probe_T_jtag_main_Probe_Reserved_20 @0x7C {
                bytes 4;
                field ccf_Probe_T_jtag_main_Probe_Reserved_20 {
                    bits 32;
                    access rw;
                    hard_reset 'h0;
                }
            }
            register ccf_Probe_T_jtag_main_Probe_Reserved_21 @0x80 {
                bytes 4;
                field ccf_Probe_T_jtag_main_Probe_Reserved_21 {
                    bits 32;
                    access rw;
                    hard_reset 'h0;
                }
            }
            register ccf_Probe_T_jtag_main_Probe_Reserved_22 @0x84 {
                bytes 4;
                field ccf_Probe_T_jtag_main_Probe_Reserved_22 {
                    bits 32;
                    access rw;
                    hard_reset 'h0;
                }
            }
            register ccf_Probe_T_jtag_main_Probe_Reserved_23 @0x88 {
                bytes 4;
                field ccf_Probe_T_jtag_main_Probe_Reserved_23 {
                    bits 32;
                    access rw;
                    hard_reset 'h0;
                }
            }
            register ccf_Probe_T_jtag_main_Probe_Reserved_24 @0x8C {
                bytes 4;
                field ccf_Probe_T_jtag_main_Probe_Reserved_24 {
                    bits 32;
                    access rw;
                    hard_reset 'h0;
                }
            }
            register ccf_Probe_T_jtag_main_Probe_Reserved_25 @0x90 {
                bytes 4;
                field ccf_Probe_T_jtag_main_Probe_Reserved_25 {
                    bits 32;
                    access rw;
                    hard_reset 'h0;
                }
            }
            register ccf_Probe_T_jtag_main_Probe_Reserved_26 @0x94 {
                bytes 4;
                field ccf_Probe_T_jtag_main_Probe_Reserved_26 {
                    bits 32;
                    access rw;
                    hard_reset 'h0;
                }
            }
            register ccf_Probe_T_jtag_main_Probe_Reserved_27 @0x98 {
                bytes 4;
                field ccf_Probe_T_jtag_main_Probe_Reserved_27 {
                    bits 32;
                    access rw;
                    hard_reset 'h0;
                }
            }
            register ccf_Probe_T_jtag_main_Probe_Reserved_28 @0x9C {
                bytes 4;
                field ccf_Probe_T_jtag_main_Probe_Reserved_28 {
                    bits 32;
                    access rw;
                    hard_reset 'h0;
                }
            }
            register ccf_Probe_T_jtag_main_Probe_Reserved_29 @0xA0 {
                bytes 4;
                field ccf_Probe_T_jtag_main_Probe_Reserved_29 {
                    bits 32;
                    access rw;
                    hard_reset 'h0;
                }
            }
            register ccf_Probe_T_jtag_main_Probe_Reserved_30 @0xA4 {
                bytes 4;
                field ccf_Probe_T_jtag_main_Probe_Reserved_30 {
                    bits 32;
                    access rw;
                    hard_reset 'h0;
                }
            }
            register ccf_Probe_T_jtag_main_Probe_Reserved_31 @0xA8 {
                bytes 4;
                field ccf_Probe_T_jtag_main_Probe_Reserved_31 {
                    bits 32;
                    access rw;
                    hard_reset 'h0;
                }
            }
            register ccf_Probe_T_jtag_main_Probe_Reserved_32 @0xAC {
                bytes 4;
                field ccf_Probe_T_jtag_main_Probe_Reserved_32 {
                    bits 32;
                    access rw;
                    hard_reset 'h0;
                }
            }
            register ccf_Probe_T_jtag_main_Probe_Reserved_33 @0xB0 {
                bytes 4;
                field ccf_Probe_T_jtag_main_Probe_Reserved_33 {
                    bits 32;
                    access rw;
                    hard_reset 'h0;
                }
            }
            register ccf_Probe_T_jtag_main_Probe_Reserved_34 @0xB4 {
                bytes 4;
                field ccf_Probe_T_jtag_main_Probe_Reserved_34 {
                    bits 32;
                    access rw;
                    hard_reset 'h0;
                }
            }
            register ccf_Probe_T_jtag_main_Probe_Reserved_35 @0xB8 {
                bytes 4;
                field ccf_Probe_T_jtag_main_Probe_Reserved_35 {
                    bits 32;
                    access rw;
                    hard_reset 'h0;
                }
            }
            register ccf_Probe_T_jtag_main_Probe_Reserved_36 @0xBC {
                bytes 4;
                field ccf_Probe_T_jtag_main_Probe_Reserved_36 {
                    bits 32;
                    access rw;
                    hard_reset 'h0;
                }
            }
            register ccf_Probe_T_jtag_main_Probe_Reserved_37 @0xC0 {
                bytes 4;
                field ccf_Probe_T_jtag_main_Probe_Reserved_37 {
                    bits 32;
                    access rw;
                    hard_reset 'h0;
                }
            }
            register ccf_Probe_T_jtag_main_Probe_Reserved_38 @0xC4 {
                bytes 4;
                field ccf_Probe_T_jtag_main_Probe_Reserved_38 {
                    bits 32;
                    access rw;
                    hard_reset 'h0;
                }
            }
            register ccf_Probe_T_jtag_main_Probe_Reserved_39 @0xC8 {
                bytes 4;
                field ccf_Probe_T_jtag_main_Probe_Reserved_39 {
                    bits 32;
                    access rw;
                    hard_reset 'h0;
                }
            }
            register ccf_Probe_T_jtag_main_Probe_Reserved_40 @0xCC {
                bytes 4;
                field ccf_Probe_T_jtag_main_Probe_Reserved_40 {
                    bits 32;
                    access rw;
                    hard_reset 'h0;
                }
            }
            register ccf_Probe_T_jtag_main_Probe_Reserved_41 @0xD0 {
                bytes 4;
                field ccf_Probe_T_jtag_main_Probe_Reserved_41 {
                    bits 32;
                    access rw;
                    hard_reset 'h0;
                }
            }
            register ccf_Probe_T_jtag_main_Probe_Reserved_42 @0xD4 {
                bytes 4;
                field ccf_Probe_T_jtag_main_Probe_Reserved_42 {
                    bits 32;
                    access rw;
                    hard_reset 'h0;
                }
            }
            register ccf_Probe_T_jtag_main_Probe_Reserved_43 @0xD8 {
                bytes 4;
                field ccf_Probe_T_jtag_main_Probe_Reserved_43 {
                    bits 32;
                    access rw;
                    hard_reset 'h0;
                }
            }
            register ccf_Probe_T_jtag_main_Probe_Reserved_44 @0xDC {
                bytes 4;
                field ccf_Probe_T_jtag_main_Probe_Reserved_44 {
                    bits 32;
                    access rw;
                    hard_reset 'h0;
                }
            }
            register ccf_Probe_T_jtag_main_Probe_Reserved_45 @0xE0 {
                bytes 4;
                field ccf_Probe_T_jtag_main_Probe_Reserved_45 {
                    bits 32;
                    access rw;
                    hard_reset 'h0;
                }
            }
            register ccf_Probe_T_jtag_main_Probe_Reserved_46 @0xE4 {
                bytes 4;
                field ccf_Probe_T_jtag_main_Probe_Reserved_46 {
                    bits 32;
                    access rw;
                    hard_reset 'h0;
                }
            }
            register ccf_Probe_T_jtag_main_Probe_Reserved_47 @0xE8 {
                bytes 4;
                field ccf_Probe_T_jtag_main_Probe_Reserved_47 {
                    bits 32;
                    access rw;
                    hard_reset 'h0;
                }
            }
            register ccf_Probe_T_jtag_main_Probe_Reserved_48 @0xEC {
                bytes 4;
                field ccf_Probe_T_jtag_main_Probe_Reserved_48 {
                    bits 32;
                    access rw;
                    hard_reset 'h0;
                }
            }
            register ccf_Probe_T_jtag_main_Probe_Reserved_49 @0xF0 {
                bytes 4;
                field ccf_Probe_T_jtag_main_Probe_Reserved_49 {
                    bits 32;
                    access rw;
                    hard_reset 'h0;
                }
            }
            register ccf_Probe_T_jtag_main_Probe_Reserved_50 @0xF4 {
                bytes 4;
                field ccf_Probe_T_jtag_main_Probe_Reserved_50 {
                    bits 32;
                    access rw;
                    hard_reset 'h0;
                }
            }
            register ccf_Probe_T_jtag_main_Probe_Reserved_51 @0xF8 {
                bytes 4;
                field ccf_Probe_T_jtag_main_Probe_Reserved_51 {
                    bits 32;
                    access rw;
                    hard_reset 'h0;
                }
            }
            register ccf_Probe_T_jtag_main_Probe_Reserved_52 @0xFC {
                bytes 4;
                field ccf_Probe_T_jtag_main_Probe_Reserved_52 {
                    bits 32;
                    access rw;
                    hard_reset 'h0;
                }
            }
            register ccf_Probe_T_jtag_main_Probe_Reserved_53 @0x100 {
                bytes 4;
                field ccf_Probe_T_jtag_main_Probe_Reserved_53 {
                    bits 32;
                    access rw;
                    hard_reset 'h0;
                }
            }
            register ccf_Probe_T_jtag_main_Probe_Reserved_54 @0x104 {
                bytes 4;
                field ccf_Probe_T_jtag_main_Probe_Reserved_54 {
                    bits 32;
                    access rw;
                    hard_reset 'h0;
                }
            }
            register ccf_Probe_T_jtag_main_Probe_Reserved_55 @0x108 {
                bytes 4;
                field ccf_Probe_T_jtag_main_Probe_Reserved_55 {
                    bits 32;
                    access rw;
                    hard_reset 'h0;
                }
            }
            register ccf_Probe_T_jtag_main_Probe_Reserved_56 @0x10C {
                bytes 4;
                field ccf_Probe_T_jtag_main_Probe_Reserved_56 {
                    bits 32;
                    access rw;
                    hard_reset 'h0;
                }
            }
            register ccf_Probe_T_jtag_main_Probe_Reserved_57 @0x110 {
                bytes 4;
                field ccf_Probe_T_jtag_main_Probe_Reserved_57 {
                    bits 32;
                    access rw;
                    hard_reset 'h0;
                }
            }
            register ccf_Probe_T_jtag_main_Probe_Reserved_58 @0x114 {
                bytes 4;
                field ccf_Probe_T_jtag_main_Probe_Reserved_58 {
                    bits 32;
                    access rw;
                    hard_reset 'h0;
                }
            }
            register ccf_Probe_T_jtag_main_Probe_Reserved_59 @0x118 {
                bytes 4;
                field ccf_Probe_T_jtag_main_Probe_Reserved_59 {
                    bits 32;
                    access rw;
                    hard_reset 'h0;
                }
            }
            register ccf_Probe_T_jtag_main_Probe_Reserved_60 @0x11C {
                bytes 4;
                field ccf_Probe_T_jtag_main_Probe_Reserved_60 {
                    bits 32;
                    access rw;
                    hard_reset 'h0;
                }
            }
            register ccf_Probe_T_jtag_main_Probe_Reserved_61 @0x120 {
                bytes 4;
                field ccf_Probe_T_jtag_main_Probe_Reserved_61 {
                    bits 32;
                    access rw;
                    hard_reset 'h0;
                }
            }
            register ccf_Probe_T_jtag_main_Probe_Reserved_62 @0x124 {
                bytes 4;
                field ccf_Probe_T_jtag_main_Probe_Reserved_62 {
                    bits 32;
                    access rw;
                    hard_reset 'h0;
                }
            }
            register ccf_Probe_T_jtag_main_Probe_Reserved_63 @0x128 {
                bytes 4;
                field ccf_Probe_T_jtag_main_Probe_Reserved_63 {
                    bits 32;
                    access rw;
                    hard_reset 'h0;
                }
            }
            register ccf_Probe_T_jtag_main_Probe_Reserved_64 @0x12C {
                bytes 4;
                field ccf_Probe_T_jtag_main_Probe_Reserved_64 {
                    bits 32;
                    access rw;
                    hard_reset 'h0;
                }
            }
            register ccf_Probe_T_jtag_main_Probe_Reserved_65 @0x130 {
                bytes 4;
                field ccf_Probe_T_jtag_main_Probe_Reserved_65 {
                    bits 32;
                    access rw;
                    hard_reset 'h0;
                }
            }
            register ccf_Probe_T_jtag_main_Probe_Reserved_66 @0x134 {
                bytes 4;
                field ccf_Probe_T_jtag_main_Probe_Reserved_66 {
                    bits 32;
                    access rw;
                    hard_reset 'h0;
                }
            }
            register ccf_Probe_T_jtag_main_Probe_Counters_0_Src @0x138 {
                bytes 4;
                field INTEVENT @'h0 {
                    bits 5;
                    access rw;
                    hard_reset 'h0;
                    enum { OFF = 0, CYCLE = 1, IDLE = 2, XFER = 3, BUSY = 4, WAIT = 5, PKT = 6, LUT = 7, BYTE = 8, PRESS0 = 9, PRESS1 = 10, PRESS2 = 11, FILT0 = 12, FILT1 = 13, FILT2 = 14, FILT3 = 15, CHAIN = 16, LUT_BYTE_EN = 17, LUT_BYTE = 18, FILT_BYTE_EN = 19, FILT_BYTE = 20, PRESS3 = 21, PRESS4 = 22, PRESS5 = 23, PRESS6 = 24, RSV_0 = 25, RSV_1 = 26, RSV_2 = 27, RSV_3 = 28, RSV_4 = 29, RSV_5 = 30, RSV_6 = 31 };
                    doc {
                        Internal packet event
                    }
                }
                field EXTEVENT @'h5 {
                    access rw;
                    hard_reset 'h0;
                    doc {
                        When greater than 0, the entire register value is used to select an external hardware event source. The index of the external event is equal to {ExtEvent,IntEvent}.
                    }
                }
                doc {
                    Register CntSrc indicates the event source used to increment the counter. Unassigned values (non-existing Press level or ExtEvent index, or unimplemented Filter) are equivalent to OFF.
	Register CntSrc indicates the event source used to increment the counter. Unassigned values (non-existing Press level or ExtEvent index, or unimplemented Filter) are equivalent to OFF.
	
                }
            }
            register ccf_Probe_T_jtag_main_Probe_Counters_0_AlarmMode @0x13C {
                bytes 4;
                field COUNTERS_0_ALARMMODE @'h0 {
                    bits 2;
                    access rw;
                    hard_reset 'h0;
                    enum { OFF = 0, MIN = 1, MAX = 2, MIN_MAX = 3 };
                    doc {
                        Register AlarmMode is a 2-bit register that is present when parameter statisticsCounterAlarm is set to True. The register defines the statistics-alarm behavior of the counter.
                    }
                }
            }
            register ccf_Probe_T_jtag_main_Probe_Counters_0_Val @0x140 {
                bytes 4;
                field COUNTERS_0_VAL @'h0 {
                    bits 11;
                    access ro;
                    hard_reset 'h0;
                    doc {
                        Register Val is a read-only register that is always present. The register containsthe statistics counter value either pending StatAlarm output, or when statisticscollection is suspended subsequent to triggers or signal statSuspend.
                    }
                }
            }
            register ccf_Probe_T_jtag_main_Probe_Reserved_67 @0x144 {
                bytes 4;
                field ccf_Probe_T_jtag_main_Probe_Reserved_67 {
                    bits 32;
                    access rw;
                    hard_reset 'h0;
                }
            }
            register ccf_Probe_T_jtag_main_Probe_Reserved_68 @0x148 {
                bytes 4;
                field ccf_Probe_T_jtag_main_Probe_Reserved_68 {
                    bits 32;
                    access rw;
                    hard_reset 'h0;
                }
            }
            register ccf_Probe_T_jtag_main_Probe_Counters_1_Src @0x14C {
                bytes 4;
                field INTEVENT @'h0 {
                    bits 5;
                    access rw;
                    hard_reset 'h0;
                    enum { OFF = 0, CYCLE = 1, IDLE = 2, XFER = 3, BUSY = 4, WAIT = 5, PKT = 6, LUT = 7, BYTE = 8, PRESS0 = 9, PRESS1 = 10, PRESS2 = 11, FILT0 = 12, FILT1 = 13, FILT2 = 14, FILT3 = 15, CHAIN = 16, LUT_BYTE_EN = 17, LUT_BYTE = 18, FILT_BYTE_EN = 19, FILT_BYTE = 20, PRESS3 = 21, PRESS4 = 22, PRESS5 = 23, PRESS6 = 24, RSV_0 = 25, RSV_1 = 26, RSV_2 = 27, RSV_3 = 28, RSV_4 = 29, RSV_5 = 30, RSV_6 = 31 };
                    doc {
                        Internal packet event
                    }
                }
                field EXTEVENT @'h5 {
                    access rw;
                    hard_reset 'h0;
                    doc {
                        When greater than 0, the entire register value is used to select an external hardware event source. The index of the external event is equal to {ExtEvent,IntEvent}.
                    }
                }
                doc {
                    Register CntSrc indicates the event source used to increment the counter. Unassigned values (non-existing Press level or ExtEvent index, or unimplemented Filter) are equivalent to OFF.
	Register CntSrc indicates the event source used to increment the counter. Unassigned values (non-existing Press level or ExtEvent index, or unimplemented Filter) are equivalent to OFF.
	
                }
            }
            register ccf_Probe_T_jtag_main_Probe_Counters_1_AlarmMode @0x150 {
                bytes 4;
                field COUNTERS_1_ALARMMODE @'h0 {
                    bits 2;
                    access rw;
                    hard_reset 'h0;
                    enum { OFF = 0, MIN = 1, MAX = 2, MIN_MAX = 3 };
                    doc {
                        Register AlarmMode is a 2-bit register that is present when parameter statisticsCounterAlarm is set to True. The register defines the statistics-alarm behavior of the counter.
                    }
                }
            }
            register ccf_Probe_T_jtag_main_Probe_Counters_1_Val @0x154 {
                bytes 4;
                field COUNTERS_1_VAL @'h0 {
                    bits 11;
                    access ro;
                    hard_reset 'h0;
                    doc {
                        Register Val is a read-only register that is always present. The register containsthe statistics counter value either pending StatAlarm output, or when statisticscollection is suspended subsequent to triggers or signal statSuspend.
                    }
                }
            }
            register ccf_Probe_T_jtag_main_Probe_Reserved_69 @0x158 {
                bytes 4;
                field ccf_Probe_T_jtag_main_Probe_Reserved_69 {
                    bits 32;
                    access rw;
                    hard_reset 'h0;
                }
            }
            register ccf_Probe_T_jtag_main_Probe_Reserved_70 @0x15C {
                bytes 4;
                field ccf_Probe_T_jtag_main_Probe_Reserved_70 {
                    bits 32;
                    access rw;
                    hard_reset 'h0;
                }
            }
            register ccf_Probe_T_jtag_main_Probe_Reserved_71 @0x160 {
                bytes 4;
                field ccf_Probe_T_jtag_main_Probe_Reserved_71 {
                    bits 32;
                    access rw;
                    hard_reset 'h0;
                }
            }
            register ccf_Probe_T_jtag_main_Probe_Reserved_72 @0x164 {
                bytes 4;
                field ccf_Probe_T_jtag_main_Probe_Reserved_72 {
                    bits 32;
                    access rw;
                    hard_reset 'h0;
                }
            }
            register ccf_Probe_T_jtag_main_Probe_Reserved_73 @0x168 {
                bytes 4;
                field ccf_Probe_T_jtag_main_Probe_Reserved_73 {
                    bits 32;
                    access rw;
                    hard_reset 'h0;
                }
            }
            register ccf_Probe_T_jtag_main_Probe_Reserved_74 @0x16C {
                bytes 4;
                field ccf_Probe_T_jtag_main_Probe_Reserved_74 {
                    bits 32;
                    access rw;
                    hard_reset 'h0;
                }
            }
            register ccf_Probe_T_jtag_main_Probe_Reserved_75 @0x170 {
                bytes 4;
                field ccf_Probe_T_jtag_main_Probe_Reserved_75 {
                    bits 32;
                    access rw;
                    hard_reset 'h0;
                }
            }
            register ccf_Probe_T_jtag_main_Probe_Reserved_76 @0x174 {
                bytes 4;
                field ccf_Probe_T_jtag_main_Probe_Reserved_76 {
                    bits 32;
                    access rw;
                    hard_reset 'h0;
                }
            }
            register ccf_Probe_T_jtag_main_Probe_Reserved_77 @0x178 {
                bytes 4;
                field ccf_Probe_T_jtag_main_Probe_Reserved_77 {
                    bits 32;
                    access rw;
                    hard_reset 'h0;
                }
            }
            register ccf_Probe_T_jtag_main_Probe_Reserved_78 @0x17C {
                bytes 4;
                field ccf_Probe_T_jtag_main_Probe_Reserved_78 {
                    bits 32;
                    access rw;
                    hard_reset 'h0;
                }
            }
            register ccf_Probe_T_jtag_main_Probe_Reserved_79 @0x180 {
                bytes 4;
                field ccf_Probe_T_jtag_main_Probe_Reserved_79 {
                    bits 32;
                    access rw;
                    hard_reset 'h0;
                }
            }
            register ccf_Probe_T_jtag_main_Probe_Reserved_80 @0x184 {
                bytes 4;
                field ccf_Probe_T_jtag_main_Probe_Reserved_80 {
                    bits 32;
                    access rw;
                    hard_reset 'h0;
                }
            }
            register ccf_Probe_T_jtag_main_Probe_Reserved_81 @0x188 {
                bytes 4;
                field ccf_Probe_T_jtag_main_Probe_Reserved_81 {
                    bits 32;
                    access rw;
                    hard_reset 'h0;
                }
            }
            register ccf_Probe_T_jtag_main_Probe_Reserved_82 @0x18C {
                bytes 4;
                field ccf_Probe_T_jtag_main_Probe_Reserved_82 {
                    bits 32;
                    access rw;
                    hard_reset 'h0;
                }
            }
            register ccf_Probe_T_jtag_main_Probe_Reserved_83 @0x190 {
                bytes 4;
                field ccf_Probe_T_jtag_main_Probe_Reserved_83 {
                    bits 32;
                    access rw;
                    hard_reset 'h0;
                }
            }
            register ccf_Probe_T_jtag_main_Probe_Reserved_84 @0x194 {
                bytes 4;
                field ccf_Probe_T_jtag_main_Probe_Reserved_84 {
                    bits 32;
                    access rw;
                    hard_reset 'h0;
                }
            }
            register ccf_Probe_T_jtag_main_Probe_Reserved_85 @0x198 {
                bytes 4;
                field ccf_Probe_T_jtag_main_Probe_Reserved_85 {
                    bits 32;
                    access rw;
                    hard_reset 'h0;
                }
            }
            register ccf_Probe_T_jtag_main_Probe_Reserved_86 @0x19C {
                bytes 4;
                field ccf_Probe_T_jtag_main_Probe_Reserved_86 {
                    bits 32;
                    access rw;
                    hard_reset 'h0;
                }
            }
            register ccf_Probe_T_jtag_main_Probe_Reserved_87 @0x1A0 {
                bytes 4;
                field ccf_Probe_T_jtag_main_Probe_Reserved_87 {
                    bits 32;
                    access rw;
                    hard_reset 'h0;
                }
            }
            register ccf_Probe_T_jtag_main_Probe_Reserved_88 @0x1A4 {
                bytes 4;
                field ccf_Probe_T_jtag_main_Probe_Reserved_88 {
                    bits 32;
                    access rw;
                    hard_reset 'h0;
                }
            }
            register ccf_Probe_T_jtag_main_Probe_Reserved_89 @0x1A8 {
                bytes 4;
                field ccf_Probe_T_jtag_main_Probe_Reserved_89 {
                    bits 32;
                    access rw;
                    hard_reset 'h0;
                }
            }
            register ccf_Probe_T_jtag_main_Probe_Reserved_90 @0x1AC {
                bytes 4;
                field ccf_Probe_T_jtag_main_Probe_Reserved_90 {
                    bits 32;
                    access rw;
                    hard_reset 'h0;
                }
            }
            register ccf_Probe_T_jtag_main_Probe_Reserved_91 @0x1B0 {
                bytes 4;
                field ccf_Probe_T_jtag_main_Probe_Reserved_91 {
                    bits 32;
                    access rw;
                    hard_reset 'h0;
                }
            }
            register ccf_Probe_T_jtag_main_Probe_Reserved_92 @0x1B4 {
                bytes 4;
                field ccf_Probe_T_jtag_main_Probe_Reserved_92 {
                    bits 32;
                    access rw;
                    hard_reset 'h0;
                }
            }
            register ccf_Probe_T_jtag_main_Probe_Reserved_93 @0x1B8 {
                bytes 4;
                field ccf_Probe_T_jtag_main_Probe_Reserved_93 {
                    bits 32;
                    access rw;
                    hard_reset 'h0;
                }
            }
            register ccf_Probe_T_jtag_main_Probe_Reserved_94 @0x1BC {
                bytes 4;
                field ccf_Probe_T_jtag_main_Probe_Reserved_94 {
                    bits 32;
                    access rw;
                    hard_reset 'h0;
                }
            }
            register ccf_Probe_T_jtag_main_Probe_Reserved_95 @0x1C0 {
                bytes 4;
                field ccf_Probe_T_jtag_main_Probe_Reserved_95 {
                    bits 32;
                    access rw;
                    hard_reset 'h0;
                }
            }
            register ccf_Probe_T_jtag_main_Probe_Reserved_96 @0x1C4 {
                bytes 4;
                field ccf_Probe_T_jtag_main_Probe_Reserved_96 {
                    bits 32;
                    access rw;
                    hard_reset 'h0;
                }
            }
            register ccf_Probe_T_jtag_main_Probe_Reserved_97 @0x1C8 {
                bytes 4;
                field ccf_Probe_T_jtag_main_Probe_Reserved_97 {
                    bits 32;
                    access rw;
                    hard_reset 'h0;
                }
            }
            register ccf_Probe_T_jtag_main_Probe_Reserved_98 @0x1CC {
                bytes 4;
                field ccf_Probe_T_jtag_main_Probe_Reserved_98 {
                    bits 32;
                    access rw;
                    hard_reset 'h0;
                }
            }
            register ccf_Probe_T_jtag_main_Probe_Reserved_99 @0x1D0 {
                bytes 4;
                field ccf_Probe_T_jtag_main_Probe_Reserved_99 {
                    bits 32;
                    access rw;
                    hard_reset 'h0;
                }
            }
            register ccf_Probe_T_jtag_main_Probe_Reserved_100 @0x1D4 {
                bytes 4;
                field ccf_Probe_T_jtag_main_Probe_Reserved_100 {
                    bits 32;
                    access rw;
                    hard_reset 'h0;
                }
            }
            register ccf_Probe_T_jtag_main_Probe_Reserved_101 @0x1D8 {
                bytes 4;
                field ccf_Probe_T_jtag_main_Probe_Reserved_101 {
                    bits 32;
                    access rw;
                    hard_reset 'h0;
                }
            }
            register ccf_Probe_T_jtag_main_Probe_Reserved_102 @0x1DC {
                bytes 4;
                field ccf_Probe_T_jtag_main_Probe_Reserved_102 {
                    bits 32;
                    access rw;
                    hard_reset 'h0;
                }
            }
            register ccf_Probe_T_jtag_main_Probe_Reserved_103 @0x1E0 {
                bytes 4;
                field ccf_Probe_T_jtag_main_Probe_Reserved_103 {
                    bits 32;
                    access rw;
                    hard_reset 'h0;
                }
            }
            register ccf_Probe_T_jtag_main_Probe_Reserved_104 @0x1E4 {
                bytes 4;
                field ccf_Probe_T_jtag_main_Probe_Reserved_104 {
                    bits 32;
                    access rw;
                    hard_reset 'h0;
                }
            }
            register ccf_Probe_T_jtag_main_Probe_Reserved_105 @0x1E8 {
                bytes 4;
                field ccf_Probe_T_jtag_main_Probe_Reserved_105 {
                    bits 32;
                    access rw;
                    hard_reset 'h0;
                }
            }
            register ccf_Probe_T_jtag_main_Probe_Reserved_106 @0x1EC {
                bytes 4;
                field ccf_Probe_T_jtag_main_Probe_Reserved_106 {
                    bits 32;
                    access rw;
                    hard_reset 'h0;
                }
            }
            register ccf_Probe_T_jtag_main_Probe_Reserved_107 @0x1F0 {
                bytes 4;
                field ccf_Probe_T_jtag_main_Probe_Reserved_107 {
                    bits 32;
                    access rw;
                    hard_reset 'h0;
                }
            }
            register ccf_Probe_T_jtag_main_Probe_Reserved_108 @0x1F4 {
                bytes 4;
                field ccf_Probe_T_jtag_main_Probe_Reserved_108 {
                    bits 32;
                    access rw;
                    hard_reset 'h0;
                }
            }
            register ccf_Probe_T_jtag_main_Probe_Reserved_109 @0x1F8 {
                bytes 4;
                field ccf_Probe_T_jtag_main_Probe_Reserved_109 {
                    bits 32;
                    access rw;
                    hard_reset 'h0;
                }
            }
            register ccf_Probe_T_jtag_main_Probe_Reserved_110 @0x1FC {
                bytes 4;
                field ccf_Probe_T_jtag_main_Probe_Reserved_110 {
                    bits 32;
                    access rw;
                    hard_reset 'h0;
                }
            }
            register ccf_Probe_T_jtag_main_Probe_Reserved_111 @0x200 {
                bytes 4;
                field ccf_Probe_T_jtag_main_Probe_Reserved_111 {
                    bits 32;
                    access rw;
                    hard_reset 'h0;
                }
            }
            register ccf_Probe_T_jtag_main_Probe_Reserved_112 @0x204 {
                bytes 4;
                field ccf_Probe_T_jtag_main_Probe_Reserved_112 {
                    bits 32;
                    access rw;
                    hard_reset 'h0;
                }
            }
            register ccf_Probe_T_jtag_main_Probe_Reserved_113 @0x208 {
                bytes 4;
                field ccf_Probe_T_jtag_main_Probe_Reserved_113 {
                    bits 32;
                    access rw;
                    hard_reset 'h0;
                }
            }
            register ccf_Probe_T_jtag_main_Probe_Reserved_114 @0x20C {
                bytes 4;
                field ccf_Probe_T_jtag_main_Probe_Reserved_114 {
                    bits 32;
                    access rw;
                    hard_reset 'h0;
                }
            }
            register ccf_Probe_T_jtag_main_Probe_Reserved_115 @0x210 {
                bytes 4;
                field ccf_Probe_T_jtag_main_Probe_Reserved_115 {
                    bits 32;
                    access rw;
                    hard_reset 'h0;
                }
            }
            register ccf_Probe_T_jtag_main_Probe_Reserved_116 @0x214 {
                bytes 4;
                field ccf_Probe_T_jtag_main_Probe_Reserved_116 {
                    bits 32;
                    access rw;
                    hard_reset 'h0;
                }
            }
            register ccf_Probe_T_jtag_main_Probe_Reserved_117 @0x218 {
                bytes 4;
                field ccf_Probe_T_jtag_main_Probe_Reserved_117 {
                    bits 32;
                    access rw;
                    hard_reset 'h0;
                }
            }
            register ccf_Probe_T_jtag_main_Probe_Reserved_118 @0x21C {
                bytes 4;
                field ccf_Probe_T_jtag_main_Probe_Reserved_118 {
                    bits 32;
                    access rw;
                    hard_reset 'h0;
                }
            }
            register ccf_Probe_T_jtag_main_Probe_Reserved_119 @0x220 {
                bytes 4;
                field ccf_Probe_T_jtag_main_Probe_Reserved_119 {
                    bits 32;
                    access rw;
                    hard_reset 'h0;
                }
            }
            register ccf_Probe_T_jtag_main_Probe_Reserved_120 @0x224 {
                bytes 4;
                field ccf_Probe_T_jtag_main_Probe_Reserved_120 {
                    bits 32;
                    access rw;
                    hard_reset 'h0;
                }
            }
            register ccf_Probe_T_jtag_main_Probe_Reserved_121 @0x228 {
                bytes 4;
                field ccf_Probe_T_jtag_main_Probe_Reserved_121 {
                    bits 32;
                    access rw;
                    hard_reset 'h0;
                }
            }
            register ccf_Probe_T_jtag_main_Probe_Reserved_122 @0x22C {
                bytes 4;
                field ccf_Probe_T_jtag_main_Probe_Reserved_122 {
                    bits 32;
                    access rw;
                    hard_reset 'h0;
                }
            }
            register ccf_Probe_T_jtag_main_Probe_Reserved_123 @0x230 {
                bytes 4;
                field ccf_Probe_T_jtag_main_Probe_Reserved_123 {
                    bits 32;
                    access rw;
                    hard_reset 'h0;
                }
            }
            register ccf_Probe_T_jtag_main_Probe_Reserved_124 @0x234 {
                bytes 4;
                field ccf_Probe_T_jtag_main_Probe_Reserved_124 {
                    bits 32;
                    access rw;
                    hard_reset 'h0;
                }
            }
            register ccf_Probe_T_jtag_main_Probe_Reserved_125 @0x238 {
                bytes 4;
                field ccf_Probe_T_jtag_main_Probe_Reserved_125 {
                    bits 32;
                    access rw;
                    hard_reset 'h0;
                }
            }
            register ccf_Probe_T_jtag_main_Probe_Reserved_126 @0x23C {
                bytes 4;
                field ccf_Probe_T_jtag_main_Probe_Reserved_126 {
                    bits 32;
                    access rw;
                    hard_reset 'h0;
                }
            }
            register ccf_Probe_T_jtag_main_Probe_Reserved_127 @0x240 {
                bytes 4;
                field ccf_Probe_T_jtag_main_Probe_Reserved_127 {
                    bits 32;
                    access rw;
                    hard_reset 'h0;
                }
            }
            register ccf_Probe_T_jtag_main_Probe_Reserved_128 @0x244 {
                bytes 4;
                field ccf_Probe_T_jtag_main_Probe_Reserved_128 {
                    bits 32;
                    access rw;
                    hard_reset 'h0;
                }
            }
            register ccf_Probe_T_jtag_main_Probe_Reserved_129 @0x248 {
                bytes 4;
                field ccf_Probe_T_jtag_main_Probe_Reserved_129 {
                    bits 32;
                    access rw;
                    hard_reset 'h0;
                }
            }
            register ccf_Probe_T_jtag_main_Probe_Reserved_130 @0x24C {
                bytes 4;
                field ccf_Probe_T_jtag_main_Probe_Reserved_130 {
                    bits 32;
                    access rw;
                    hard_reset 'h0;
                }
            }
            register ccf_Probe_T_jtag_main_Probe_Reserved_131 @0x250 {
                bytes 4;
                field ccf_Probe_T_jtag_main_Probe_Reserved_131 {
                    bits 32;
                    access rw;
                    hard_reset 'h0;
                }
            }
            register ccf_Probe_T_jtag_main_Probe_Reserved_132 @0x254 {
                bytes 4;
                field ccf_Probe_T_jtag_main_Probe_Reserved_132 {
                    bits 32;
                    access rw;
                    hard_reset 'h0;
                }
            }
            register ccf_Probe_T_jtag_main_Probe_Reserved_133 @0x258 {
                bytes 4;
                field ccf_Probe_T_jtag_main_Probe_Reserved_133 {
                    bits 32;
                    access rw;
                    hard_reset 'h0;
                }
            }
            register ccf_Probe_T_jtag_main_Probe_Reserved_134 @0x25C {
                bytes 4;
                field ccf_Probe_T_jtag_main_Probe_Reserved_134 {
                    bits 32;
                    access rw;
                    hard_reset 'h0;
                }
            }
            register ccf_Probe_T_jtag_main_Probe_Reserved_135 @0x260 {
                bytes 4;
                field ccf_Probe_T_jtag_main_Probe_Reserved_135 {
                    bits 32;
                    access rw;
                    hard_reset 'h0;
                }
            }
            register ccf_Probe_T_jtag_main_Probe_Reserved_136 @0x264 {
                bytes 4;
                field ccf_Probe_T_jtag_main_Probe_Reserved_136 {
                    bits 32;
                    access rw;
                    hard_reset 'h0;
                }
            }
            register ccf_Probe_T_jtag_main_Probe_Reserved_137 @0x268 {
                bytes 4;
                field ccf_Probe_T_jtag_main_Probe_Reserved_137 {
                    bits 32;
                    access rw;
                    hard_reset 'h0;
                }
            }
            register ccf_Probe_T_jtag_main_Probe_Reserved_138 @0x26C {
                bytes 4;
                field ccf_Probe_T_jtag_main_Probe_Reserved_138 {
                    bits 32;
                    access rw;
                    hard_reset 'h0;
                }
            }
            register ccf_Probe_T_jtag_main_Probe_Reserved_139 @0x270 {
                bytes 4;
                field ccf_Probe_T_jtag_main_Probe_Reserved_139 {
                    bits 32;
                    access rw;
                    hard_reset 'h0;
                }
            }
            register ccf_Probe_T_jtag_main_Probe_Reserved_140 @0x274 {
                bytes 4;
                field ccf_Probe_T_jtag_main_Probe_Reserved_140 {
                    bits 32;
                    access rw;
                    hard_reset 'h0;
                }
            }
            register ccf_Probe_T_jtag_main_Probe_Reserved_141 @0x278 {
                bytes 4;
                field ccf_Probe_T_jtag_main_Probe_Reserved_141 {
                    bits 32;
                    access rw;
                    hard_reset 'h0;
                }
            }
            register ccf_Probe_T_jtag_main_Probe_Reserved_142 @0x27C {
                bytes 4;
                field ccf_Probe_T_jtag_main_Probe_Reserved_142 {
                    bits 32;
                    access rw;
                    hard_reset 'h0;
                }
            }
            register ccf_Probe_T_jtag_main_Probe_Reserved_143 @0x280 {
                bytes 4;
                field ccf_Probe_T_jtag_main_Probe_Reserved_143 {
                    bits 32;
                    access rw;
                    hard_reset 'h0;
                }
            }
            register ccf_Probe_T_jtag_main_Probe_Reserved_144 @0x284 {
                bytes 4;
                field ccf_Probe_T_jtag_main_Probe_Reserved_144 {
                    bits 32;
                    access rw;
                    hard_reset 'h0;
                }
            }
            register ccf_Probe_T_jtag_main_Probe_Reserved_145 @0x288 {
                bytes 4;
                field ccf_Probe_T_jtag_main_Probe_Reserved_145 {
                    bits 32;
                    access rw;
                    hard_reset 'h0;
                }
            }
            register ccf_Probe_T_jtag_main_Probe_Reserved_146 @0x28C {
                bytes 4;
                field ccf_Probe_T_jtag_main_Probe_Reserved_146 {
                    bits 32;
                    access rw;
                    hard_reset 'h0;
                }
            }
            register ccf_Probe_T_jtag_main_Probe_Reserved_147 @0x290 {
                bytes 4;
                field ccf_Probe_T_jtag_main_Probe_Reserved_147 {
                    bits 32;
                    access rw;
                    hard_reset 'h0;
                }
            }
            register ccf_Probe_T_jtag_main_Probe_Reserved_148 @0x294 {
                bytes 4;
                field ccf_Probe_T_jtag_main_Probe_Reserved_148 {
                    bits 32;
                    access rw;
                    hard_reset 'h0;
                }
            }
            register ccf_Probe_T_jtag_main_Probe_Reserved_149 @0x298 {
                bytes 4;
                field ccf_Probe_T_jtag_main_Probe_Reserved_149 {
                    bits 32;
                    access rw;
                    hard_reset 'h0;
                }
            }
            register ccf_Probe_T_jtag_main_Probe_Reserved_150 @0x29C {
                bytes 4;
                field ccf_Probe_T_jtag_main_Probe_Reserved_150 {
                    bits 32;
                    access rw;
                    hard_reset 'h0;
                }
            }
            register ccf_Probe_T_jtag_main_Probe_Reserved_151 @0x2A0 {
                bytes 4;
                field ccf_Probe_T_jtag_main_Probe_Reserved_151 {
                    bits 32;
                    access rw;
                    hard_reset 'h0;
                }
            }
            register ccf_Probe_T_jtag_main_Probe_Reserved_152 @0x2A4 {
                bytes 4;
                field ccf_Probe_T_jtag_main_Probe_Reserved_152 {
                    bits 32;
                    access rw;
                    hard_reset 'h0;
                }
            }
            register ccf_Probe_T_jtag_main_Probe_Reserved_153 @0x2A8 {
                bytes 4;
                field ccf_Probe_T_jtag_main_Probe_Reserved_153 {
                    bits 32;
                    access rw;
                    hard_reset 'h0;
                }
            }
            register ccf_Probe_T_jtag_main_Probe_Reserved_154 @0x2AC {
                bytes 4;
                field ccf_Probe_T_jtag_main_Probe_Reserved_154 {
                    bits 32;
                    access rw;
                    hard_reset 'h0;
                }
            }
            register ccf_Probe_T_jtag_main_Probe_Reserved_155 @0x2B0 {
                bytes 4;
                field ccf_Probe_T_jtag_main_Probe_Reserved_155 {
                    bits 32;
                    access rw;
                    hard_reset 'h0;
                }
            }
            register ccf_Probe_T_jtag_main_Probe_Reserved_156 @0x2B4 {
                bytes 4;
                field ccf_Probe_T_jtag_main_Probe_Reserved_156 {
                    bits 32;
                    access rw;
                    hard_reset 'h0;
                }
            }
            register ccf_Probe_T_jtag_main_Probe_Reserved_157 @0x2B8 {
                bytes 4;
                field ccf_Probe_T_jtag_main_Probe_Reserved_157 {
                    bits 32;
                    access rw;
                    hard_reset 'h0;
                }
            }
            register ccf_Probe_T_jtag_main_Probe_Reserved_158 @0x2BC {
                bytes 4;
                field ccf_Probe_T_jtag_main_Probe_Reserved_158 {
                    bits 32;
                    access rw;
                    hard_reset 'h0;
                }
            }
            register ccf_Probe_T_jtag_main_Probe_Reserved_159 @0x2C0 {
                bytes 4;
                field ccf_Probe_T_jtag_main_Probe_Reserved_159 {
                    bits 32;
                    access rw;
                    hard_reset 'h0;
                }
            }
            register ccf_Probe_T_jtag_main_Probe_Reserved_160 @0x2C4 {
                bytes 4;
                field ccf_Probe_T_jtag_main_Probe_Reserved_160 {
                    bits 32;
                    access rw;
                    hard_reset 'h0;
                }
            }
            register ccf_Probe_T_jtag_main_Probe_Reserved_161 @0x2C8 {
                bytes 4;
                field ccf_Probe_T_jtag_main_Probe_Reserved_161 {
                    bits 32;
                    access rw;
                    hard_reset 'h0;
                }
            }
            register ccf_Probe_T_jtag_main_Probe_Reserved_162 @0x2CC {
                bytes 4;
                field ccf_Probe_T_jtag_main_Probe_Reserved_162 {
                    bits 32;
                    access rw;
                    hard_reset 'h0;
                }
            }
            register ccf_Probe_T_jtag_main_Probe_Reserved_163 @0x2D0 {
                bytes 4;
                field ccf_Probe_T_jtag_main_Probe_Reserved_163 {
                    bits 32;
                    access rw;
                    hard_reset 'h0;
                }
            }
            register ccf_Probe_T_jtag_main_Probe_Reserved_164 @0x2D4 {
                bytes 4;
                field ccf_Probe_T_jtag_main_Probe_Reserved_164 {
                    bits 32;
                    access rw;
                    hard_reset 'h0;
                }
            }
            register ccf_Probe_T_jtag_main_Probe_Reserved_165 @0x2D8 {
                bytes 4;
                field ccf_Probe_T_jtag_main_Probe_Reserved_165 {
                    bits 32;
                    access rw;
                    hard_reset 'h0;
                }
            }
            register ccf_Probe_T_jtag_main_Probe_Reserved_166 @0x2DC {
                bytes 4;
                field ccf_Probe_T_jtag_main_Probe_Reserved_166 {
                    bits 32;
                    access rw;
                    hard_reset 'h0;
                }
            }
            register ccf_Probe_T_jtag_main_Probe_Reserved_167 @0x2E0 {
                bytes 4;
                field ccf_Probe_T_jtag_main_Probe_Reserved_167 {
                    bits 32;
                    access rw;
                    hard_reset 'h0;
                }
            }
            register ccf_Probe_T_jtag_main_Probe_Reserved_168 @0x2E4 {
                bytes 4;
                field ccf_Probe_T_jtag_main_Probe_Reserved_168 {
                    bits 32;
                    access rw;
                    hard_reset 'h0;
                }
            }
            register ccf_Probe_T_jtag_main_Probe_Reserved_169 @0x2E8 {
                bytes 4;
                field ccf_Probe_T_jtag_main_Probe_Reserved_169 {
                    bits 32;
                    access rw;
                    hard_reset 'h0;
                }
            }
            register ccf_Probe_T_jtag_main_Probe_Reserved_170 @0x2EC {
                bytes 4;
                field ccf_Probe_T_jtag_main_Probe_Reserved_170 {
                    bits 32;
                    access rw;
                    hard_reset 'h0;
                }
            }
            register ccf_Probe_T_jtag_main_Probe_Reserved_171 @0x2F0 {
                bytes 4;
                field ccf_Probe_T_jtag_main_Probe_Reserved_171 {
                    bits 32;
                    access rw;
                    hard_reset 'h0;
                }
            }
            register ccf_Probe_T_jtag_main_Probe_Reserved_172 @0x2F4 {
                bytes 4;
                field ccf_Probe_T_jtag_main_Probe_Reserved_172 {
                    bits 32;
                    access rw;
                    hard_reset 'h0;
                }
            }
            register ccf_Probe_T_jtag_main_Probe_Reserved_173 @0x2F8 {
                bytes 4;
                field ccf_Probe_T_jtag_main_Probe_Reserved_173 {
                    bits 32;
                    access rw;
                    hard_reset 'h0;
                }
            }
            register ccf_Probe_T_jtag_main_Probe_Reserved_174 @0x2FC {
                bytes 4;
                field ccf_Probe_T_jtag_main_Probe_Reserved_174 {
                    bits 32;
                    access rw;
                    hard_reset 'h0;
                }
            }
            register ccf_Probe_T_jtag_main_Probe_Reserved_175 @0x300 {
                bytes 4;
                field ccf_Probe_T_jtag_main_Probe_Reserved_175 {
                    bits 32;
                    access rw;
                    hard_reset 'h0;
                }
            }
            register ccf_Probe_T_jtag_main_Probe_Reserved_176 @0x304 {
                bytes 4;
                field ccf_Probe_T_jtag_main_Probe_Reserved_176 {
                    bits 32;
                    access rw;
                    hard_reset 'h0;
                }
            }
            register ccf_Probe_T_jtag_main_Probe_Reserved_177 @0x308 {
                bytes 4;
                field ccf_Probe_T_jtag_main_Probe_Reserved_177 {
                    bits 32;
                    access rw;
                    hard_reset 'h0;
                }
            }
            register ccf_Probe_T_jtag_main_Probe_Reserved_178 @0x30C {
                bytes 4;
                field ccf_Probe_T_jtag_main_Probe_Reserved_178 {
                    bits 32;
                    access rw;
                    hard_reset 'h0;
                }
            }
            register ccf_Probe_T_jtag_main_Probe_Reserved_179 @0x310 {
                bytes 4;
                field ccf_Probe_T_jtag_main_Probe_Reserved_179 {
                    bits 32;
                    access rw;
                    hard_reset 'h0;
                }
            }
            register ccf_Probe_T_jtag_main_Probe_Reserved_180 @0x314 {
                bytes 4;
                field ccf_Probe_T_jtag_main_Probe_Reserved_180 {
                    bits 32;
                    access rw;
                    hard_reset 'h0;
                }
            }
            register ccf_Probe_T_jtag_main_Probe_Reserved_181 @0x318 {
                bytes 4;
                field ccf_Probe_T_jtag_main_Probe_Reserved_181 {
                    bits 32;
                    access rw;
                    hard_reset 'h0;
                }
            }
            register ccf_Probe_T_jtag_main_Probe_Reserved_182 @0x31C {
                bytes 4;
                field ccf_Probe_T_jtag_main_Probe_Reserved_182 {
                    bits 32;
                    access rw;
                    hard_reset 'h0;
                }
            }
            register ccf_Probe_T_jtag_main_Probe_Reserved_183 @0x320 {
                bytes 4;
                field ccf_Probe_T_jtag_main_Probe_Reserved_183 {
                    bits 32;
                    access rw;
                    hard_reset 'h0;
                }
            }
            register ccf_Probe_T_jtag_main_Probe_Reserved_184 @0x324 {
                bytes 4;
                field ccf_Probe_T_jtag_main_Probe_Reserved_184 {
                    bits 32;
                    access rw;
                    hard_reset 'h0;
                }
            }
            register ccf_Probe_T_jtag_main_Probe_Reserved_185 @0x328 {
                bytes 4;
                field ccf_Probe_T_jtag_main_Probe_Reserved_185 {
                    bits 32;
                    access rw;
                    hard_reset 'h0;
                }
            }
            register ccf_Probe_T_jtag_main_Probe_Reserved_186 @0x32C {
                bytes 4;
                field ccf_Probe_T_jtag_main_Probe_Reserved_186 {
                    bits 32;
                    access rw;
                    hard_reset 'h0;
                }
            }
            register ccf_Probe_T_jtag_main_Probe_Reserved_187 @0x330 {
                bytes 4;
                field ccf_Probe_T_jtag_main_Probe_Reserved_187 {
                    bits 32;
                    access rw;
                    hard_reset 'h0;
                }
            }
            register ccf_Probe_T_jtag_main_Probe_Reserved_188 @0x334 {
                bytes 4;
                field ccf_Probe_T_jtag_main_Probe_Reserved_188 {
                    bits 32;
                    access rw;
                    hard_reset 'h0;
                }
            }
            register ccf_Probe_T_jtag_main_Probe_Reserved_189 @0x338 {
                bytes 4;
                field ccf_Probe_T_jtag_main_Probe_Reserved_189 {
                    bits 32;
                    access rw;
                    hard_reset 'h0;
                }
            }
            register ccf_Probe_T_jtag_main_Probe_Reserved_190 @0x33C {
                bytes 4;
                field ccf_Probe_T_jtag_main_Probe_Reserved_190 {
                    bits 32;
                    access rw;
                    hard_reset 'h0;
                }
            }
            register ccf_Probe_T_jtag_main_Probe_Reserved_191 @0x340 {
                bytes 4;
                field ccf_Probe_T_jtag_main_Probe_Reserved_191 {
                    bits 32;
                    access rw;
                    hard_reset 'h0;
                }
            }
            register ccf_Probe_T_jtag_main_Probe_Reserved_192 @0x344 {
                bytes 4;
                field ccf_Probe_T_jtag_main_Probe_Reserved_192 {
                    bits 32;
                    access rw;
                    hard_reset 'h0;
                }
            }
            register ccf_Probe_T_jtag_main_Probe_Reserved_193 @0x348 {
                bytes 4;
                field ccf_Probe_T_jtag_main_Probe_Reserved_193 {
                    bits 32;
                    access rw;
                    hard_reset 'h0;
                }
            }
            register ccf_Probe_T_jtag_main_Probe_Reserved_194 @0x34C {
                bytes 4;
                field ccf_Probe_T_jtag_main_Probe_Reserved_194 {
                    bits 32;
                    access rw;
                    hard_reset 'h0;
                }
            }
            register ccf_Probe_T_jtag_main_Probe_Reserved_195 @0x350 {
                bytes 4;
                field ccf_Probe_T_jtag_main_Probe_Reserved_195 {
                    bits 32;
                    access rw;
                    hard_reset 'h0;
                }
            }
            register ccf_Probe_T_jtag_main_Probe_Reserved_196 @0x354 {
                bytes 4;
                field ccf_Probe_T_jtag_main_Probe_Reserved_196 {
                    bits 32;
                    access rw;
                    hard_reset 'h0;
                }
            }
            register ccf_Probe_T_jtag_main_Probe_Reserved_197 @0x358 {
                bytes 4;
                field ccf_Probe_T_jtag_main_Probe_Reserved_197 {
                    bits 32;
                    access rw;
                    hard_reset 'h0;
                }
            }
            register ccf_Probe_T_jtag_main_Probe_Reserved_198 @0x35C {
                bytes 4;
                field ccf_Probe_T_jtag_main_Probe_Reserved_198 {
                    bits 32;
                    access rw;
                    hard_reset 'h0;
                }
            }
            register ccf_Probe_T_jtag_main_Probe_Reserved_199 @0x360 {
                bytes 4;
                field ccf_Probe_T_jtag_main_Probe_Reserved_199 {
                    bits 32;
                    access rw;
                    hard_reset 'h0;
                }
            }
            register ccf_Probe_T_jtag_main_Probe_Reserved_200 @0x364 {
                bytes 4;
                field ccf_Probe_T_jtag_main_Probe_Reserved_200 {
                    bits 32;
                    access rw;
                    hard_reset 'h0;
                }
            }
            register ccf_Probe_T_jtag_main_Probe_Reserved_201 @0x368 {
                bytes 4;
                field ccf_Probe_T_jtag_main_Probe_Reserved_201 {
                    bits 32;
                    access rw;
                    hard_reset 'h0;
                }
            }
            register ccf_Probe_T_jtag_main_Probe_Reserved_202 @0x36C {
                bytes 4;
                field ccf_Probe_T_jtag_main_Probe_Reserved_202 {
                    bits 32;
                    access rw;
                    hard_reset 'h0;
                }
            }
            register ccf_Probe_T_jtag_main_Probe_Reserved_203 @0x370 {
                bytes 4;
                field ccf_Probe_T_jtag_main_Probe_Reserved_203 {
                    bits 32;
                    access rw;
                    hard_reset 'h0;
                }
            }
            register ccf_Probe_T_jtag_main_Probe_Reserved_204 @0x374 {
                bytes 4;
                field ccf_Probe_T_jtag_main_Probe_Reserved_204 {
                    bits 32;
                    access rw;
                    hard_reset 'h0;
                }
            }
            register ccf_Probe_T_jtag_main_Probe_Reserved_205 @0x378 {
                bytes 4;
                field ccf_Probe_T_jtag_main_Probe_Reserved_205 {
                    bits 32;
                    access rw;
                    hard_reset 'h0;
                }
            }
            register ccf_Probe_T_jtag_main_Probe_Reserved_206 @0x37C {
                bytes 4;
                field ccf_Probe_T_jtag_main_Probe_Reserved_206 {
                    bits 32;
                    access rw;
                    hard_reset 'h0;
                }
            }
            register ccf_Probe_T_jtag_main_Probe_Reserved_207 @0x380 {
                bytes 4;
                field ccf_Probe_T_jtag_main_Probe_Reserved_207 {
                    bits 32;
                    access rw;
                    hard_reset 'h0;
                }
            }
            register ccf_Probe_T_jtag_main_Probe_Reserved_208 @0x384 {
                bytes 4;
                field ccf_Probe_T_jtag_main_Probe_Reserved_208 {
                    bits 32;
                    access rw;
                    hard_reset 'h0;
                }
            }
            register ccf_Probe_T_jtag_main_Probe_Reserved_209 @0x388 {
                bytes 4;
                field ccf_Probe_T_jtag_main_Probe_Reserved_209 {
                    bits 32;
                    access rw;
                    hard_reset 'h0;
                }
            }
            register ccf_Probe_T_jtag_main_Probe_Reserved_210 @0x38C {
                bytes 4;
                field ccf_Probe_T_jtag_main_Probe_Reserved_210 {
                    bits 32;
                    access rw;
                    hard_reset 'h0;
                }
            }
            register ccf_Probe_T_jtag_main_Probe_Reserved_211 @0x390 {
                bytes 4;
                field ccf_Probe_T_jtag_main_Probe_Reserved_211 {
                    bits 32;
                    access rw;
                    hard_reset 'h0;
                }
            }
            register ccf_Probe_T_jtag_main_Probe_Reserved_212 @0x394 {
                bytes 4;
                field ccf_Probe_T_jtag_main_Probe_Reserved_212 {
                    bits 32;
                    access rw;
                    hard_reset 'h0;
                }
            }
            register ccf_Probe_T_jtag_main_Probe_Reserved_213 @0x398 {
                bytes 4;
                field ccf_Probe_T_jtag_main_Probe_Reserved_213 {
                    bits 32;
                    access rw;
                    hard_reset 'h0;
                }
            }
            register ccf_Probe_T_jtag_main_Probe_Reserved_214 @0x39C {
                bytes 4;
                field ccf_Probe_T_jtag_main_Probe_Reserved_214 {
                    bits 32;
                    access rw;
                    hard_reset 'h0;
                }
            }
            register ccf_Probe_T_jtag_main_Probe_Reserved_215 @0x3A0 {
                bytes 4;
                field ccf_Probe_T_jtag_main_Probe_Reserved_215 {
                    bits 32;
                    access rw;
                    hard_reset 'h0;
                }
            }
            register ccf_Probe_T_jtag_main_Probe_Reserved_216 @0x3A4 {
                bytes 4;
                field ccf_Probe_T_jtag_main_Probe_Reserved_216 {
                    bits 32;
                    access rw;
                    hard_reset 'h0;
                }
            }
            register ccf_Probe_T_jtag_main_Probe_Reserved_217 @0x3A8 {
                bytes 4;
                field ccf_Probe_T_jtag_main_Probe_Reserved_217 {
                    bits 32;
                    access rw;
                    hard_reset 'h0;
                }
            }
            register ccf_Probe_T_jtag_main_Probe_Reserved_218 @0x3AC {
                bytes 4;
                field ccf_Probe_T_jtag_main_Probe_Reserved_218 {
                    bits 32;
                    access rw;
                    hard_reset 'h0;
                }
            }
            register ccf_Probe_T_jtag_main_Probe_Reserved_219 @0x3B0 {
                bytes 4;
                field ccf_Probe_T_jtag_main_Probe_Reserved_219 {
                    bits 32;
                    access rw;
                    hard_reset 'h0;
                }
            }
            register ccf_Probe_T_jtag_main_Probe_Reserved_220 @0x3B4 {
                bytes 4;
                field ccf_Probe_T_jtag_main_Probe_Reserved_220 {
                    bits 32;
                    access rw;
                    hard_reset 'h0;
                }
            }
            register ccf_Probe_T_jtag_main_Probe_Reserved_221 @0x3B8 {
                bytes 4;
                field ccf_Probe_T_jtag_main_Probe_Reserved_221 {
                    bits 32;
                    access rw;
                    hard_reset 'h0;
                }
            }
            register ccf_Probe_T_jtag_main_Probe_Reserved_222 @0x3BC {
                bytes 4;
                field ccf_Probe_T_jtag_main_Probe_Reserved_222 {
                    bits 32;
                    access rw;
                    hard_reset 'h0;
                }
            }
            register ccf_Probe_T_jtag_main_Probe_Reserved_223 @0x3C0 {
                bytes 4;
                field ccf_Probe_T_jtag_main_Probe_Reserved_223 {
                    bits 32;
                    access rw;
                    hard_reset 'h0;
                }
            }
            register ccf_Probe_T_jtag_main_Probe_Reserved_224 @0x3C4 {
                bytes 4;
                field ccf_Probe_T_jtag_main_Probe_Reserved_224 {
                    bits 32;
                    access rw;
                    hard_reset 'h0;
                }
            }
            register ccf_Probe_T_jtag_main_Probe_Reserved_225 @0x3C8 {
                bytes 4;
                field ccf_Probe_T_jtag_main_Probe_Reserved_225 {
                    bits 32;
                    access rw;
                    hard_reset 'h0;
                }
            }
            register ccf_Probe_T_jtag_main_Probe_Reserved_226 @0x3CC {
                bytes 4;
                field ccf_Probe_T_jtag_main_Probe_Reserved_226 {
                    bits 32;
                    access rw;
                    hard_reset 'h0;
                }
            }
            register ccf_Probe_T_jtag_main_Probe_Reserved_227 @0x3D0 {
                bytes 4;
                field ccf_Probe_T_jtag_main_Probe_Reserved_227 {
                    bits 32;
                    access rw;
                    hard_reset 'h0;
                }
            }
            register ccf_Probe_T_jtag_main_Probe_Reserved_228 @0x3D4 {
                bytes 4;
                field ccf_Probe_T_jtag_main_Probe_Reserved_228 {
                    bits 32;
                    access rw;
                    hard_reset 'h0;
                }
            }
            register ccf_Probe_T_jtag_main_Probe_Reserved_229 @0x3D8 {
                bytes 4;
                field ccf_Probe_T_jtag_main_Probe_Reserved_229 {
                    bits 32;
                    access rw;
                    hard_reset 'h0;
                }
            }
            register ccf_Probe_T_jtag_main_Probe_Reserved_230 @0x3DC {
                bytes 4;
                field ccf_Probe_T_jtag_main_Probe_Reserved_230 {
                    bits 32;
                    access rw;
                    hard_reset 'h0;
                }
            }
            register ccf_Probe_T_jtag_main_Probe_Reserved_231 @0x3E0 {
                bytes 4;
                field ccf_Probe_T_jtag_main_Probe_Reserved_231 {
                    bits 32;
                    access rw;
                    hard_reset 'h0;
                }
            }
            register ccf_Probe_T_jtag_main_Probe_Reserved_232 @0x3E4 {
                bytes 4;
                field ccf_Probe_T_jtag_main_Probe_Reserved_232 {
                    bits 32;
                    access rw;
                    hard_reset 'h0;
                }
            }
            register ccf_Probe_T_jtag_main_Probe_Reserved_233 @0x3E8 {
                bytes 4;
                field ccf_Probe_T_jtag_main_Probe_Reserved_233 {
                    bits 32;
                    access rw;
                    hard_reset 'h0;
                }
            }
            register ccf_Probe_T_jtag_main_Probe_Reserved_234 @0x3EC {
                bytes 4;
                field ccf_Probe_T_jtag_main_Probe_Reserved_234 {
                    bits 32;
                    access rw;
                    hard_reset 'h0;
                }
            }
            register ccf_Probe_T_jtag_main_Probe_Reserved_235 @0x3F0 {
                bytes 4;
                field ccf_Probe_T_jtag_main_Probe_Reserved_235 {
                    bits 32;
                    access rw;
                    hard_reset 'h0;
                }
            }
            register ccf_Probe_T_jtag_main_Probe_Reserved_236 @0x3F4 {
                bytes 4;
                field ccf_Probe_T_jtag_main_Probe_Reserved_236 {
                    bits 32;
                    access rw;
                    hard_reset 'h0;
                }
            }
            register ccf_Probe_T_jtag_main_Probe_Reserved_237 @0x3F8 {
                bytes 4;
                field ccf_Probe_T_jtag_main_Probe_Reserved_237 {
                    bits 32;
                    access rw;
                    hard_reset 'h0;
                }
            }
            register ccf_Probe_T_jtag_main_Probe_Reserved_238 @0x3FC {
                bytes 4;
                field ccf_Probe_T_jtag_main_Probe_Reserved_238 {
                    bits 32;
                    access rw;
                    hard_reset 'h0;
                }
            }
        }
        block ecf_ccf_axi_ccf_Probe_T_sip0_main_Probe @0xD9000 {
            bytes 4;
            register ccf_Probe_T_sip0_main_Probe_Id_CoreId @0x0 {
                bytes 4;
                field CORETYPEID @'h0 {
                    bits 8;
                    access ro;
                    hard_reset 'h6;
                    doc {
                        Field identifying the type of IP.
                    }
                }
                field CORECHECKSUM @'h8 {
                    bits 24;
                    access ro;
                    hard_reset 'hc10d17;
                    doc {
                        Field containing a checksum of the parameters of the IP.
                    }
                }
            }
            register ccf_Probe_T_sip0_main_Probe_Id_RevisionId @0x4 {
                bytes 4;
                field USERID @'h0 {
                    bits 8;
                    access ro;
                    hard_reset 'h0;
                    doc {
                        Field containing a user defined value, not used anywhere inside the IP itself.
                    }
                }
                field FLEXNOCID @'h8 {
                    bits 24;
                    access ro;
                    hard_reset 'h84f8c6;
                    doc {
                        Field containing the build revision of the software used to generate the IP HDL code.
                    }
                }
            }
            register ccf_Probe_T_sip0_main_Probe_MainCtl @0x8 {
                bytes 4;
                field ERREN @'h0 {
                    access rw;
                    hard_reset 'h0;
                    doc {
                        Register field ErrEn enables the probe to send on the ObsTx output any packet with Error status, independently of filtering mechanisms, thus constituting a simple supplementary global filter.
                    }
                }
                field TRACEEN @'h1 {
                    access ro;
                    hard_reset 'h0;
                    doc {
                        Register field TraceEn enables the probe to send filtered packets (Trace) on the ObsTx observation output.
                    }
                }
                field PAYLOADEN @'h2 {
                    access rw;
                    hard_reset 'h0;
                    doc {
                        Register field PayloadEn, when set to 1, enables traces to contain headers and payload. When set ot 0, only headers are reported.
                    }
                }
                field STATEN @'h3 {
                    access rw;
                    hard_reset 'h0;
                    doc {
                        When set to 1, register field StatEn enables statistics profiling. The probe sendS statistics results to the output for signal ObsTx. All statistics counters are cleared when the StatEn bit goes from 0 to 1. When set to 0, counters are disabled.
                    }
                }
                field ALARMEN @'h4 {
                    access rw;
                    hard_reset 'h0;
                    doc {
                        When set, register field AlarmEn enables the probe to collect alarm-related information. When the register field bit is null, both TraceAlarm and StatAlarm outputs are driven to 0.
                    }
                }
                field STATCONDDUMP @'h5 {
                    access rw;
                    hard_reset 'h0;
                    doc {
                        When set, register field StatCondDump enables the dump of a statistics frame to the range of counter values set for registers StatAlarmMin, StatAlarmMax, and AlarmMode. This field also renders register StatAlarmStatus inoperative. When parameter statisticsCounterAlarm is set to False, the StatCondDump register bit is reserved.
                    }
                }
                field INTRUSIVEMODE @'h6 {
                    access ro;
                    hard_reset 'h0;
                    doc {
                        When set to 1, register field IntrusiveMode enables trace operation in Intrusive flow-control mode. When set to 0, the register  enables trace operation in Overflow flow-control mode
                    }
                }
                field FILTBYTEALWAYSCHAINABLEEN @'h7 {
                    access rw;
                    hard_reset 'h0;
                    doc {
                        When set to 0, filters are mapped to all statistic counters when counting bytes or enabled bytes. Therefore, only filter events mapped to even counters can be counted using a pair of chained counters.When set to 1, filters are mapped only to even statistic counters when counting bytes or enabled bytes. Thus events from any filter can be counted using a pair of chained counters.
                    }
                }
                doc {
                    Register MainCtl contains probe global control bits. The register has seven bit fields:Register MainCtl contains probe global control bits. The register has seven bit fields:
                }
            }
            register ccf_Probe_T_sip0_main_Probe_CfgCtl @0xC {
                bytes 4;
                field GLOBALEN @'h0 {
                    access rw;
                    hard_reset 'h0;
                }
                field ACTIVE @'h1 {
                    access ro;
                    hard_reset 'h0;
                }
            }
            register ccf_Probe_T_sip0_main_Probe_Reserved_00 @0x10 {
                bytes 4;
                field ccf_Probe_T_sip0_main_Probe_Reserved_00 {
                    bits 32;
                    access rw;
                    hard_reset 'h0;
                }
            }
            register ccf_Probe_T_sip0_main_Probe_Reserved_01 @0x14 {
                bytes 4;
                field ccf_Probe_T_sip0_main_Probe_Reserved_01 {
                    bits 32;
                    access rw;
                    hard_reset 'h0;
                }
            }
            register ccf_Probe_T_sip0_main_Probe_Reserved_02 @0x18 {
                bytes 4;
                field ccf_Probe_T_sip0_main_Probe_Reserved_02 {
                    bits 32;
                    access rw;
                    hard_reset 'h0;
                }
            }
            register ccf_Probe_T_sip0_main_Probe_Reserved_03 @0x1C {
                bytes 4;
                field ccf_Probe_T_sip0_main_Probe_Reserved_03 {
                    bits 32;
                    access rw;
                    hard_reset 'h0;
                }
            }
            register ccf_Probe_T_sip0_main_Probe_Reserved_04 @0x20 {
                bytes 4;
                field ccf_Probe_T_sip0_main_Probe_Reserved_04 {
                    bits 32;
                    access rw;
                    hard_reset 'h0;
                }
            }
            register ccf_Probe_T_sip0_main_Probe_StatPeriod @0x24 {
                bytes 4;
                field STATPERIOD @'h0 {
                    bits 5;
                    access rw;
                    hard_reset 'h0;
                    doc {
                        Register StatPeriod is a 5-bit register that sets a period, within a range of 2 cycles to 2 gigacycles, during which statistics are collected before being dumped automatically. Setting the register implicitly enables automatic mode operation for statistics collection. The period is calculated with the formula: N_Cycle = 2**StatPeriodWhen register StatPeriod is set to its default value 0, automatic dump mode is disabled, and register StatGo is activated for manual mode operation. Note: When parameter statisticsCollection is set to False, StatPeriod is reserved.
                    }
                }
            }
            register ccf_Probe_T_sip0_main_Probe_StatGo @0x28 {
                bytes 4;
                field STATGO @'h0 {
                    access w1c;
                    hard_reset 'h0;
                    doc {
                        Writing a 1 to the 1-bit pulse register StatGo generates a statistics dump.The register is active when statistics collection operates in manual mode, that is, when register StatPeriod is set to 0.NOTE  The written value is not stored in StatGo. A read always returns 0.
                    }
                }
            }
            register ccf_Probe_T_sip0_main_Probe_StatAlarmMin @0x2C {
                bytes 4;
                field STATALARMMIN @'h0 {
                    bits 22;
                    access rw;
                    hard_reset 'h0;
                    doc {
                        Register StatAlarmMin contains the minimum count value used in statistics alarm comparisons. The number of bits is equal to twice the value set forparameter wStatisticsCounter. When parameter statisticsCounterAlarm is set to False, StatAlarmMin is reserved.
                    }
                }
            }
            register ccf_Probe_T_sip0_main_Probe_StatAlarmMax @0x30 {
                bytes 4;
                field STATALARMMAX @'h0 {
                    bits 22;
                    access rw;
                    hard_reset 'h0;
                    doc {
                        Register StatAlarmMax contains the maximum count value used in statistics alarm comparisons.The number of bits is equal to twice the value set for parameter wStatisticsCounter. When parameter statisticsCounterAlarm is set to False, StatAlarmMax is reserved.
                    }
                }
            }
            register ccf_Probe_T_sip0_main_Probe_StatAlarmStatus @0x34 {
                bytes 4;
                field STATALARMSTATUS @'h0 {
                    access ro;
                    hard_reset 'h0;
                    doc {
                        Register StatAlarmStatus is a read-only 1-bit register indicating that at least one statistics counter has exceeded the programmed values for registers StatAlarmMin or StatAlarmMax. Output signal StatAlarm is equal to the values stored in register MainCtl fields StatAlarmStatus and AlarmEn. When parameter statisticsCounterAlarm is set to False, StatAlarmStatus is reserved.
                    }
                }
            }
            register ccf_Probe_T_sip0_main_Probe_StatAlarmClr @0x38 {
                bytes 4;
                field STATALARMCLR @'h0 {
                    access w1c;
                    hard_reset 'h0;
                    doc {
                        Register StatAlarmClr is a 1-bit register. Writing a 1 to this register clears the StatAlarmStatus register bit.When parameter statisticsCounterAlarm is set to False, StatAlarmClr is reserved.NOTE  The written value is not stored in StatAlarmClr. A read always returns 0.
                    }
                }
            }
            register ccf_Probe_T_sip0_main_Probe_StatAlarmEn @0x3C {
                bytes 4;
                field STATALARMEN @'h0 {
                    access rw;
                    hard_reset 'h1;
                    doc {
                        Register StatAlarmEn is a 1-bit register. When set to 0 it masks StatAlarm and CtiTrigOut(1) signal interrupts.
                    }
                }
            }
            register ccf_Probe_T_sip0_main_Probe_Reserved_05 @0x40 {
                bytes 4;
                field ccf_Probe_T_sip0_main_Probe_Reserved_05 {
                    bits 32;
                    access rw;
                    hard_reset 'h0;
                }
            }
            register ccf_Probe_T_sip0_main_Probe_Reserved_06 @0x44 {
                bytes 4;
                field ccf_Probe_T_sip0_main_Probe_Reserved_06 {
                    bits 32;
                    access rw;
                    hard_reset 'h0;
                }
            }
            register ccf_Probe_T_sip0_main_Probe_Reserved_07 @0x48 {
                bytes 4;
                field ccf_Probe_T_sip0_main_Probe_Reserved_07 {
                    bits 32;
                    access rw;
                    hard_reset 'h0;
                }
            }
            register ccf_Probe_T_sip0_main_Probe_Reserved_08 @0x4C {
                bytes 4;
                field ccf_Probe_T_sip0_main_Probe_Reserved_08 {
                    bits 32;
                    access rw;
                    hard_reset 'h0;
                }
            }
            register ccf_Probe_T_sip0_main_Probe_Reserved_09 @0x50 {
                bytes 4;
                field ccf_Probe_T_sip0_main_Probe_Reserved_09 {
                    bits 32;
                    access rw;
                    hard_reset 'h0;
                }
            }
            register ccf_Probe_T_sip0_main_Probe_Reserved_10 @0x54 {
                bytes 4;
                field ccf_Probe_T_sip0_main_Probe_Reserved_10 {
                    bits 32;
                    access rw;
                    hard_reset 'h0;
                }
            }
            register ccf_Probe_T_sip0_main_Probe_Reserved_11 @0x58 {
                bytes 4;
                field ccf_Probe_T_sip0_main_Probe_Reserved_11 {
                    bits 32;
                    access rw;
                    hard_reset 'h0;
                }
            }
            register ccf_Probe_T_sip0_main_Probe_Reserved_12 @0x5C {
                bytes 4;
                field ccf_Probe_T_sip0_main_Probe_Reserved_12 {
                    bits 32;
                    access rw;
                    hard_reset 'h0;
                }
            }
            register ccf_Probe_T_sip0_main_Probe_Reserved_13 @0x60 {
                bytes 4;
                field ccf_Probe_T_sip0_main_Probe_Reserved_13 {
                    bits 32;
                    access rw;
                    hard_reset 'h0;
                }
            }
            register ccf_Probe_T_sip0_main_Probe_Reserved_14 @0x64 {
                bytes 4;
                field ccf_Probe_T_sip0_main_Probe_Reserved_14 {
                    bits 32;
                    access rw;
                    hard_reset 'h0;
                }
            }
            register ccf_Probe_T_sip0_main_Probe_Reserved_15 @0x68 {
                bytes 4;
                field ccf_Probe_T_sip0_main_Probe_Reserved_15 {
                    bits 32;
                    access rw;
                    hard_reset 'h0;
                }
            }
            register ccf_Probe_T_sip0_main_Probe_Reserved_16 @0x6C {
                bytes 4;
                field ccf_Probe_T_sip0_main_Probe_Reserved_16 {
                    bits 32;
                    access rw;
                    hard_reset 'h0;
                }
            }
            register ccf_Probe_T_sip0_main_Probe_Reserved_17 @0x70 {
                bytes 4;
                field ccf_Probe_T_sip0_main_Probe_Reserved_17 {
                    bits 32;
                    access rw;
                    hard_reset 'h0;
                }
            }
            register ccf_Probe_T_sip0_main_Probe_Reserved_18 @0x74 {
                bytes 4;
                field ccf_Probe_T_sip0_main_Probe_Reserved_18 {
                    bits 32;
                    access rw;
                    hard_reset 'h0;
                }
            }
            register ccf_Probe_T_sip0_main_Probe_Reserved_19 @0x78 {
                bytes 4;
                field ccf_Probe_T_sip0_main_Probe_Reserved_19 {
                    bits 32;
                    access rw;
                    hard_reset 'h0;
                }
            }
            register ccf_Probe_T_sip0_main_Probe_Reserved_20 @0x7C {
                bytes 4;
                field ccf_Probe_T_sip0_main_Probe_Reserved_20 {
                    bits 32;
                    access rw;
                    hard_reset 'h0;
                }
            }
            register ccf_Probe_T_sip0_main_Probe_Reserved_21 @0x80 {
                bytes 4;
                field ccf_Probe_T_sip0_main_Probe_Reserved_21 {
                    bits 32;
                    access rw;
                    hard_reset 'h0;
                }
            }
            register ccf_Probe_T_sip0_main_Probe_Reserved_22 @0x84 {
                bytes 4;
                field ccf_Probe_T_sip0_main_Probe_Reserved_22 {
                    bits 32;
                    access rw;
                    hard_reset 'h0;
                }
            }
            register ccf_Probe_T_sip0_main_Probe_Reserved_23 @0x88 {
                bytes 4;
                field ccf_Probe_T_sip0_main_Probe_Reserved_23 {
                    bits 32;
                    access rw;
                    hard_reset 'h0;
                }
            }
            register ccf_Probe_T_sip0_main_Probe_Reserved_24 @0x8C {
                bytes 4;
                field ccf_Probe_T_sip0_main_Probe_Reserved_24 {
                    bits 32;
                    access rw;
                    hard_reset 'h0;
                }
            }
            register ccf_Probe_T_sip0_main_Probe_Reserved_25 @0x90 {
                bytes 4;
                field ccf_Probe_T_sip0_main_Probe_Reserved_25 {
                    bits 32;
                    access rw;
                    hard_reset 'h0;
                }
            }
            register ccf_Probe_T_sip0_main_Probe_Reserved_26 @0x94 {
                bytes 4;
                field ccf_Probe_T_sip0_main_Probe_Reserved_26 {
                    bits 32;
                    access rw;
                    hard_reset 'h0;
                }
            }
            register ccf_Probe_T_sip0_main_Probe_Reserved_27 @0x98 {
                bytes 4;
                field ccf_Probe_T_sip0_main_Probe_Reserved_27 {
                    bits 32;
                    access rw;
                    hard_reset 'h0;
                }
            }
            register ccf_Probe_T_sip0_main_Probe_Reserved_28 @0x9C {
                bytes 4;
                field ccf_Probe_T_sip0_main_Probe_Reserved_28 {
                    bits 32;
                    access rw;
                    hard_reset 'h0;
                }
            }
            register ccf_Probe_T_sip0_main_Probe_Reserved_29 @0xA0 {
                bytes 4;
                field ccf_Probe_T_sip0_main_Probe_Reserved_29 {
                    bits 32;
                    access rw;
                    hard_reset 'h0;
                }
            }
            register ccf_Probe_T_sip0_main_Probe_Reserved_30 @0xA4 {
                bytes 4;
                field ccf_Probe_T_sip0_main_Probe_Reserved_30 {
                    bits 32;
                    access rw;
                    hard_reset 'h0;
                }
            }
            register ccf_Probe_T_sip0_main_Probe_Reserved_31 @0xA8 {
                bytes 4;
                field ccf_Probe_T_sip0_main_Probe_Reserved_31 {
                    bits 32;
                    access rw;
                    hard_reset 'h0;
                }
            }
            register ccf_Probe_T_sip0_main_Probe_Reserved_32 @0xAC {
                bytes 4;
                field ccf_Probe_T_sip0_main_Probe_Reserved_32 {
                    bits 32;
                    access rw;
                    hard_reset 'h0;
                }
            }
            register ccf_Probe_T_sip0_main_Probe_Reserved_33 @0xB0 {
                bytes 4;
                field ccf_Probe_T_sip0_main_Probe_Reserved_33 {
                    bits 32;
                    access rw;
                    hard_reset 'h0;
                }
            }
            register ccf_Probe_T_sip0_main_Probe_Reserved_34 @0xB4 {
                bytes 4;
                field ccf_Probe_T_sip0_main_Probe_Reserved_34 {
                    bits 32;
                    access rw;
                    hard_reset 'h0;
                }
            }
            register ccf_Probe_T_sip0_main_Probe_Reserved_35 @0xB8 {
                bytes 4;
                field ccf_Probe_T_sip0_main_Probe_Reserved_35 {
                    bits 32;
                    access rw;
                    hard_reset 'h0;
                }
            }
            register ccf_Probe_T_sip0_main_Probe_Reserved_36 @0xBC {
                bytes 4;
                field ccf_Probe_T_sip0_main_Probe_Reserved_36 {
                    bits 32;
                    access rw;
                    hard_reset 'h0;
                }
            }
            register ccf_Probe_T_sip0_main_Probe_Reserved_37 @0xC0 {
                bytes 4;
                field ccf_Probe_T_sip0_main_Probe_Reserved_37 {
                    bits 32;
                    access rw;
                    hard_reset 'h0;
                }
            }
            register ccf_Probe_T_sip0_main_Probe_Reserved_38 @0xC4 {
                bytes 4;
                field ccf_Probe_T_sip0_main_Probe_Reserved_38 {
                    bits 32;
                    access rw;
                    hard_reset 'h0;
                }
            }
            register ccf_Probe_T_sip0_main_Probe_Reserved_39 @0xC8 {
                bytes 4;
                field ccf_Probe_T_sip0_main_Probe_Reserved_39 {
                    bits 32;
                    access rw;
                    hard_reset 'h0;
                }
            }
            register ccf_Probe_T_sip0_main_Probe_Reserved_40 @0xCC {
                bytes 4;
                field ccf_Probe_T_sip0_main_Probe_Reserved_40 {
                    bits 32;
                    access rw;
                    hard_reset 'h0;
                }
            }
            register ccf_Probe_T_sip0_main_Probe_Reserved_41 @0xD0 {
                bytes 4;
                field ccf_Probe_T_sip0_main_Probe_Reserved_41 {
                    bits 32;
                    access rw;
                    hard_reset 'h0;
                }
            }
            register ccf_Probe_T_sip0_main_Probe_Reserved_42 @0xD4 {
                bytes 4;
                field ccf_Probe_T_sip0_main_Probe_Reserved_42 {
                    bits 32;
                    access rw;
                    hard_reset 'h0;
                }
            }
            register ccf_Probe_T_sip0_main_Probe_Reserved_43 @0xD8 {
                bytes 4;
                field ccf_Probe_T_sip0_main_Probe_Reserved_43 {
                    bits 32;
                    access rw;
                    hard_reset 'h0;
                }
            }
            register ccf_Probe_T_sip0_main_Probe_Reserved_44 @0xDC {
                bytes 4;
                field ccf_Probe_T_sip0_main_Probe_Reserved_44 {
                    bits 32;
                    access rw;
                    hard_reset 'h0;
                }
            }
            register ccf_Probe_T_sip0_main_Probe_Reserved_45 @0xE0 {
                bytes 4;
                field ccf_Probe_T_sip0_main_Probe_Reserved_45 {
                    bits 32;
                    access rw;
                    hard_reset 'h0;
                }
            }
            register ccf_Probe_T_sip0_main_Probe_Reserved_46 @0xE4 {
                bytes 4;
                field ccf_Probe_T_sip0_main_Probe_Reserved_46 {
                    bits 32;
                    access rw;
                    hard_reset 'h0;
                }
            }
            register ccf_Probe_T_sip0_main_Probe_Reserved_47 @0xE8 {
                bytes 4;
                field ccf_Probe_T_sip0_main_Probe_Reserved_47 {
                    bits 32;
                    access rw;
                    hard_reset 'h0;
                }
            }
            register ccf_Probe_T_sip0_main_Probe_Reserved_48 @0xEC {
                bytes 4;
                field ccf_Probe_T_sip0_main_Probe_Reserved_48 {
                    bits 32;
                    access rw;
                    hard_reset 'h0;
                }
            }
            register ccf_Probe_T_sip0_main_Probe_Reserved_49 @0xF0 {
                bytes 4;
                field ccf_Probe_T_sip0_main_Probe_Reserved_49 {
                    bits 32;
                    access rw;
                    hard_reset 'h0;
                }
            }
            register ccf_Probe_T_sip0_main_Probe_Reserved_50 @0xF4 {
                bytes 4;
                field ccf_Probe_T_sip0_main_Probe_Reserved_50 {
                    bits 32;
                    access rw;
                    hard_reset 'h0;
                }
            }
            register ccf_Probe_T_sip0_main_Probe_Reserved_51 @0xF8 {
                bytes 4;
                field ccf_Probe_T_sip0_main_Probe_Reserved_51 {
                    bits 32;
                    access rw;
                    hard_reset 'h0;
                }
            }
            register ccf_Probe_T_sip0_main_Probe_Reserved_52 @0xFC {
                bytes 4;
                field ccf_Probe_T_sip0_main_Probe_Reserved_52 {
                    bits 32;
                    access rw;
                    hard_reset 'h0;
                }
            }
            register ccf_Probe_T_sip0_main_Probe_Reserved_53 @0x100 {
                bytes 4;
                field ccf_Probe_T_sip0_main_Probe_Reserved_53 {
                    bits 32;
                    access rw;
                    hard_reset 'h0;
                }
            }
            register ccf_Probe_T_sip0_main_Probe_Reserved_54 @0x104 {
                bytes 4;
                field ccf_Probe_T_sip0_main_Probe_Reserved_54 {
                    bits 32;
                    access rw;
                    hard_reset 'h0;
                }
            }
            register ccf_Probe_T_sip0_main_Probe_Reserved_55 @0x108 {
                bytes 4;
                field ccf_Probe_T_sip0_main_Probe_Reserved_55 {
                    bits 32;
                    access rw;
                    hard_reset 'h0;
                }
            }
            register ccf_Probe_T_sip0_main_Probe_Reserved_56 @0x10C {
                bytes 4;
                field ccf_Probe_T_sip0_main_Probe_Reserved_56 {
                    bits 32;
                    access rw;
                    hard_reset 'h0;
                }
            }
            register ccf_Probe_T_sip0_main_Probe_Reserved_57 @0x110 {
                bytes 4;
                field ccf_Probe_T_sip0_main_Probe_Reserved_57 {
                    bits 32;
                    access rw;
                    hard_reset 'h0;
                }
            }
            register ccf_Probe_T_sip0_main_Probe_Reserved_58 @0x114 {
                bytes 4;
                field ccf_Probe_T_sip0_main_Probe_Reserved_58 {
                    bits 32;
                    access rw;
                    hard_reset 'h0;
                }
            }
            register ccf_Probe_T_sip0_main_Probe_Reserved_59 @0x118 {
                bytes 4;
                field ccf_Probe_T_sip0_main_Probe_Reserved_59 {
                    bits 32;
                    access rw;
                    hard_reset 'h0;
                }
            }
            register ccf_Probe_T_sip0_main_Probe_Reserved_60 @0x11C {
                bytes 4;
                field ccf_Probe_T_sip0_main_Probe_Reserved_60 {
                    bits 32;
                    access rw;
                    hard_reset 'h0;
                }
            }
            register ccf_Probe_T_sip0_main_Probe_Reserved_61 @0x120 {
                bytes 4;
                field ccf_Probe_T_sip0_main_Probe_Reserved_61 {
                    bits 32;
                    access rw;
                    hard_reset 'h0;
                }
            }
            register ccf_Probe_T_sip0_main_Probe_Reserved_62 @0x124 {
                bytes 4;
                field ccf_Probe_T_sip0_main_Probe_Reserved_62 {
                    bits 32;
                    access rw;
                    hard_reset 'h0;
                }
            }
            register ccf_Probe_T_sip0_main_Probe_Reserved_63 @0x128 {
                bytes 4;
                field ccf_Probe_T_sip0_main_Probe_Reserved_63 {
                    bits 32;
                    access rw;
                    hard_reset 'h0;
                }
            }
            register ccf_Probe_T_sip0_main_Probe_Reserved_64 @0x12C {
                bytes 4;
                field ccf_Probe_T_sip0_main_Probe_Reserved_64 {
                    bits 32;
                    access rw;
                    hard_reset 'h0;
                }
            }
            register ccf_Probe_T_sip0_main_Probe_Reserved_65 @0x130 {
                bytes 4;
                field ccf_Probe_T_sip0_main_Probe_Reserved_65 {
                    bits 32;
                    access rw;
                    hard_reset 'h0;
                }
            }
            register ccf_Probe_T_sip0_main_Probe_Reserved_66 @0x134 {
                bytes 4;
                field ccf_Probe_T_sip0_main_Probe_Reserved_66 {
                    bits 32;
                    access rw;
                    hard_reset 'h0;
                }
            }
            register ccf_Probe_T_sip0_main_Probe_Counters_0_Src @0x138 {
                bytes 4;
                field INTEVENT @'h0 {
                    bits 5;
                    access rw;
                    hard_reset 'h0;
                    enum { OFF = 0, CYCLE = 1, IDLE = 2, XFER = 3, BUSY = 4, WAIT = 5, PKT = 6, LUT = 7, BYTE = 8, PRESS0 = 9, PRESS1 = 10, PRESS2 = 11, FILT0 = 12, FILT1 = 13, FILT2 = 14, FILT3 = 15, CHAIN = 16, LUT_BYTE_EN = 17, LUT_BYTE = 18, FILT_BYTE_EN = 19, FILT_BYTE = 20, PRESS3 = 21, PRESS4 = 22, PRESS5 = 23, PRESS6 = 24, RSV_0 = 25, RSV_1 = 26, RSV_2 = 27, RSV_3 = 28, RSV_4 = 29, RSV_5 = 30, RSV_6 = 31 };
                    doc {
                        Internal packet event
                    }
                }
                field EXTEVENT @'h5 {
                    access rw;
                    hard_reset 'h0;
                    doc {
                        When greater than 0, the entire register value is used to select an external hardware event source. The index of the external event is equal to {ExtEvent,IntEvent}.
                    }
                }
                doc {
                    Register CntSrc indicates the event source used to increment the counter. Unassigned values (non-existing Press level or ExtEvent index, or unimplemented Filter) are equivalent to OFF.
	Register CntSrc indicates the event source used to increment the counter. Unassigned values (non-existing Press level or ExtEvent index, or unimplemented Filter) are equivalent to OFF.
	
                }
            }
            register ccf_Probe_T_sip0_main_Probe_Counters_0_AlarmMode @0x13C {
                bytes 4;
                field COUNTERS_0_ALARMMODE @'h0 {
                    bits 2;
                    access rw;
                    hard_reset 'h0;
                    enum { OFF = 0, MIN = 1, MAX = 2, MIN_MAX = 3 };
                    doc {
                        Register AlarmMode is a 2-bit register that is present when parameter statisticsCounterAlarm is set to True. The register defines the statistics-alarm behavior of the counter.
                    }
                }
            }
            register ccf_Probe_T_sip0_main_Probe_Counters_0_Val @0x140 {
                bytes 4;
                field COUNTERS_0_VAL @'h0 {
                    bits 11;
                    access ro;
                    hard_reset 'h0;
                    doc {
                        Register Val is a read-only register that is always present. The register containsthe statistics counter value either pending StatAlarm output, or when statisticscollection is suspended subsequent to triggers or signal statSuspend.
                    }
                }
            }
            register ccf_Probe_T_sip0_main_Probe_Reserved_67 @0x144 {
                bytes 4;
                field ccf_Probe_T_sip0_main_Probe_Reserved_67 {
                    bits 32;
                    access rw;
                    hard_reset 'h0;
                }
            }
            register ccf_Probe_T_sip0_main_Probe_Reserved_68 @0x148 {
                bytes 4;
                field ccf_Probe_T_sip0_main_Probe_Reserved_68 {
                    bits 32;
                    access rw;
                    hard_reset 'h0;
                }
            }
            register ccf_Probe_T_sip0_main_Probe_Counters_1_Src @0x14C {
                bytes 4;
                field INTEVENT @'h0 {
                    bits 5;
                    access rw;
                    hard_reset 'h0;
                    enum { OFF = 0, CYCLE = 1, IDLE = 2, XFER = 3, BUSY = 4, WAIT = 5, PKT = 6, LUT = 7, BYTE = 8, PRESS0 = 9, PRESS1 = 10, PRESS2 = 11, FILT0 = 12, FILT1 = 13, FILT2 = 14, FILT3 = 15, CHAIN = 16, LUT_BYTE_EN = 17, LUT_BYTE = 18, FILT_BYTE_EN = 19, FILT_BYTE = 20, PRESS3 = 21, PRESS4 = 22, PRESS5 = 23, PRESS6 = 24, RSV_0 = 25, RSV_1 = 26, RSV_2 = 27, RSV_3 = 28, RSV_4 = 29, RSV_5 = 30, RSV_6 = 31 };
                    doc {
                        Internal packet event
                    }
                }
                field EXTEVENT @'h5 {
                    access rw;
                    hard_reset 'h0;
                    doc {
                        When greater than 0, the entire register value is used to select an external hardware event source. The index of the external event is equal to {ExtEvent,IntEvent}.
                    }
                }
                doc {
                    Register CntSrc indicates the event source used to increment the counter. Unassigned values (non-existing Press level or ExtEvent index, or unimplemented Filter) are equivalent to OFF.
	Register CntSrc indicates the event source used to increment the counter. Unassigned values (non-existing Press level or ExtEvent index, or unimplemented Filter) are equivalent to OFF.
	
                }
            }
            register ccf_Probe_T_sip0_main_Probe_Counters_1_AlarmMode @0x150 {
                bytes 4;
                field COUNTERS_1_ALARMMODE @'h0 {
                    bits 2;
                    access rw;
                    hard_reset 'h0;
                    enum { OFF = 0, MIN = 1, MAX = 2, MIN_MAX = 3 };
                    doc {
                        Register AlarmMode is a 2-bit register that is present when parameter statisticsCounterAlarm is set to True. The register defines the statistics-alarm behavior of the counter.
                    }
                }
            }
            register ccf_Probe_T_sip0_main_Probe_Counters_1_Val @0x154 {
                bytes 4;
                field COUNTERS_1_VAL @'h0 {
                    bits 11;
                    access ro;
                    hard_reset 'h0;
                    doc {
                        Register Val is a read-only register that is always present. The register containsthe statistics counter value either pending StatAlarm output, or when statisticscollection is suspended subsequent to triggers or signal statSuspend.
                    }
                }
            }
            register ccf_Probe_T_sip0_main_Probe_Reserved_69 @0x158 {
                bytes 4;
                field ccf_Probe_T_sip0_main_Probe_Reserved_69 {
                    bits 32;
                    access rw;
                    hard_reset 'h0;
                }
            }
            register ccf_Probe_T_sip0_main_Probe_Reserved_70 @0x15C {
                bytes 4;
                field ccf_Probe_T_sip0_main_Probe_Reserved_70 {
                    bits 32;
                    access rw;
                    hard_reset 'h0;
                }
            }
            register ccf_Probe_T_sip0_main_Probe_Reserved_71 @0x160 {
                bytes 4;
                field ccf_Probe_T_sip0_main_Probe_Reserved_71 {
                    bits 32;
                    access rw;
                    hard_reset 'h0;
                }
            }
            register ccf_Probe_T_sip0_main_Probe_Reserved_72 @0x164 {
                bytes 4;
                field ccf_Probe_T_sip0_main_Probe_Reserved_72 {
                    bits 32;
                    access rw;
                    hard_reset 'h0;
                }
            }
            register ccf_Probe_T_sip0_main_Probe_Reserved_73 @0x168 {
                bytes 4;
                field ccf_Probe_T_sip0_main_Probe_Reserved_73 {
                    bits 32;
                    access rw;
                    hard_reset 'h0;
                }
            }
            register ccf_Probe_T_sip0_main_Probe_Reserved_74 @0x16C {
                bytes 4;
                field ccf_Probe_T_sip0_main_Probe_Reserved_74 {
                    bits 32;
                    access rw;
                    hard_reset 'h0;
                }
            }
            register ccf_Probe_T_sip0_main_Probe_Reserved_75 @0x170 {
                bytes 4;
                field ccf_Probe_T_sip0_main_Probe_Reserved_75 {
                    bits 32;
                    access rw;
                    hard_reset 'h0;
                }
            }
            register ccf_Probe_T_sip0_main_Probe_Reserved_76 @0x174 {
                bytes 4;
                field ccf_Probe_T_sip0_main_Probe_Reserved_76 {
                    bits 32;
                    access rw;
                    hard_reset 'h0;
                }
            }
            register ccf_Probe_T_sip0_main_Probe_Reserved_77 @0x178 {
                bytes 4;
                field ccf_Probe_T_sip0_main_Probe_Reserved_77 {
                    bits 32;
                    access rw;
                    hard_reset 'h0;
                }
            }
            register ccf_Probe_T_sip0_main_Probe_Reserved_78 @0x17C {
                bytes 4;
                field ccf_Probe_T_sip0_main_Probe_Reserved_78 {
                    bits 32;
                    access rw;
                    hard_reset 'h0;
                }
            }
            register ccf_Probe_T_sip0_main_Probe_Reserved_79 @0x180 {
                bytes 4;
                field ccf_Probe_T_sip0_main_Probe_Reserved_79 {
                    bits 32;
                    access rw;
                    hard_reset 'h0;
                }
            }
            register ccf_Probe_T_sip0_main_Probe_Reserved_80 @0x184 {
                bytes 4;
                field ccf_Probe_T_sip0_main_Probe_Reserved_80 {
                    bits 32;
                    access rw;
                    hard_reset 'h0;
                }
            }
            register ccf_Probe_T_sip0_main_Probe_Reserved_81 @0x188 {
                bytes 4;
                field ccf_Probe_T_sip0_main_Probe_Reserved_81 {
                    bits 32;
                    access rw;
                    hard_reset 'h0;
                }
            }
            register ccf_Probe_T_sip0_main_Probe_Reserved_82 @0x18C {
                bytes 4;
                field ccf_Probe_T_sip0_main_Probe_Reserved_82 {
                    bits 32;
                    access rw;
                    hard_reset 'h0;
                }
            }
            register ccf_Probe_T_sip0_main_Probe_Reserved_83 @0x190 {
                bytes 4;
                field ccf_Probe_T_sip0_main_Probe_Reserved_83 {
                    bits 32;
                    access rw;
                    hard_reset 'h0;
                }
            }
            register ccf_Probe_T_sip0_main_Probe_Reserved_84 @0x194 {
                bytes 4;
                field ccf_Probe_T_sip0_main_Probe_Reserved_84 {
                    bits 32;
                    access rw;
                    hard_reset 'h0;
                }
            }
            register ccf_Probe_T_sip0_main_Probe_Reserved_85 @0x198 {
                bytes 4;
                field ccf_Probe_T_sip0_main_Probe_Reserved_85 {
                    bits 32;
                    access rw;
                    hard_reset 'h0;
                }
            }
            register ccf_Probe_T_sip0_main_Probe_Reserved_86 @0x19C {
                bytes 4;
                field ccf_Probe_T_sip0_main_Probe_Reserved_86 {
                    bits 32;
                    access rw;
                    hard_reset 'h0;
                }
            }
            register ccf_Probe_T_sip0_main_Probe_Reserved_87 @0x1A0 {
                bytes 4;
                field ccf_Probe_T_sip0_main_Probe_Reserved_87 {
                    bits 32;
                    access rw;
                    hard_reset 'h0;
                }
            }
            register ccf_Probe_T_sip0_main_Probe_Reserved_88 @0x1A4 {
                bytes 4;
                field ccf_Probe_T_sip0_main_Probe_Reserved_88 {
                    bits 32;
                    access rw;
                    hard_reset 'h0;
                }
            }
            register ccf_Probe_T_sip0_main_Probe_Reserved_89 @0x1A8 {
                bytes 4;
                field ccf_Probe_T_sip0_main_Probe_Reserved_89 {
                    bits 32;
                    access rw;
                    hard_reset 'h0;
                }
            }
            register ccf_Probe_T_sip0_main_Probe_Reserved_90 @0x1AC {
                bytes 4;
                field ccf_Probe_T_sip0_main_Probe_Reserved_90 {
                    bits 32;
                    access rw;
                    hard_reset 'h0;
                }
            }
            register ccf_Probe_T_sip0_main_Probe_Reserved_91 @0x1B0 {
                bytes 4;
                field ccf_Probe_T_sip0_main_Probe_Reserved_91 {
                    bits 32;
                    access rw;
                    hard_reset 'h0;
                }
            }
            register ccf_Probe_T_sip0_main_Probe_Reserved_92 @0x1B4 {
                bytes 4;
                field ccf_Probe_T_sip0_main_Probe_Reserved_92 {
                    bits 32;
                    access rw;
                    hard_reset 'h0;
                }
            }
            register ccf_Probe_T_sip0_main_Probe_Reserved_93 @0x1B8 {
                bytes 4;
                field ccf_Probe_T_sip0_main_Probe_Reserved_93 {
                    bits 32;
                    access rw;
                    hard_reset 'h0;
                }
            }
            register ccf_Probe_T_sip0_main_Probe_Reserved_94 @0x1BC {
                bytes 4;
                field ccf_Probe_T_sip0_main_Probe_Reserved_94 {
                    bits 32;
                    access rw;
                    hard_reset 'h0;
                }
            }
            register ccf_Probe_T_sip0_main_Probe_Reserved_95 @0x1C0 {
                bytes 4;
                field ccf_Probe_T_sip0_main_Probe_Reserved_95 {
                    bits 32;
                    access rw;
                    hard_reset 'h0;
                }
            }
            register ccf_Probe_T_sip0_main_Probe_Reserved_96 @0x1C4 {
                bytes 4;
                field ccf_Probe_T_sip0_main_Probe_Reserved_96 {
                    bits 32;
                    access rw;
                    hard_reset 'h0;
                }
            }
            register ccf_Probe_T_sip0_main_Probe_Reserved_97 @0x1C8 {
                bytes 4;
                field ccf_Probe_T_sip0_main_Probe_Reserved_97 {
                    bits 32;
                    access rw;
                    hard_reset 'h0;
                }
            }
            register ccf_Probe_T_sip0_main_Probe_Reserved_98 @0x1CC {
                bytes 4;
                field ccf_Probe_T_sip0_main_Probe_Reserved_98 {
                    bits 32;
                    access rw;
                    hard_reset 'h0;
                }
            }
            register ccf_Probe_T_sip0_main_Probe_Reserved_99 @0x1D0 {
                bytes 4;
                field ccf_Probe_T_sip0_main_Probe_Reserved_99 {
                    bits 32;
                    access rw;
                    hard_reset 'h0;
                }
            }
            register ccf_Probe_T_sip0_main_Probe_Reserved_100 @0x1D4 {
                bytes 4;
                field ccf_Probe_T_sip0_main_Probe_Reserved_100 {
                    bits 32;
                    access rw;
                    hard_reset 'h0;
                }
            }
            register ccf_Probe_T_sip0_main_Probe_Reserved_101 @0x1D8 {
                bytes 4;
                field ccf_Probe_T_sip0_main_Probe_Reserved_101 {
                    bits 32;
                    access rw;
                    hard_reset 'h0;
                }
            }
            register ccf_Probe_T_sip0_main_Probe_Reserved_102 @0x1DC {
                bytes 4;
                field ccf_Probe_T_sip0_main_Probe_Reserved_102 {
                    bits 32;
                    access rw;
                    hard_reset 'h0;
                }
            }
            register ccf_Probe_T_sip0_main_Probe_Reserved_103 @0x1E0 {
                bytes 4;
                field ccf_Probe_T_sip0_main_Probe_Reserved_103 {
                    bits 32;
                    access rw;
                    hard_reset 'h0;
                }
            }
            register ccf_Probe_T_sip0_main_Probe_Reserved_104 @0x1E4 {
                bytes 4;
                field ccf_Probe_T_sip0_main_Probe_Reserved_104 {
                    bits 32;
                    access rw;
                    hard_reset 'h0;
                }
            }
            register ccf_Probe_T_sip0_main_Probe_Reserved_105 @0x1E8 {
                bytes 4;
                field ccf_Probe_T_sip0_main_Probe_Reserved_105 {
                    bits 32;
                    access rw;
                    hard_reset 'h0;
                }
            }
            register ccf_Probe_T_sip0_main_Probe_Reserved_106 @0x1EC {
                bytes 4;
                field ccf_Probe_T_sip0_main_Probe_Reserved_106 {
                    bits 32;
                    access rw;
                    hard_reset 'h0;
                }
            }
            register ccf_Probe_T_sip0_main_Probe_Reserved_107 @0x1F0 {
                bytes 4;
                field ccf_Probe_T_sip0_main_Probe_Reserved_107 {
                    bits 32;
                    access rw;
                    hard_reset 'h0;
                }
            }
            register ccf_Probe_T_sip0_main_Probe_Reserved_108 @0x1F4 {
                bytes 4;
                field ccf_Probe_T_sip0_main_Probe_Reserved_108 {
                    bits 32;
                    access rw;
                    hard_reset 'h0;
                }
            }
            register ccf_Probe_T_sip0_main_Probe_Reserved_109 @0x1F8 {
                bytes 4;
                field ccf_Probe_T_sip0_main_Probe_Reserved_109 {
                    bits 32;
                    access rw;
                    hard_reset 'h0;
                }
            }
            register ccf_Probe_T_sip0_main_Probe_Reserved_110 @0x1FC {
                bytes 4;
                field ccf_Probe_T_sip0_main_Probe_Reserved_110 {
                    bits 32;
                    access rw;
                    hard_reset 'h0;
                }
            }
            register ccf_Probe_T_sip0_main_Probe_Reserved_111 @0x200 {
                bytes 4;
                field ccf_Probe_T_sip0_main_Probe_Reserved_111 {
                    bits 32;
                    access rw;
                    hard_reset 'h0;
                }
            }
            register ccf_Probe_T_sip0_main_Probe_Reserved_112 @0x204 {
                bytes 4;
                field ccf_Probe_T_sip0_main_Probe_Reserved_112 {
                    bits 32;
                    access rw;
                    hard_reset 'h0;
                }
            }
            register ccf_Probe_T_sip0_main_Probe_Reserved_113 @0x208 {
                bytes 4;
                field ccf_Probe_T_sip0_main_Probe_Reserved_113 {
                    bits 32;
                    access rw;
                    hard_reset 'h0;
                }
            }
            register ccf_Probe_T_sip0_main_Probe_Reserved_114 @0x20C {
                bytes 4;
                field ccf_Probe_T_sip0_main_Probe_Reserved_114 {
                    bits 32;
                    access rw;
                    hard_reset 'h0;
                }
            }
            register ccf_Probe_T_sip0_main_Probe_Reserved_115 @0x210 {
                bytes 4;
                field ccf_Probe_T_sip0_main_Probe_Reserved_115 {
                    bits 32;
                    access rw;
                    hard_reset 'h0;
                }
            }
            register ccf_Probe_T_sip0_main_Probe_Reserved_116 @0x214 {
                bytes 4;
                field ccf_Probe_T_sip0_main_Probe_Reserved_116 {
                    bits 32;
                    access rw;
                    hard_reset 'h0;
                }
            }
            register ccf_Probe_T_sip0_main_Probe_Reserved_117 @0x218 {
                bytes 4;
                field ccf_Probe_T_sip0_main_Probe_Reserved_117 {
                    bits 32;
                    access rw;
                    hard_reset 'h0;
                }
            }
            register ccf_Probe_T_sip0_main_Probe_Reserved_118 @0x21C {
                bytes 4;
                field ccf_Probe_T_sip0_main_Probe_Reserved_118 {
                    bits 32;
                    access rw;
                    hard_reset 'h0;
                }
            }
            register ccf_Probe_T_sip0_main_Probe_Reserved_119 @0x220 {
                bytes 4;
                field ccf_Probe_T_sip0_main_Probe_Reserved_119 {
                    bits 32;
                    access rw;
                    hard_reset 'h0;
                }
            }
            register ccf_Probe_T_sip0_main_Probe_Reserved_120 @0x224 {
                bytes 4;
                field ccf_Probe_T_sip0_main_Probe_Reserved_120 {
                    bits 32;
                    access rw;
                    hard_reset 'h0;
                }
            }
            register ccf_Probe_T_sip0_main_Probe_Reserved_121 @0x228 {
                bytes 4;
                field ccf_Probe_T_sip0_main_Probe_Reserved_121 {
                    bits 32;
                    access rw;
                    hard_reset 'h0;
                }
            }
            register ccf_Probe_T_sip0_main_Probe_Reserved_122 @0x22C {
                bytes 4;
                field ccf_Probe_T_sip0_main_Probe_Reserved_122 {
                    bits 32;
                    access rw;
                    hard_reset 'h0;
                }
            }
            register ccf_Probe_T_sip0_main_Probe_Reserved_123 @0x230 {
                bytes 4;
                field ccf_Probe_T_sip0_main_Probe_Reserved_123 {
                    bits 32;
                    access rw;
                    hard_reset 'h0;
                }
            }
            register ccf_Probe_T_sip0_main_Probe_Reserved_124 @0x234 {
                bytes 4;
                field ccf_Probe_T_sip0_main_Probe_Reserved_124 {
                    bits 32;
                    access rw;
                    hard_reset 'h0;
                }
            }
            register ccf_Probe_T_sip0_main_Probe_Reserved_125 @0x238 {
                bytes 4;
                field ccf_Probe_T_sip0_main_Probe_Reserved_125 {
                    bits 32;
                    access rw;
                    hard_reset 'h0;
                }
            }
            register ccf_Probe_T_sip0_main_Probe_Reserved_126 @0x23C {
                bytes 4;
                field ccf_Probe_T_sip0_main_Probe_Reserved_126 {
                    bits 32;
                    access rw;
                    hard_reset 'h0;
                }
            }
            register ccf_Probe_T_sip0_main_Probe_Reserved_127 @0x240 {
                bytes 4;
                field ccf_Probe_T_sip0_main_Probe_Reserved_127 {
                    bits 32;
                    access rw;
                    hard_reset 'h0;
                }
            }
            register ccf_Probe_T_sip0_main_Probe_Reserved_128 @0x244 {
                bytes 4;
                field ccf_Probe_T_sip0_main_Probe_Reserved_128 {
                    bits 32;
                    access rw;
                    hard_reset 'h0;
                }
            }
            register ccf_Probe_T_sip0_main_Probe_Reserved_129 @0x248 {
                bytes 4;
                field ccf_Probe_T_sip0_main_Probe_Reserved_129 {
                    bits 32;
                    access rw;
                    hard_reset 'h0;
                }
            }
            register ccf_Probe_T_sip0_main_Probe_Reserved_130 @0x24C {
                bytes 4;
                field ccf_Probe_T_sip0_main_Probe_Reserved_130 {
                    bits 32;
                    access rw;
                    hard_reset 'h0;
                }
            }
            register ccf_Probe_T_sip0_main_Probe_Reserved_131 @0x250 {
                bytes 4;
                field ccf_Probe_T_sip0_main_Probe_Reserved_131 {
                    bits 32;
                    access rw;
                    hard_reset 'h0;
                }
            }
            register ccf_Probe_T_sip0_main_Probe_Reserved_132 @0x254 {
                bytes 4;
                field ccf_Probe_T_sip0_main_Probe_Reserved_132 {
                    bits 32;
                    access rw;
                    hard_reset 'h0;
                }
            }
            register ccf_Probe_T_sip0_main_Probe_Reserved_133 @0x258 {
                bytes 4;
                field ccf_Probe_T_sip0_main_Probe_Reserved_133 {
                    bits 32;
                    access rw;
                    hard_reset 'h0;
                }
            }
            register ccf_Probe_T_sip0_main_Probe_Reserved_134 @0x25C {
                bytes 4;
                field ccf_Probe_T_sip0_main_Probe_Reserved_134 {
                    bits 32;
                    access rw;
                    hard_reset 'h0;
                }
            }
            register ccf_Probe_T_sip0_main_Probe_Reserved_135 @0x260 {
                bytes 4;
                field ccf_Probe_T_sip0_main_Probe_Reserved_135 {
                    bits 32;
                    access rw;
                    hard_reset 'h0;
                }
            }
            register ccf_Probe_T_sip0_main_Probe_Reserved_136 @0x264 {
                bytes 4;
                field ccf_Probe_T_sip0_main_Probe_Reserved_136 {
                    bits 32;
                    access rw;
                    hard_reset 'h0;
                }
            }
            register ccf_Probe_T_sip0_main_Probe_Reserved_137 @0x268 {
                bytes 4;
                field ccf_Probe_T_sip0_main_Probe_Reserved_137 {
                    bits 32;
                    access rw;
                    hard_reset 'h0;
                }
            }
            register ccf_Probe_T_sip0_main_Probe_Reserved_138 @0x26C {
                bytes 4;
                field ccf_Probe_T_sip0_main_Probe_Reserved_138 {
                    bits 32;
                    access rw;
                    hard_reset 'h0;
                }
            }
            register ccf_Probe_T_sip0_main_Probe_Reserved_139 @0x270 {
                bytes 4;
                field ccf_Probe_T_sip0_main_Probe_Reserved_139 {
                    bits 32;
                    access rw;
                    hard_reset 'h0;
                }
            }
            register ccf_Probe_T_sip0_main_Probe_Reserved_140 @0x274 {
                bytes 4;
                field ccf_Probe_T_sip0_main_Probe_Reserved_140 {
                    bits 32;
                    access rw;
                    hard_reset 'h0;
                }
            }
            register ccf_Probe_T_sip0_main_Probe_Reserved_141 @0x278 {
                bytes 4;
                field ccf_Probe_T_sip0_main_Probe_Reserved_141 {
                    bits 32;
                    access rw;
                    hard_reset 'h0;
                }
            }
            register ccf_Probe_T_sip0_main_Probe_Reserved_142 @0x27C {
                bytes 4;
                field ccf_Probe_T_sip0_main_Probe_Reserved_142 {
                    bits 32;
                    access rw;
                    hard_reset 'h0;
                }
            }
            register ccf_Probe_T_sip0_main_Probe_Reserved_143 @0x280 {
                bytes 4;
                field ccf_Probe_T_sip0_main_Probe_Reserved_143 {
                    bits 32;
                    access rw;
                    hard_reset 'h0;
                }
            }
            register ccf_Probe_T_sip0_main_Probe_Reserved_144 @0x284 {
                bytes 4;
                field ccf_Probe_T_sip0_main_Probe_Reserved_144 {
                    bits 32;
                    access rw;
                    hard_reset 'h0;
                }
            }
            register ccf_Probe_T_sip0_main_Probe_Reserved_145 @0x288 {
                bytes 4;
                field ccf_Probe_T_sip0_main_Probe_Reserved_145 {
                    bits 32;
                    access rw;
                    hard_reset 'h0;
                }
            }
            register ccf_Probe_T_sip0_main_Probe_Reserved_146 @0x28C {
                bytes 4;
                field ccf_Probe_T_sip0_main_Probe_Reserved_146 {
                    bits 32;
                    access rw;
                    hard_reset 'h0;
                }
            }
            register ccf_Probe_T_sip0_main_Probe_Reserved_147 @0x290 {
                bytes 4;
                field ccf_Probe_T_sip0_main_Probe_Reserved_147 {
                    bits 32;
                    access rw;
                    hard_reset 'h0;
                }
            }
            register ccf_Probe_T_sip0_main_Probe_Reserved_148 @0x294 {
                bytes 4;
                field ccf_Probe_T_sip0_main_Probe_Reserved_148 {
                    bits 32;
                    access rw;
                    hard_reset 'h0;
                }
            }
            register ccf_Probe_T_sip0_main_Probe_Reserved_149 @0x298 {
                bytes 4;
                field ccf_Probe_T_sip0_main_Probe_Reserved_149 {
                    bits 32;
                    access rw;
                    hard_reset 'h0;
                }
            }
            register ccf_Probe_T_sip0_main_Probe_Reserved_150 @0x29C {
                bytes 4;
                field ccf_Probe_T_sip0_main_Probe_Reserved_150 {
                    bits 32;
                    access rw;
                    hard_reset 'h0;
                }
            }
            register ccf_Probe_T_sip0_main_Probe_Reserved_151 @0x2A0 {
                bytes 4;
                field ccf_Probe_T_sip0_main_Probe_Reserved_151 {
                    bits 32;
                    access rw;
                    hard_reset 'h0;
                }
            }
            register ccf_Probe_T_sip0_main_Probe_Reserved_152 @0x2A4 {
                bytes 4;
                field ccf_Probe_T_sip0_main_Probe_Reserved_152 {
                    bits 32;
                    access rw;
                    hard_reset 'h0;
                }
            }
            register ccf_Probe_T_sip0_main_Probe_Reserved_153 @0x2A8 {
                bytes 4;
                field ccf_Probe_T_sip0_main_Probe_Reserved_153 {
                    bits 32;
                    access rw;
                    hard_reset 'h0;
                }
            }
            register ccf_Probe_T_sip0_main_Probe_Reserved_154 @0x2AC {
                bytes 4;
                field ccf_Probe_T_sip0_main_Probe_Reserved_154 {
                    bits 32;
                    access rw;
                    hard_reset 'h0;
                }
            }
            register ccf_Probe_T_sip0_main_Probe_Reserved_155 @0x2B0 {
                bytes 4;
                field ccf_Probe_T_sip0_main_Probe_Reserved_155 {
                    bits 32;
                    access rw;
                    hard_reset 'h0;
                }
            }
            register ccf_Probe_T_sip0_main_Probe_Reserved_156 @0x2B4 {
                bytes 4;
                field ccf_Probe_T_sip0_main_Probe_Reserved_156 {
                    bits 32;
                    access rw;
                    hard_reset 'h0;
                }
            }
            register ccf_Probe_T_sip0_main_Probe_Reserved_157 @0x2B8 {
                bytes 4;
                field ccf_Probe_T_sip0_main_Probe_Reserved_157 {
                    bits 32;
                    access rw;
                    hard_reset 'h0;
                }
            }
            register ccf_Probe_T_sip0_main_Probe_Reserved_158 @0x2BC {
                bytes 4;
                field ccf_Probe_T_sip0_main_Probe_Reserved_158 {
                    bits 32;
                    access rw;
                    hard_reset 'h0;
                }
            }
            register ccf_Probe_T_sip0_main_Probe_Reserved_159 @0x2C0 {
                bytes 4;
                field ccf_Probe_T_sip0_main_Probe_Reserved_159 {
                    bits 32;
                    access rw;
                    hard_reset 'h0;
                }
            }
            register ccf_Probe_T_sip0_main_Probe_Reserved_160 @0x2C4 {
                bytes 4;
                field ccf_Probe_T_sip0_main_Probe_Reserved_160 {
                    bits 32;
                    access rw;
                    hard_reset 'h0;
                }
            }
            register ccf_Probe_T_sip0_main_Probe_Reserved_161 @0x2C8 {
                bytes 4;
                field ccf_Probe_T_sip0_main_Probe_Reserved_161 {
                    bits 32;
                    access rw;
                    hard_reset 'h0;
                }
            }
            register ccf_Probe_T_sip0_main_Probe_Reserved_162 @0x2CC {
                bytes 4;
                field ccf_Probe_T_sip0_main_Probe_Reserved_162 {
                    bits 32;
                    access rw;
                    hard_reset 'h0;
                }
            }
            register ccf_Probe_T_sip0_main_Probe_Reserved_163 @0x2D0 {
                bytes 4;
                field ccf_Probe_T_sip0_main_Probe_Reserved_163 {
                    bits 32;
                    access rw;
                    hard_reset 'h0;
                }
            }
            register ccf_Probe_T_sip0_main_Probe_Reserved_164 @0x2D4 {
                bytes 4;
                field ccf_Probe_T_sip0_main_Probe_Reserved_164 {
                    bits 32;
                    access rw;
                    hard_reset 'h0;
                }
            }
            register ccf_Probe_T_sip0_main_Probe_Reserved_165 @0x2D8 {
                bytes 4;
                field ccf_Probe_T_sip0_main_Probe_Reserved_165 {
                    bits 32;
                    access rw;
                    hard_reset 'h0;
                }
            }
            register ccf_Probe_T_sip0_main_Probe_Reserved_166 @0x2DC {
                bytes 4;
                field ccf_Probe_T_sip0_main_Probe_Reserved_166 {
                    bits 32;
                    access rw;
                    hard_reset 'h0;
                }
            }
            register ccf_Probe_T_sip0_main_Probe_Reserved_167 @0x2E0 {
                bytes 4;
                field ccf_Probe_T_sip0_main_Probe_Reserved_167 {
                    bits 32;
                    access rw;
                    hard_reset 'h0;
                }
            }
            register ccf_Probe_T_sip0_main_Probe_Reserved_168 @0x2E4 {
                bytes 4;
                field ccf_Probe_T_sip0_main_Probe_Reserved_168 {
                    bits 32;
                    access rw;
                    hard_reset 'h0;
                }
            }
            register ccf_Probe_T_sip0_main_Probe_Reserved_169 @0x2E8 {
                bytes 4;
                field ccf_Probe_T_sip0_main_Probe_Reserved_169 {
                    bits 32;
                    access rw;
                    hard_reset 'h0;
                }
            }
            register ccf_Probe_T_sip0_main_Probe_Reserved_170 @0x2EC {
                bytes 4;
                field ccf_Probe_T_sip0_main_Probe_Reserved_170 {
                    bits 32;
                    access rw;
                    hard_reset 'h0;
                }
            }
            register ccf_Probe_T_sip0_main_Probe_Reserved_171 @0x2F0 {
                bytes 4;
                field ccf_Probe_T_sip0_main_Probe_Reserved_171 {
                    bits 32;
                    access rw;
                    hard_reset 'h0;
                }
            }
            register ccf_Probe_T_sip0_main_Probe_Reserved_172 @0x2F4 {
                bytes 4;
                field ccf_Probe_T_sip0_main_Probe_Reserved_172 {
                    bits 32;
                    access rw;
                    hard_reset 'h0;
                }
            }
            register ccf_Probe_T_sip0_main_Probe_Reserved_173 @0x2F8 {
                bytes 4;
                field ccf_Probe_T_sip0_main_Probe_Reserved_173 {
                    bits 32;
                    access rw;
                    hard_reset 'h0;
                }
            }
            register ccf_Probe_T_sip0_main_Probe_Reserved_174 @0x2FC {
                bytes 4;
                field ccf_Probe_T_sip0_main_Probe_Reserved_174 {
                    bits 32;
                    access rw;
                    hard_reset 'h0;
                }
            }
            register ccf_Probe_T_sip0_main_Probe_Reserved_175 @0x300 {
                bytes 4;
                field ccf_Probe_T_sip0_main_Probe_Reserved_175 {
                    bits 32;
                    access rw;
                    hard_reset 'h0;
                }
            }
            register ccf_Probe_T_sip0_main_Probe_Reserved_176 @0x304 {
                bytes 4;
                field ccf_Probe_T_sip0_main_Probe_Reserved_176 {
                    bits 32;
                    access rw;
                    hard_reset 'h0;
                }
            }
            register ccf_Probe_T_sip0_main_Probe_Reserved_177 @0x308 {
                bytes 4;
                field ccf_Probe_T_sip0_main_Probe_Reserved_177 {
                    bits 32;
                    access rw;
                    hard_reset 'h0;
                }
            }
            register ccf_Probe_T_sip0_main_Probe_Reserved_178 @0x30C {
                bytes 4;
                field ccf_Probe_T_sip0_main_Probe_Reserved_178 {
                    bits 32;
                    access rw;
                    hard_reset 'h0;
                }
            }
            register ccf_Probe_T_sip0_main_Probe_Reserved_179 @0x310 {
                bytes 4;
                field ccf_Probe_T_sip0_main_Probe_Reserved_179 {
                    bits 32;
                    access rw;
                    hard_reset 'h0;
                }
            }
            register ccf_Probe_T_sip0_main_Probe_Reserved_180 @0x314 {
                bytes 4;
                field ccf_Probe_T_sip0_main_Probe_Reserved_180 {
                    bits 32;
                    access rw;
                    hard_reset 'h0;
                }
            }
            register ccf_Probe_T_sip0_main_Probe_Reserved_181 @0x318 {
                bytes 4;
                field ccf_Probe_T_sip0_main_Probe_Reserved_181 {
                    bits 32;
                    access rw;
                    hard_reset 'h0;
                }
            }
            register ccf_Probe_T_sip0_main_Probe_Reserved_182 @0x31C {
                bytes 4;
                field ccf_Probe_T_sip0_main_Probe_Reserved_182 {
                    bits 32;
                    access rw;
                    hard_reset 'h0;
                }
            }
            register ccf_Probe_T_sip0_main_Probe_Reserved_183 @0x320 {
                bytes 4;
                field ccf_Probe_T_sip0_main_Probe_Reserved_183 {
                    bits 32;
                    access rw;
                    hard_reset 'h0;
                }
            }
            register ccf_Probe_T_sip0_main_Probe_Reserved_184 @0x324 {
                bytes 4;
                field ccf_Probe_T_sip0_main_Probe_Reserved_184 {
                    bits 32;
                    access rw;
                    hard_reset 'h0;
                }
            }
            register ccf_Probe_T_sip0_main_Probe_Reserved_185 @0x328 {
                bytes 4;
                field ccf_Probe_T_sip0_main_Probe_Reserved_185 {
                    bits 32;
                    access rw;
                    hard_reset 'h0;
                }
            }
            register ccf_Probe_T_sip0_main_Probe_Reserved_186 @0x32C {
                bytes 4;
                field ccf_Probe_T_sip0_main_Probe_Reserved_186 {
                    bits 32;
                    access rw;
                    hard_reset 'h0;
                }
            }
            register ccf_Probe_T_sip0_main_Probe_Reserved_187 @0x330 {
                bytes 4;
                field ccf_Probe_T_sip0_main_Probe_Reserved_187 {
                    bits 32;
                    access rw;
                    hard_reset 'h0;
                }
            }
            register ccf_Probe_T_sip0_main_Probe_Reserved_188 @0x334 {
                bytes 4;
                field ccf_Probe_T_sip0_main_Probe_Reserved_188 {
                    bits 32;
                    access rw;
                    hard_reset 'h0;
                }
            }
            register ccf_Probe_T_sip0_main_Probe_Reserved_189 @0x338 {
                bytes 4;
                field ccf_Probe_T_sip0_main_Probe_Reserved_189 {
                    bits 32;
                    access rw;
                    hard_reset 'h0;
                }
            }
            register ccf_Probe_T_sip0_main_Probe_Reserved_190 @0x33C {
                bytes 4;
                field ccf_Probe_T_sip0_main_Probe_Reserved_190 {
                    bits 32;
                    access rw;
                    hard_reset 'h0;
                }
            }
            register ccf_Probe_T_sip0_main_Probe_Reserved_191 @0x340 {
                bytes 4;
                field ccf_Probe_T_sip0_main_Probe_Reserved_191 {
                    bits 32;
                    access rw;
                    hard_reset 'h0;
                }
            }
            register ccf_Probe_T_sip0_main_Probe_Reserved_192 @0x344 {
                bytes 4;
                field ccf_Probe_T_sip0_main_Probe_Reserved_192 {
                    bits 32;
                    access rw;
                    hard_reset 'h0;
                }
            }
            register ccf_Probe_T_sip0_main_Probe_Reserved_193 @0x348 {
                bytes 4;
                field ccf_Probe_T_sip0_main_Probe_Reserved_193 {
                    bits 32;
                    access rw;
                    hard_reset 'h0;
                }
            }
            register ccf_Probe_T_sip0_main_Probe_Reserved_194 @0x34C {
                bytes 4;
                field ccf_Probe_T_sip0_main_Probe_Reserved_194 {
                    bits 32;
                    access rw;
                    hard_reset 'h0;
                }
            }
            register ccf_Probe_T_sip0_main_Probe_Reserved_195 @0x350 {
                bytes 4;
                field ccf_Probe_T_sip0_main_Probe_Reserved_195 {
                    bits 32;
                    access rw;
                    hard_reset 'h0;
                }
            }
            register ccf_Probe_T_sip0_main_Probe_Reserved_196 @0x354 {
                bytes 4;
                field ccf_Probe_T_sip0_main_Probe_Reserved_196 {
                    bits 32;
                    access rw;
                    hard_reset 'h0;
                }
            }
            register ccf_Probe_T_sip0_main_Probe_Reserved_197 @0x358 {
                bytes 4;
                field ccf_Probe_T_sip0_main_Probe_Reserved_197 {
                    bits 32;
                    access rw;
                    hard_reset 'h0;
                }
            }
            register ccf_Probe_T_sip0_main_Probe_Reserved_198 @0x35C {
                bytes 4;
                field ccf_Probe_T_sip0_main_Probe_Reserved_198 {
                    bits 32;
                    access rw;
                    hard_reset 'h0;
                }
            }
            register ccf_Probe_T_sip0_main_Probe_Reserved_199 @0x360 {
                bytes 4;
                field ccf_Probe_T_sip0_main_Probe_Reserved_199 {
                    bits 32;
                    access rw;
                    hard_reset 'h0;
                }
            }
            register ccf_Probe_T_sip0_main_Probe_Reserved_200 @0x364 {
                bytes 4;
                field ccf_Probe_T_sip0_main_Probe_Reserved_200 {
                    bits 32;
                    access rw;
                    hard_reset 'h0;
                }
            }
            register ccf_Probe_T_sip0_main_Probe_Reserved_201 @0x368 {
                bytes 4;
                field ccf_Probe_T_sip0_main_Probe_Reserved_201 {
                    bits 32;
                    access rw;
                    hard_reset 'h0;
                }
            }
            register ccf_Probe_T_sip0_main_Probe_Reserved_202 @0x36C {
                bytes 4;
                field ccf_Probe_T_sip0_main_Probe_Reserved_202 {
                    bits 32;
                    access rw;
                    hard_reset 'h0;
                }
            }
            register ccf_Probe_T_sip0_main_Probe_Reserved_203 @0x370 {
                bytes 4;
                field ccf_Probe_T_sip0_main_Probe_Reserved_203 {
                    bits 32;
                    access rw;
                    hard_reset 'h0;
                }
            }
            register ccf_Probe_T_sip0_main_Probe_Reserved_204 @0x374 {
                bytes 4;
                field ccf_Probe_T_sip0_main_Probe_Reserved_204 {
                    bits 32;
                    access rw;
                    hard_reset 'h0;
                }
            }
            register ccf_Probe_T_sip0_main_Probe_Reserved_205 @0x378 {
                bytes 4;
                field ccf_Probe_T_sip0_main_Probe_Reserved_205 {
                    bits 32;
                    access rw;
                    hard_reset 'h0;
                }
            }
            register ccf_Probe_T_sip0_main_Probe_Reserved_206 @0x37C {
                bytes 4;
                field ccf_Probe_T_sip0_main_Probe_Reserved_206 {
                    bits 32;
                    access rw;
                    hard_reset 'h0;
                }
            }
            register ccf_Probe_T_sip0_main_Probe_Reserved_207 @0x380 {
                bytes 4;
                field ccf_Probe_T_sip0_main_Probe_Reserved_207 {
                    bits 32;
                    access rw;
                    hard_reset 'h0;
                }
            }
            register ccf_Probe_T_sip0_main_Probe_Reserved_208 @0x384 {
                bytes 4;
                field ccf_Probe_T_sip0_main_Probe_Reserved_208 {
                    bits 32;
                    access rw;
                    hard_reset 'h0;
                }
            }
            register ccf_Probe_T_sip0_main_Probe_Reserved_209 @0x388 {
                bytes 4;
                field ccf_Probe_T_sip0_main_Probe_Reserved_209 {
                    bits 32;
                    access rw;
                    hard_reset 'h0;
                }
            }
            register ccf_Probe_T_sip0_main_Probe_Reserved_210 @0x38C {
                bytes 4;
                field ccf_Probe_T_sip0_main_Probe_Reserved_210 {
                    bits 32;
                    access rw;
                    hard_reset 'h0;
                }
            }
            register ccf_Probe_T_sip0_main_Probe_Reserved_211 @0x390 {
                bytes 4;
                field ccf_Probe_T_sip0_main_Probe_Reserved_211 {
                    bits 32;
                    access rw;
                    hard_reset 'h0;
                }
            }
            register ccf_Probe_T_sip0_main_Probe_Reserved_212 @0x394 {
                bytes 4;
                field ccf_Probe_T_sip0_main_Probe_Reserved_212 {
                    bits 32;
                    access rw;
                    hard_reset 'h0;
                }
            }
            register ccf_Probe_T_sip0_main_Probe_Reserved_213 @0x398 {
                bytes 4;
                field ccf_Probe_T_sip0_main_Probe_Reserved_213 {
                    bits 32;
                    access rw;
                    hard_reset 'h0;
                }
            }
            register ccf_Probe_T_sip0_main_Probe_Reserved_214 @0x39C {
                bytes 4;
                field ccf_Probe_T_sip0_main_Probe_Reserved_214 {
                    bits 32;
                    access rw;
                    hard_reset 'h0;
                }
            }
            register ccf_Probe_T_sip0_main_Probe_Reserved_215 @0x3A0 {
                bytes 4;
                field ccf_Probe_T_sip0_main_Probe_Reserved_215 {
                    bits 32;
                    access rw;
                    hard_reset 'h0;
                }
            }
            register ccf_Probe_T_sip0_main_Probe_Reserved_216 @0x3A4 {
                bytes 4;
                field ccf_Probe_T_sip0_main_Probe_Reserved_216 {
                    bits 32;
                    access rw;
                    hard_reset 'h0;
                }
            }
            register ccf_Probe_T_sip0_main_Probe_Reserved_217 @0x3A8 {
                bytes 4;
                field ccf_Probe_T_sip0_main_Probe_Reserved_217 {
                    bits 32;
                    access rw;
                    hard_reset 'h0;
                }
            }
            register ccf_Probe_T_sip0_main_Probe_Reserved_218 @0x3AC {
                bytes 4;
                field ccf_Probe_T_sip0_main_Probe_Reserved_218 {
                    bits 32;
                    access rw;
                    hard_reset 'h0;
                }
            }
            register ccf_Probe_T_sip0_main_Probe_Reserved_219 @0x3B0 {
                bytes 4;
                field ccf_Probe_T_sip0_main_Probe_Reserved_219 {
                    bits 32;
                    access rw;
                    hard_reset 'h0;
                }
            }
            register ccf_Probe_T_sip0_main_Probe_Reserved_220 @0x3B4 {
                bytes 4;
                field ccf_Probe_T_sip0_main_Probe_Reserved_220 {
                    bits 32;
                    access rw;
                    hard_reset 'h0;
                }
            }
            register ccf_Probe_T_sip0_main_Probe_Reserved_221 @0x3B8 {
                bytes 4;
                field ccf_Probe_T_sip0_main_Probe_Reserved_221 {
                    bits 32;
                    access rw;
                    hard_reset 'h0;
                }
            }
            register ccf_Probe_T_sip0_main_Probe_Reserved_222 @0x3BC {
                bytes 4;
                field ccf_Probe_T_sip0_main_Probe_Reserved_222 {
                    bits 32;
                    access rw;
                    hard_reset 'h0;
                }
            }
            register ccf_Probe_T_sip0_main_Probe_Reserved_223 @0x3C0 {
                bytes 4;
                field ccf_Probe_T_sip0_main_Probe_Reserved_223 {
                    bits 32;
                    access rw;
                    hard_reset 'h0;
                }
            }
            register ccf_Probe_T_sip0_main_Probe_Reserved_224 @0x3C4 {
                bytes 4;
                field ccf_Probe_T_sip0_main_Probe_Reserved_224 {
                    bits 32;
                    access rw;
                    hard_reset 'h0;
                }
            }
            register ccf_Probe_T_sip0_main_Probe_Reserved_225 @0x3C8 {
                bytes 4;
                field ccf_Probe_T_sip0_main_Probe_Reserved_225 {
                    bits 32;
                    access rw;
                    hard_reset 'h0;
                }
            }
            register ccf_Probe_T_sip0_main_Probe_Reserved_226 @0x3CC {
                bytes 4;
                field ccf_Probe_T_sip0_main_Probe_Reserved_226 {
                    bits 32;
                    access rw;
                    hard_reset 'h0;
                }
            }
            register ccf_Probe_T_sip0_main_Probe_Reserved_227 @0x3D0 {
                bytes 4;
                field ccf_Probe_T_sip0_main_Probe_Reserved_227 {
                    bits 32;
                    access rw;
                    hard_reset 'h0;
                }
            }
            register ccf_Probe_T_sip0_main_Probe_Reserved_228 @0x3D4 {
                bytes 4;
                field ccf_Probe_T_sip0_main_Probe_Reserved_228 {
                    bits 32;
                    access rw;
                    hard_reset 'h0;
                }
            }
            register ccf_Probe_T_sip0_main_Probe_Reserved_229 @0x3D8 {
                bytes 4;
                field ccf_Probe_T_sip0_main_Probe_Reserved_229 {
                    bits 32;
                    access rw;
                    hard_reset 'h0;
                }
            }
            register ccf_Probe_T_sip0_main_Probe_Reserved_230 @0x3DC {
                bytes 4;
                field ccf_Probe_T_sip0_main_Probe_Reserved_230 {
                    bits 32;
                    access rw;
                    hard_reset 'h0;
                }
            }
            register ccf_Probe_T_sip0_main_Probe_Reserved_231 @0x3E0 {
                bytes 4;
                field ccf_Probe_T_sip0_main_Probe_Reserved_231 {
                    bits 32;
                    access rw;
                    hard_reset 'h0;
                }
            }
            register ccf_Probe_T_sip0_main_Probe_Reserved_232 @0x3E4 {
                bytes 4;
                field ccf_Probe_T_sip0_main_Probe_Reserved_232 {
                    bits 32;
                    access rw;
                    hard_reset 'h0;
                }
            }
            register ccf_Probe_T_sip0_main_Probe_Reserved_233 @0x3E8 {
                bytes 4;
                field ccf_Probe_T_sip0_main_Probe_Reserved_233 {
                    bits 32;
                    access rw;
                    hard_reset 'h0;
                }
            }
            register ccf_Probe_T_sip0_main_Probe_Reserved_234 @0x3EC {
                bytes 4;
                field ccf_Probe_T_sip0_main_Probe_Reserved_234 {
                    bits 32;
                    access rw;
                    hard_reset 'h0;
                }
            }
            register ccf_Probe_T_sip0_main_Probe_Reserved_235 @0x3F0 {
                bytes 4;
                field ccf_Probe_T_sip0_main_Probe_Reserved_235 {
                    bits 32;
                    access rw;
                    hard_reset 'h0;
                }
            }
            register ccf_Probe_T_sip0_main_Probe_Reserved_236 @0x3F4 {
                bytes 4;
                field ccf_Probe_T_sip0_main_Probe_Reserved_236 {
                    bits 32;
                    access rw;
                    hard_reset 'h0;
                }
            }
            register ccf_Probe_T_sip0_main_Probe_Reserved_237 @0x3F8 {
                bytes 4;
                field ccf_Probe_T_sip0_main_Probe_Reserved_237 {
                    bits 32;
                    access rw;
                    hard_reset 'h0;
                }
            }
            register ccf_Probe_T_sip0_main_Probe_Reserved_238 @0x3FC {
                bytes 4;
                field ccf_Probe_T_sip0_main_Probe_Reserved_238 {
                    bits 32;
                    access rw;
                    hard_reset 'h0;
                }
            }
        }
        block ecf_ccf_axi_ccf_Probe_T_sip1_main_Probe @0xD9400 {
            bytes 4;
            register ccf_Probe_T_sip1_main_Probe_Id_CoreId @0x0 {
                bytes 4;
                field CORETYPEID @'h0 {
                    bits 8;
                    access ro;
                    hard_reset 'h6;
                    doc {
                        Field identifying the type of IP.
                    }
                }
                field CORECHECKSUM @'h8 {
                    bits 24;
                    access ro;
                    hard_reset 'h39e793;
                    doc {
                        Field containing a checksum of the parameters of the IP.
                    }
                }
            }
            register ccf_Probe_T_sip1_main_Probe_Id_RevisionId @0x4 {
                bytes 4;
                field USERID @'h0 {
                    bits 8;
                    access ro;
                    hard_reset 'h0;
                    doc {
                        Field containing a user defined value, not used anywhere inside the IP itself.
                    }
                }
                field FLEXNOCID @'h8 {
                    bits 24;
                    access ro;
                    hard_reset 'h84f8c6;
                    doc {
                        Field containing the build revision of the software used to generate the IP HDL code.
                    }
                }
            }
            register ccf_Probe_T_sip1_main_Probe_MainCtl @0x8 {
                bytes 4;
                field ERREN @'h0 {
                    access rw;
                    hard_reset 'h0;
                    doc {
                        Register field ErrEn enables the probe to send on the ObsTx output any packet with Error status, independently of filtering mechanisms, thus constituting a simple supplementary global filter.
                    }
                }
                field TRACEEN @'h1 {
                    access ro;
                    hard_reset 'h0;
                    doc {
                        Register field TraceEn enables the probe to send filtered packets (Trace) on the ObsTx observation output.
                    }
                }
                field PAYLOADEN @'h2 {
                    access rw;
                    hard_reset 'h0;
                    doc {
                        Register field PayloadEn, when set to 1, enables traces to contain headers and payload. When set ot 0, only headers are reported.
                    }
                }
                field STATEN @'h3 {
                    access rw;
                    hard_reset 'h0;
                    doc {
                        When set to 1, register field StatEn enables statistics profiling. The probe sendS statistics results to the output for signal ObsTx. All statistics counters are cleared when the StatEn bit goes from 0 to 1. When set to 0, counters are disabled.
                    }
                }
                field ALARMEN @'h4 {
                    access rw;
                    hard_reset 'h0;
                    doc {
                        When set, register field AlarmEn enables the probe to collect alarm-related information. When the register field bit is null, both TraceAlarm and StatAlarm outputs are driven to 0.
                    }
                }
                field STATCONDDUMP @'h5 {
                    access rw;
                    hard_reset 'h0;
                    doc {
                        When set, register field StatCondDump enables the dump of a statistics frame to the range of counter values set for registers StatAlarmMin, StatAlarmMax, and AlarmMode. This field also renders register StatAlarmStatus inoperative. When parameter statisticsCounterAlarm is set to False, the StatCondDump register bit is reserved.
                    }
                }
                field INTRUSIVEMODE @'h6 {
                    access ro;
                    hard_reset 'h0;
                    doc {
                        When set to 1, register field IntrusiveMode enables trace operation in Intrusive flow-control mode. When set to 0, the register  enables trace operation in Overflow flow-control mode
                    }
                }
                field FILTBYTEALWAYSCHAINABLEEN @'h7 {
                    access rw;
                    hard_reset 'h0;
                    doc {
                        When set to 0, filters are mapped to all statistic counters when counting bytes or enabled bytes. Therefore, only filter events mapped to even counters can be counted using a pair of chained counters.When set to 1, filters are mapped only to even statistic counters when counting bytes or enabled bytes. Thus events from any filter can be counted using a pair of chained counters.
                    }
                }
                doc {
                    Register MainCtl contains probe global control bits. The register has seven bit fields:Register MainCtl contains probe global control bits. The register has seven bit fields:
                }
            }
            register ccf_Probe_T_sip1_main_Probe_CfgCtl @0xC {
                bytes 4;
                field GLOBALEN @'h0 {
                    access rw;
                    hard_reset 'h0;
                }
                field ACTIVE @'h1 {
                    access ro;
                    hard_reset 'h0;
                }
            }
            register ccf_Probe_T_sip1_main_Probe_Reserved_00 @0x10 {
                bytes 4;
                field ccf_Probe_T_sip1_main_Probe_Reserved_00 {
                    bits 32;
                    access rw;
                    hard_reset 'h0;
                }
            }
            register ccf_Probe_T_sip1_main_Probe_Reserved_01 @0x14 {
                bytes 4;
                field ccf_Probe_T_sip1_main_Probe_Reserved_01 {
                    bits 32;
                    access rw;
                    hard_reset 'h0;
                }
            }
            register ccf_Probe_T_sip1_main_Probe_Reserved_02 @0x18 {
                bytes 4;
                field ccf_Probe_T_sip1_main_Probe_Reserved_02 {
                    bits 32;
                    access rw;
                    hard_reset 'h0;
                }
            }
            register ccf_Probe_T_sip1_main_Probe_Reserved_03 @0x1C {
                bytes 4;
                field ccf_Probe_T_sip1_main_Probe_Reserved_03 {
                    bits 32;
                    access rw;
                    hard_reset 'h0;
                }
            }
            register ccf_Probe_T_sip1_main_Probe_Reserved_04 @0x20 {
                bytes 4;
                field ccf_Probe_T_sip1_main_Probe_Reserved_04 {
                    bits 32;
                    access rw;
                    hard_reset 'h0;
                }
            }
            register ccf_Probe_T_sip1_main_Probe_StatPeriod @0x24 {
                bytes 4;
                field STATPERIOD @'h0 {
                    bits 5;
                    access rw;
                    hard_reset 'h0;
                    doc {
                        Register StatPeriod is a 5-bit register that sets a period, within a range of 2 cycles to 2 gigacycles, during which statistics are collected before being dumped automatically. Setting the register implicitly enables automatic mode operation for statistics collection. The period is calculated with the formula: N_Cycle = 2**StatPeriodWhen register StatPeriod is set to its default value 0, automatic dump mode is disabled, and register StatGo is activated for manual mode operation. Note: When parameter statisticsCollection is set to False, StatPeriod is reserved.
                    }
                }
            }
            register ccf_Probe_T_sip1_main_Probe_StatGo @0x28 {
                bytes 4;
                field STATGO @'h0 {
                    access w1c;
                    hard_reset 'h0;
                    doc {
                        Writing a 1 to the 1-bit pulse register StatGo generates a statistics dump.The register is active when statistics collection operates in manual mode, that is, when register StatPeriod is set to 0.NOTE  The written value is not stored in StatGo. A read always returns 0.
                    }
                }
            }
            register ccf_Probe_T_sip1_main_Probe_StatAlarmMin @0x2C {
                bytes 4;
                field STATALARMMIN @'h0 {
                    bits 22;
                    access rw;
                    hard_reset 'h0;
                    doc {
                        Register StatAlarmMin contains the minimum count value used in statistics alarm comparisons. The number of bits is equal to twice the value set forparameter wStatisticsCounter. When parameter statisticsCounterAlarm is set to False, StatAlarmMin is reserved.
                    }
                }
            }
            register ccf_Probe_T_sip1_main_Probe_StatAlarmMax @0x30 {
                bytes 4;
                field STATALARMMAX @'h0 {
                    bits 22;
                    access rw;
                    hard_reset 'h0;
                    doc {
                        Register StatAlarmMax contains the maximum count value used in statistics alarm comparisons.The number of bits is equal to twice the value set for parameter wStatisticsCounter. When parameter statisticsCounterAlarm is set to False, StatAlarmMax is reserved.
                    }
                }
            }
            register ccf_Probe_T_sip1_main_Probe_StatAlarmStatus @0x34 {
                bytes 4;
                field STATALARMSTATUS @'h0 {
                    access ro;
                    hard_reset 'h0;
                    doc {
                        Register StatAlarmStatus is a read-only 1-bit register indicating that at least one statistics counter has exceeded the programmed values for registers StatAlarmMin or StatAlarmMax. Output signal StatAlarm is equal to the values stored in register MainCtl fields StatAlarmStatus and AlarmEn. When parameter statisticsCounterAlarm is set to False, StatAlarmStatus is reserved.
                    }
                }
            }
            register ccf_Probe_T_sip1_main_Probe_StatAlarmClr @0x38 {
                bytes 4;
                field STATALARMCLR @'h0 {
                    access w1c;
                    hard_reset 'h0;
                    doc {
                        Register StatAlarmClr is a 1-bit register. Writing a 1 to this register clears the StatAlarmStatus register bit.When parameter statisticsCounterAlarm is set to False, StatAlarmClr is reserved.NOTE  The written value is not stored in StatAlarmClr. A read always returns 0.
                    }
                }
            }
            register ccf_Probe_T_sip1_main_Probe_StatAlarmEn @0x3C {
                bytes 4;
                field STATALARMEN @'h0 {
                    access rw;
                    hard_reset 'h1;
                    doc {
                        Register StatAlarmEn is a 1-bit register. When set to 0 it masks StatAlarm and CtiTrigOut(1) signal interrupts.
                    }
                }
            }
            register ccf_Probe_T_sip1_main_Probe_Reserved_05 @0x40 {
                bytes 4;
                field ccf_Probe_T_sip1_main_Probe_Reserved_05 {
                    bits 32;
                    access rw;
                    hard_reset 'h0;
                }
            }
            register ccf_Probe_T_sip1_main_Probe_Reserved_06 @0x44 {
                bytes 4;
                field ccf_Probe_T_sip1_main_Probe_Reserved_06 {
                    bits 32;
                    access rw;
                    hard_reset 'h0;
                }
            }
            register ccf_Probe_T_sip1_main_Probe_Reserved_07 @0x48 {
                bytes 4;
                field ccf_Probe_T_sip1_main_Probe_Reserved_07 {
                    bits 32;
                    access rw;
                    hard_reset 'h0;
                }
            }
            register ccf_Probe_T_sip1_main_Probe_Reserved_08 @0x4C {
                bytes 4;
                field ccf_Probe_T_sip1_main_Probe_Reserved_08 {
                    bits 32;
                    access rw;
                    hard_reset 'h0;
                }
            }
            register ccf_Probe_T_sip1_main_Probe_Reserved_09 @0x50 {
                bytes 4;
                field ccf_Probe_T_sip1_main_Probe_Reserved_09 {
                    bits 32;
                    access rw;
                    hard_reset 'h0;
                }
            }
            register ccf_Probe_T_sip1_main_Probe_Reserved_10 @0x54 {
                bytes 4;
                field ccf_Probe_T_sip1_main_Probe_Reserved_10 {
                    bits 32;
                    access rw;
                    hard_reset 'h0;
                }
            }
            register ccf_Probe_T_sip1_main_Probe_Reserved_11 @0x58 {
                bytes 4;
                field ccf_Probe_T_sip1_main_Probe_Reserved_11 {
                    bits 32;
                    access rw;
                    hard_reset 'h0;
                }
            }
            register ccf_Probe_T_sip1_main_Probe_Reserved_12 @0x5C {
                bytes 4;
                field ccf_Probe_T_sip1_main_Probe_Reserved_12 {
                    bits 32;
                    access rw;
                    hard_reset 'h0;
                }
            }
            register ccf_Probe_T_sip1_main_Probe_Reserved_13 @0x60 {
                bytes 4;
                field ccf_Probe_T_sip1_main_Probe_Reserved_13 {
                    bits 32;
                    access rw;
                    hard_reset 'h0;
                }
            }
            register ccf_Probe_T_sip1_main_Probe_Reserved_14 @0x64 {
                bytes 4;
                field ccf_Probe_T_sip1_main_Probe_Reserved_14 {
                    bits 32;
                    access rw;
                    hard_reset 'h0;
                }
            }
            register ccf_Probe_T_sip1_main_Probe_Reserved_15 @0x68 {
                bytes 4;
                field ccf_Probe_T_sip1_main_Probe_Reserved_15 {
                    bits 32;
                    access rw;
                    hard_reset 'h0;
                }
            }
            register ccf_Probe_T_sip1_main_Probe_Reserved_16 @0x6C {
                bytes 4;
                field ccf_Probe_T_sip1_main_Probe_Reserved_16 {
                    bits 32;
                    access rw;
                    hard_reset 'h0;
                }
            }
            register ccf_Probe_T_sip1_main_Probe_Reserved_17 @0x70 {
                bytes 4;
                field ccf_Probe_T_sip1_main_Probe_Reserved_17 {
                    bits 32;
                    access rw;
                    hard_reset 'h0;
                }
            }
            register ccf_Probe_T_sip1_main_Probe_Reserved_18 @0x74 {
                bytes 4;
                field ccf_Probe_T_sip1_main_Probe_Reserved_18 {
                    bits 32;
                    access rw;
                    hard_reset 'h0;
                }
            }
            register ccf_Probe_T_sip1_main_Probe_Reserved_19 @0x78 {
                bytes 4;
                field ccf_Probe_T_sip1_main_Probe_Reserved_19 {
                    bits 32;
                    access rw;
                    hard_reset 'h0;
                }
            }
            register ccf_Probe_T_sip1_main_Probe_Reserved_20 @0x7C {
                bytes 4;
                field ccf_Probe_T_sip1_main_Probe_Reserved_20 {
                    bits 32;
                    access rw;
                    hard_reset 'h0;
                }
            }
            register ccf_Probe_T_sip1_main_Probe_Reserved_21 @0x80 {
                bytes 4;
                field ccf_Probe_T_sip1_main_Probe_Reserved_21 {
                    bits 32;
                    access rw;
                    hard_reset 'h0;
                }
            }
            register ccf_Probe_T_sip1_main_Probe_Reserved_22 @0x84 {
                bytes 4;
                field ccf_Probe_T_sip1_main_Probe_Reserved_22 {
                    bits 32;
                    access rw;
                    hard_reset 'h0;
                }
            }
            register ccf_Probe_T_sip1_main_Probe_Reserved_23 @0x88 {
                bytes 4;
                field ccf_Probe_T_sip1_main_Probe_Reserved_23 {
                    bits 32;
                    access rw;
                    hard_reset 'h0;
                }
            }
            register ccf_Probe_T_sip1_main_Probe_Reserved_24 @0x8C {
                bytes 4;
                field ccf_Probe_T_sip1_main_Probe_Reserved_24 {
                    bits 32;
                    access rw;
                    hard_reset 'h0;
                }
            }
            register ccf_Probe_T_sip1_main_Probe_Reserved_25 @0x90 {
                bytes 4;
                field ccf_Probe_T_sip1_main_Probe_Reserved_25 {
                    bits 32;
                    access rw;
                    hard_reset 'h0;
                }
            }
            register ccf_Probe_T_sip1_main_Probe_Reserved_26 @0x94 {
                bytes 4;
                field ccf_Probe_T_sip1_main_Probe_Reserved_26 {
                    bits 32;
                    access rw;
                    hard_reset 'h0;
                }
            }
            register ccf_Probe_T_sip1_main_Probe_Reserved_27 @0x98 {
                bytes 4;
                field ccf_Probe_T_sip1_main_Probe_Reserved_27 {
                    bits 32;
                    access rw;
                    hard_reset 'h0;
                }
            }
            register ccf_Probe_T_sip1_main_Probe_Reserved_28 @0x9C {
                bytes 4;
                field ccf_Probe_T_sip1_main_Probe_Reserved_28 {
                    bits 32;
                    access rw;
                    hard_reset 'h0;
                }
            }
            register ccf_Probe_T_sip1_main_Probe_Reserved_29 @0xA0 {
                bytes 4;
                field ccf_Probe_T_sip1_main_Probe_Reserved_29 {
                    bits 32;
                    access rw;
                    hard_reset 'h0;
                }
            }
            register ccf_Probe_T_sip1_main_Probe_Reserved_30 @0xA4 {
                bytes 4;
                field ccf_Probe_T_sip1_main_Probe_Reserved_30 {
                    bits 32;
                    access rw;
                    hard_reset 'h0;
                }
            }
            register ccf_Probe_T_sip1_main_Probe_Reserved_31 @0xA8 {
                bytes 4;
                field ccf_Probe_T_sip1_main_Probe_Reserved_31 {
                    bits 32;
                    access rw;
                    hard_reset 'h0;
                }
            }
            register ccf_Probe_T_sip1_main_Probe_Reserved_32 @0xAC {
                bytes 4;
                field ccf_Probe_T_sip1_main_Probe_Reserved_32 {
                    bits 32;
                    access rw;
                    hard_reset 'h0;
                }
            }
            register ccf_Probe_T_sip1_main_Probe_Reserved_33 @0xB0 {
                bytes 4;
                field ccf_Probe_T_sip1_main_Probe_Reserved_33 {
                    bits 32;
                    access rw;
                    hard_reset 'h0;
                }
            }
            register ccf_Probe_T_sip1_main_Probe_Reserved_34 @0xB4 {
                bytes 4;
                field ccf_Probe_T_sip1_main_Probe_Reserved_34 {
                    bits 32;
                    access rw;
                    hard_reset 'h0;
                }
            }
            register ccf_Probe_T_sip1_main_Probe_Reserved_35 @0xB8 {
                bytes 4;
                field ccf_Probe_T_sip1_main_Probe_Reserved_35 {
                    bits 32;
                    access rw;
                    hard_reset 'h0;
                }
            }
            register ccf_Probe_T_sip1_main_Probe_Reserved_36 @0xBC {
                bytes 4;
                field ccf_Probe_T_sip1_main_Probe_Reserved_36 {
                    bits 32;
                    access rw;
                    hard_reset 'h0;
                }
            }
            register ccf_Probe_T_sip1_main_Probe_Reserved_37 @0xC0 {
                bytes 4;
                field ccf_Probe_T_sip1_main_Probe_Reserved_37 {
                    bits 32;
                    access rw;
                    hard_reset 'h0;
                }
            }
            register ccf_Probe_T_sip1_main_Probe_Reserved_38 @0xC4 {
                bytes 4;
                field ccf_Probe_T_sip1_main_Probe_Reserved_38 {
                    bits 32;
                    access rw;
                    hard_reset 'h0;
                }
            }
            register ccf_Probe_T_sip1_main_Probe_Reserved_39 @0xC8 {
                bytes 4;
                field ccf_Probe_T_sip1_main_Probe_Reserved_39 {
                    bits 32;
                    access rw;
                    hard_reset 'h0;
                }
            }
            register ccf_Probe_T_sip1_main_Probe_Reserved_40 @0xCC {
                bytes 4;
                field ccf_Probe_T_sip1_main_Probe_Reserved_40 {
                    bits 32;
                    access rw;
                    hard_reset 'h0;
                }
            }
            register ccf_Probe_T_sip1_main_Probe_Reserved_41 @0xD0 {
                bytes 4;
                field ccf_Probe_T_sip1_main_Probe_Reserved_41 {
                    bits 32;
                    access rw;
                    hard_reset 'h0;
                }
            }
            register ccf_Probe_T_sip1_main_Probe_Reserved_42 @0xD4 {
                bytes 4;
                field ccf_Probe_T_sip1_main_Probe_Reserved_42 {
                    bits 32;
                    access rw;
                    hard_reset 'h0;
                }
            }
            register ccf_Probe_T_sip1_main_Probe_Reserved_43 @0xD8 {
                bytes 4;
                field ccf_Probe_T_sip1_main_Probe_Reserved_43 {
                    bits 32;
                    access rw;
                    hard_reset 'h0;
                }
            }
            register ccf_Probe_T_sip1_main_Probe_Reserved_44 @0xDC {
                bytes 4;
                field ccf_Probe_T_sip1_main_Probe_Reserved_44 {
                    bits 32;
                    access rw;
                    hard_reset 'h0;
                }
            }
            register ccf_Probe_T_sip1_main_Probe_Reserved_45 @0xE0 {
                bytes 4;
                field ccf_Probe_T_sip1_main_Probe_Reserved_45 {
                    bits 32;
                    access rw;
                    hard_reset 'h0;
                }
            }
            register ccf_Probe_T_sip1_main_Probe_Reserved_46 @0xE4 {
                bytes 4;
                field ccf_Probe_T_sip1_main_Probe_Reserved_46 {
                    bits 32;
                    access rw;
                    hard_reset 'h0;
                }
            }
            register ccf_Probe_T_sip1_main_Probe_Reserved_47 @0xE8 {
                bytes 4;
                field ccf_Probe_T_sip1_main_Probe_Reserved_47 {
                    bits 32;
                    access rw;
                    hard_reset 'h0;
                }
            }
            register ccf_Probe_T_sip1_main_Probe_Reserved_48 @0xEC {
                bytes 4;
                field ccf_Probe_T_sip1_main_Probe_Reserved_48 {
                    bits 32;
                    access rw;
                    hard_reset 'h0;
                }
            }
            register ccf_Probe_T_sip1_main_Probe_Reserved_49 @0xF0 {
                bytes 4;
                field ccf_Probe_T_sip1_main_Probe_Reserved_49 {
                    bits 32;
                    access rw;
                    hard_reset 'h0;
                }
            }
            register ccf_Probe_T_sip1_main_Probe_Reserved_50 @0xF4 {
                bytes 4;
                field ccf_Probe_T_sip1_main_Probe_Reserved_50 {
                    bits 32;
                    access rw;
                    hard_reset 'h0;
                }
            }
            register ccf_Probe_T_sip1_main_Probe_Reserved_51 @0xF8 {
                bytes 4;
                field ccf_Probe_T_sip1_main_Probe_Reserved_51 {
                    bits 32;
                    access rw;
                    hard_reset 'h0;
                }
            }
            register ccf_Probe_T_sip1_main_Probe_Reserved_52 @0xFC {
                bytes 4;
                field ccf_Probe_T_sip1_main_Probe_Reserved_52 {
                    bits 32;
                    access rw;
                    hard_reset 'h0;
                }
            }
            register ccf_Probe_T_sip1_main_Probe_Reserved_53 @0x100 {
                bytes 4;
                field ccf_Probe_T_sip1_main_Probe_Reserved_53 {
                    bits 32;
                    access rw;
                    hard_reset 'h0;
                }
            }
            register ccf_Probe_T_sip1_main_Probe_Reserved_54 @0x104 {
                bytes 4;
                field ccf_Probe_T_sip1_main_Probe_Reserved_54 {
                    bits 32;
                    access rw;
                    hard_reset 'h0;
                }
            }
            register ccf_Probe_T_sip1_main_Probe_Reserved_55 @0x108 {
                bytes 4;
                field ccf_Probe_T_sip1_main_Probe_Reserved_55 {
                    bits 32;
                    access rw;
                    hard_reset 'h0;
                }
            }
            register ccf_Probe_T_sip1_main_Probe_Reserved_56 @0x10C {
                bytes 4;
                field ccf_Probe_T_sip1_main_Probe_Reserved_56 {
                    bits 32;
                    access rw;
                    hard_reset 'h0;
                }
            }
            register ccf_Probe_T_sip1_main_Probe_Reserved_57 @0x110 {
                bytes 4;
                field ccf_Probe_T_sip1_main_Probe_Reserved_57 {
                    bits 32;
                    access rw;
                    hard_reset 'h0;
                }
            }
            register ccf_Probe_T_sip1_main_Probe_Reserved_58 @0x114 {
                bytes 4;
                field ccf_Probe_T_sip1_main_Probe_Reserved_58 {
                    bits 32;
                    access rw;
                    hard_reset 'h0;
                }
            }
            register ccf_Probe_T_sip1_main_Probe_Reserved_59 @0x118 {
                bytes 4;
                field ccf_Probe_T_sip1_main_Probe_Reserved_59 {
                    bits 32;
                    access rw;
                    hard_reset 'h0;
                }
            }
            register ccf_Probe_T_sip1_main_Probe_Reserved_60 @0x11C {
                bytes 4;
                field ccf_Probe_T_sip1_main_Probe_Reserved_60 {
                    bits 32;
                    access rw;
                    hard_reset 'h0;
                }
            }
            register ccf_Probe_T_sip1_main_Probe_Reserved_61 @0x120 {
                bytes 4;
                field ccf_Probe_T_sip1_main_Probe_Reserved_61 {
                    bits 32;
                    access rw;
                    hard_reset 'h0;
                }
            }
            register ccf_Probe_T_sip1_main_Probe_Reserved_62 @0x124 {
                bytes 4;
                field ccf_Probe_T_sip1_main_Probe_Reserved_62 {
                    bits 32;
                    access rw;
                    hard_reset 'h0;
                }
            }
            register ccf_Probe_T_sip1_main_Probe_Reserved_63 @0x128 {
                bytes 4;
                field ccf_Probe_T_sip1_main_Probe_Reserved_63 {
                    bits 32;
                    access rw;
                    hard_reset 'h0;
                }
            }
            register ccf_Probe_T_sip1_main_Probe_Reserved_64 @0x12C {
                bytes 4;
                field ccf_Probe_T_sip1_main_Probe_Reserved_64 {
                    bits 32;
                    access rw;
                    hard_reset 'h0;
                }
            }
            register ccf_Probe_T_sip1_main_Probe_Reserved_65 @0x130 {
                bytes 4;
                field ccf_Probe_T_sip1_main_Probe_Reserved_65 {
                    bits 32;
                    access rw;
                    hard_reset 'h0;
                }
            }
            register ccf_Probe_T_sip1_main_Probe_Reserved_66 @0x134 {
                bytes 4;
                field ccf_Probe_T_sip1_main_Probe_Reserved_66 {
                    bits 32;
                    access rw;
                    hard_reset 'h0;
                }
            }
            register ccf_Probe_T_sip1_main_Probe_Counters_0_Src @0x138 {
                bytes 4;
                field INTEVENT @'h0 {
                    bits 5;
                    access rw;
                    hard_reset 'h0;
                    enum { OFF = 0, CYCLE = 1, IDLE = 2, XFER = 3, BUSY = 4, WAIT = 5, PKT = 6, LUT = 7, BYTE = 8, PRESS0 = 9, PRESS1 = 10, PRESS2 = 11, FILT0 = 12, FILT1 = 13, FILT2 = 14, FILT3 = 15, CHAIN = 16, LUT_BYTE_EN = 17, LUT_BYTE = 18, FILT_BYTE_EN = 19, FILT_BYTE = 20, PRESS3 = 21, PRESS4 = 22, PRESS5 = 23, PRESS6 = 24, RSV_0 = 25, RSV_1 = 26, RSV_2 = 27, RSV_3 = 28, RSV_4 = 29, RSV_5 = 30, RSV_6 = 31 };
                    doc {
                        Internal packet event
                    }
                }
                field EXTEVENT @'h5 {
                    access rw;
                    hard_reset 'h0;
                    doc {
                        When greater than 0, the entire register value is used to select an external hardware event source. The index of the external event is equal to {ExtEvent,IntEvent}.
                    }
                }
                doc {
                    Register CntSrc indicates the event source used to increment the counter. Unassigned values (non-existing Press level or ExtEvent index, or unimplemented Filter) are equivalent to OFF.
	Register CntSrc indicates the event source used to increment the counter. Unassigned values (non-existing Press level or ExtEvent index, or unimplemented Filter) are equivalent to OFF.
	
                }
            }
            register ccf_Probe_T_sip1_main_Probe_Counters_0_AlarmMode @0x13C {
                bytes 4;
                field COUNTERS_0_ALARMMODE @'h0 {
                    bits 2;
                    access rw;
                    hard_reset 'h0;
                    enum { OFF = 0, MIN = 1, MAX = 2, MIN_MAX = 3 };
                    doc {
                        Register AlarmMode is a 2-bit register that is present when parameter statisticsCounterAlarm is set to True. The register defines the statistics-alarm behavior of the counter.
                    }
                }
            }
            register ccf_Probe_T_sip1_main_Probe_Counters_0_Val @0x140 {
                bytes 4;
                field COUNTERS_0_VAL @'h0 {
                    bits 11;
                    access ro;
                    hard_reset 'h0;
                    doc {
                        Register Val is a read-only register that is always present. The register containsthe statistics counter value either pending StatAlarm output, or when statisticscollection is suspended subsequent to triggers or signal statSuspend.
                    }
                }
            }
            register ccf_Probe_T_sip1_main_Probe_Reserved_67 @0x144 {
                bytes 4;
                field ccf_Probe_T_sip1_main_Probe_Reserved_67 {
                    bits 32;
                    access rw;
                    hard_reset 'h0;
                }
            }
            register ccf_Probe_T_sip1_main_Probe_Reserved_68 @0x148 {
                bytes 4;
                field ccf_Probe_T_sip1_main_Probe_Reserved_68 {
                    bits 32;
                    access rw;
                    hard_reset 'h0;
                }
            }
            register ccf_Probe_T_sip1_main_Probe_Counters_1_Src @0x14C {
                bytes 4;
                field INTEVENT @'h0 {
                    bits 5;
                    access rw;
                    hard_reset 'h0;
                    enum { OFF = 0, CYCLE = 1, IDLE = 2, XFER = 3, BUSY = 4, WAIT = 5, PKT = 6, LUT = 7, BYTE = 8, PRESS0 = 9, PRESS1 = 10, PRESS2 = 11, FILT0 = 12, FILT1 = 13, FILT2 = 14, FILT3 = 15, CHAIN = 16, LUT_BYTE_EN = 17, LUT_BYTE = 18, FILT_BYTE_EN = 19, FILT_BYTE = 20, PRESS3 = 21, PRESS4 = 22, PRESS5 = 23, PRESS6 = 24, RSV_0 = 25, RSV_1 = 26, RSV_2 = 27, RSV_3 = 28, RSV_4 = 29, RSV_5 = 30, RSV_6 = 31 };
                    doc {
                        Internal packet event
                    }
                }
                field EXTEVENT @'h5 {
                    access rw;
                    hard_reset 'h0;
                    doc {
                        When greater than 0, the entire register value is used to select an external hardware event source. The index of the external event is equal to {ExtEvent,IntEvent}.
                    }
                }
                doc {
                    Register CntSrc indicates the event source used to increment the counter. Unassigned values (non-existing Press level or ExtEvent index, or unimplemented Filter) are equivalent to OFF.
	Register CntSrc indicates the event source used to increment the counter. Unassigned values (non-existing Press level or ExtEvent index, or unimplemented Filter) are equivalent to OFF.
	
                }
            }
            register ccf_Probe_T_sip1_main_Probe_Counters_1_AlarmMode @0x150 {
                bytes 4;
                field COUNTERS_1_ALARMMODE @'h0 {
                    bits 2;
                    access rw;
                    hard_reset 'h0;
                    enum { OFF = 0, MIN = 1, MAX = 2, MIN_MAX = 3 };
                    doc {
                        Register AlarmMode is a 2-bit register that is present when parameter statisticsCounterAlarm is set to True. The register defines the statistics-alarm behavior of the counter.
                    }
                }
            }
            register ccf_Probe_T_sip1_main_Probe_Counters_1_Val @0x154 {
                bytes 4;
                field COUNTERS_1_VAL @'h0 {
                    bits 11;
                    access ro;
                    hard_reset 'h0;
                    doc {
                        Register Val is a read-only register that is always present. The register containsthe statistics counter value either pending StatAlarm output, or when statisticscollection is suspended subsequent to triggers or signal statSuspend.
                    }
                }
            }
            register ccf_Probe_T_sip1_main_Probe_Reserved_69 @0x158 {
                bytes 4;
                field ccf_Probe_T_sip1_main_Probe_Reserved_69 {
                    bits 32;
                    access rw;
                    hard_reset 'h0;
                }
            }
            register ccf_Probe_T_sip1_main_Probe_Reserved_70 @0x15C {
                bytes 4;
                field ccf_Probe_T_sip1_main_Probe_Reserved_70 {
                    bits 32;
                    access rw;
                    hard_reset 'h0;
                }
            }
            register ccf_Probe_T_sip1_main_Probe_Reserved_71 @0x160 {
                bytes 4;
                field ccf_Probe_T_sip1_main_Probe_Reserved_71 {
                    bits 32;
                    access rw;
                    hard_reset 'h0;
                }
            }
            register ccf_Probe_T_sip1_main_Probe_Reserved_72 @0x164 {
                bytes 4;
                field ccf_Probe_T_sip1_main_Probe_Reserved_72 {
                    bits 32;
                    access rw;
                    hard_reset 'h0;
                }
            }
            register ccf_Probe_T_sip1_main_Probe_Reserved_73 @0x168 {
                bytes 4;
                field ccf_Probe_T_sip1_main_Probe_Reserved_73 {
                    bits 32;
                    access rw;
                    hard_reset 'h0;
                }
            }
            register ccf_Probe_T_sip1_main_Probe_Reserved_74 @0x16C {
                bytes 4;
                field ccf_Probe_T_sip1_main_Probe_Reserved_74 {
                    bits 32;
                    access rw;
                    hard_reset 'h0;
                }
            }
            register ccf_Probe_T_sip1_main_Probe_Reserved_75 @0x170 {
                bytes 4;
                field ccf_Probe_T_sip1_main_Probe_Reserved_75 {
                    bits 32;
                    access rw;
                    hard_reset 'h0;
                }
            }
            register ccf_Probe_T_sip1_main_Probe_Reserved_76 @0x174 {
                bytes 4;
                field ccf_Probe_T_sip1_main_Probe_Reserved_76 {
                    bits 32;
                    access rw;
                    hard_reset 'h0;
                }
            }
            register ccf_Probe_T_sip1_main_Probe_Reserved_77 @0x178 {
                bytes 4;
                field ccf_Probe_T_sip1_main_Probe_Reserved_77 {
                    bits 32;
                    access rw;
                    hard_reset 'h0;
                }
            }
            register ccf_Probe_T_sip1_main_Probe_Reserved_78 @0x17C {
                bytes 4;
                field ccf_Probe_T_sip1_main_Probe_Reserved_78 {
                    bits 32;
                    access rw;
                    hard_reset 'h0;
                }
            }
            register ccf_Probe_T_sip1_main_Probe_Reserved_79 @0x180 {
                bytes 4;
                field ccf_Probe_T_sip1_main_Probe_Reserved_79 {
                    bits 32;
                    access rw;
                    hard_reset 'h0;
                }
            }
            register ccf_Probe_T_sip1_main_Probe_Reserved_80 @0x184 {
                bytes 4;
                field ccf_Probe_T_sip1_main_Probe_Reserved_80 {
                    bits 32;
                    access rw;
                    hard_reset 'h0;
                }
            }
            register ccf_Probe_T_sip1_main_Probe_Reserved_81 @0x188 {
                bytes 4;
                field ccf_Probe_T_sip1_main_Probe_Reserved_81 {
                    bits 32;
                    access rw;
                    hard_reset 'h0;
                }
            }
            register ccf_Probe_T_sip1_main_Probe_Reserved_82 @0x18C {
                bytes 4;
                field ccf_Probe_T_sip1_main_Probe_Reserved_82 {
                    bits 32;
                    access rw;
                    hard_reset 'h0;
                }
            }
            register ccf_Probe_T_sip1_main_Probe_Reserved_83 @0x190 {
                bytes 4;
                field ccf_Probe_T_sip1_main_Probe_Reserved_83 {
                    bits 32;
                    access rw;
                    hard_reset 'h0;
                }
            }
            register ccf_Probe_T_sip1_main_Probe_Reserved_84 @0x194 {
                bytes 4;
                field ccf_Probe_T_sip1_main_Probe_Reserved_84 {
                    bits 32;
                    access rw;
                    hard_reset 'h0;
                }
            }
            register ccf_Probe_T_sip1_main_Probe_Reserved_85 @0x198 {
                bytes 4;
                field ccf_Probe_T_sip1_main_Probe_Reserved_85 {
                    bits 32;
                    access rw;
                    hard_reset 'h0;
                }
            }
            register ccf_Probe_T_sip1_main_Probe_Reserved_86 @0x19C {
                bytes 4;
                field ccf_Probe_T_sip1_main_Probe_Reserved_86 {
                    bits 32;
                    access rw;
                    hard_reset 'h0;
                }
            }
            register ccf_Probe_T_sip1_main_Probe_Reserved_87 @0x1A0 {
                bytes 4;
                field ccf_Probe_T_sip1_main_Probe_Reserved_87 {
                    bits 32;
                    access rw;
                    hard_reset 'h0;
                }
            }
            register ccf_Probe_T_sip1_main_Probe_Reserved_88 @0x1A4 {
                bytes 4;
                field ccf_Probe_T_sip1_main_Probe_Reserved_88 {
                    bits 32;
                    access rw;
                    hard_reset 'h0;
                }
            }
            register ccf_Probe_T_sip1_main_Probe_Reserved_89 @0x1A8 {
                bytes 4;
                field ccf_Probe_T_sip1_main_Probe_Reserved_89 {
                    bits 32;
                    access rw;
                    hard_reset 'h0;
                }
            }
            register ccf_Probe_T_sip1_main_Probe_Reserved_90 @0x1AC {
                bytes 4;
                field ccf_Probe_T_sip1_main_Probe_Reserved_90 {
                    bits 32;
                    access rw;
                    hard_reset 'h0;
                }
            }
            register ccf_Probe_T_sip1_main_Probe_Reserved_91 @0x1B0 {
                bytes 4;
                field ccf_Probe_T_sip1_main_Probe_Reserved_91 {
                    bits 32;
                    access rw;
                    hard_reset 'h0;
                }
            }
            register ccf_Probe_T_sip1_main_Probe_Reserved_92 @0x1B4 {
                bytes 4;
                field ccf_Probe_T_sip1_main_Probe_Reserved_92 {
                    bits 32;
                    access rw;
                    hard_reset 'h0;
                }
            }
            register ccf_Probe_T_sip1_main_Probe_Reserved_93 @0x1B8 {
                bytes 4;
                field ccf_Probe_T_sip1_main_Probe_Reserved_93 {
                    bits 32;
                    access rw;
                    hard_reset 'h0;
                }
            }
            register ccf_Probe_T_sip1_main_Probe_Reserved_94 @0x1BC {
                bytes 4;
                field ccf_Probe_T_sip1_main_Probe_Reserved_94 {
                    bits 32;
                    access rw;
                    hard_reset 'h0;
                }
            }
            register ccf_Probe_T_sip1_main_Probe_Reserved_95 @0x1C0 {
                bytes 4;
                field ccf_Probe_T_sip1_main_Probe_Reserved_95 {
                    bits 32;
                    access rw;
                    hard_reset 'h0;
                }
            }
            register ccf_Probe_T_sip1_main_Probe_Reserved_96 @0x1C4 {
                bytes 4;
                field ccf_Probe_T_sip1_main_Probe_Reserved_96 {
                    bits 32;
                    access rw;
                    hard_reset 'h0;
                }
            }
            register ccf_Probe_T_sip1_main_Probe_Reserved_97 @0x1C8 {
                bytes 4;
                field ccf_Probe_T_sip1_main_Probe_Reserved_97 {
                    bits 32;
                    access rw;
                    hard_reset 'h0;
                }
            }
            register ccf_Probe_T_sip1_main_Probe_Reserved_98 @0x1CC {
                bytes 4;
                field ccf_Probe_T_sip1_main_Probe_Reserved_98 {
                    bits 32;
                    access rw;
                    hard_reset 'h0;
                }
            }
            register ccf_Probe_T_sip1_main_Probe_Reserved_99 @0x1D0 {
                bytes 4;
                field ccf_Probe_T_sip1_main_Probe_Reserved_99 {
                    bits 32;
                    access rw;
                    hard_reset 'h0;
                }
            }
            register ccf_Probe_T_sip1_main_Probe_Reserved_100 @0x1D4 {
                bytes 4;
                field ccf_Probe_T_sip1_main_Probe_Reserved_100 {
                    bits 32;
                    access rw;
                    hard_reset 'h0;
                }
            }
            register ccf_Probe_T_sip1_main_Probe_Reserved_101 @0x1D8 {
                bytes 4;
                field ccf_Probe_T_sip1_main_Probe_Reserved_101 {
                    bits 32;
                    access rw;
                    hard_reset 'h0;
                }
            }
            register ccf_Probe_T_sip1_main_Probe_Reserved_102 @0x1DC {
                bytes 4;
                field ccf_Probe_T_sip1_main_Probe_Reserved_102 {
                    bits 32;
                    access rw;
                    hard_reset 'h0;
                }
            }
            register ccf_Probe_T_sip1_main_Probe_Reserved_103 @0x1E0 {
                bytes 4;
                field ccf_Probe_T_sip1_main_Probe_Reserved_103 {
                    bits 32;
                    access rw;
                    hard_reset 'h0;
                }
            }
            register ccf_Probe_T_sip1_main_Probe_Reserved_104 @0x1E4 {
                bytes 4;
                field ccf_Probe_T_sip1_main_Probe_Reserved_104 {
                    bits 32;
                    access rw;
                    hard_reset 'h0;
                }
            }
            register ccf_Probe_T_sip1_main_Probe_Reserved_105 @0x1E8 {
                bytes 4;
                field ccf_Probe_T_sip1_main_Probe_Reserved_105 {
                    bits 32;
                    access rw;
                    hard_reset 'h0;
                }
            }
            register ccf_Probe_T_sip1_main_Probe_Reserved_106 @0x1EC {
                bytes 4;
                field ccf_Probe_T_sip1_main_Probe_Reserved_106 {
                    bits 32;
                    access rw;
                    hard_reset 'h0;
                }
            }
            register ccf_Probe_T_sip1_main_Probe_Reserved_107 @0x1F0 {
                bytes 4;
                field ccf_Probe_T_sip1_main_Probe_Reserved_107 {
                    bits 32;
                    access rw;
                    hard_reset 'h0;
                }
            }
            register ccf_Probe_T_sip1_main_Probe_Reserved_108 @0x1F4 {
                bytes 4;
                field ccf_Probe_T_sip1_main_Probe_Reserved_108 {
                    bits 32;
                    access rw;
                    hard_reset 'h0;
                }
            }
            register ccf_Probe_T_sip1_main_Probe_Reserved_109 @0x1F8 {
                bytes 4;
                field ccf_Probe_T_sip1_main_Probe_Reserved_109 {
                    bits 32;
                    access rw;
                    hard_reset 'h0;
                }
            }
            register ccf_Probe_T_sip1_main_Probe_Reserved_110 @0x1FC {
                bytes 4;
                field ccf_Probe_T_sip1_main_Probe_Reserved_110 {
                    bits 32;
                    access rw;
                    hard_reset 'h0;
                }
            }
            register ccf_Probe_T_sip1_main_Probe_Reserved_111 @0x200 {
                bytes 4;
                field ccf_Probe_T_sip1_main_Probe_Reserved_111 {
                    bits 32;
                    access rw;
                    hard_reset 'h0;
                }
            }
            register ccf_Probe_T_sip1_main_Probe_Reserved_112 @0x204 {
                bytes 4;
                field ccf_Probe_T_sip1_main_Probe_Reserved_112 {
                    bits 32;
                    access rw;
                    hard_reset 'h0;
                }
            }
            register ccf_Probe_T_sip1_main_Probe_Reserved_113 @0x208 {
                bytes 4;
                field ccf_Probe_T_sip1_main_Probe_Reserved_113 {
                    bits 32;
                    access rw;
                    hard_reset 'h0;
                }
            }
            register ccf_Probe_T_sip1_main_Probe_Reserved_114 @0x20C {
                bytes 4;
                field ccf_Probe_T_sip1_main_Probe_Reserved_114 {
                    bits 32;
                    access rw;
                    hard_reset 'h0;
                }
            }
            register ccf_Probe_T_sip1_main_Probe_Reserved_115 @0x210 {
                bytes 4;
                field ccf_Probe_T_sip1_main_Probe_Reserved_115 {
                    bits 32;
                    access rw;
                    hard_reset 'h0;
                }
            }
            register ccf_Probe_T_sip1_main_Probe_Reserved_116 @0x214 {
                bytes 4;
                field ccf_Probe_T_sip1_main_Probe_Reserved_116 {
                    bits 32;
                    access rw;
                    hard_reset 'h0;
                }
            }
            register ccf_Probe_T_sip1_main_Probe_Reserved_117 @0x218 {
                bytes 4;
                field ccf_Probe_T_sip1_main_Probe_Reserved_117 {
                    bits 32;
                    access rw;
                    hard_reset 'h0;
                }
            }
            register ccf_Probe_T_sip1_main_Probe_Reserved_118 @0x21C {
                bytes 4;
                field ccf_Probe_T_sip1_main_Probe_Reserved_118 {
                    bits 32;
                    access rw;
                    hard_reset 'h0;
                }
            }
            register ccf_Probe_T_sip1_main_Probe_Reserved_119 @0x220 {
                bytes 4;
                field ccf_Probe_T_sip1_main_Probe_Reserved_119 {
                    bits 32;
                    access rw;
                    hard_reset 'h0;
                }
            }
            register ccf_Probe_T_sip1_main_Probe_Reserved_120 @0x224 {
                bytes 4;
                field ccf_Probe_T_sip1_main_Probe_Reserved_120 {
                    bits 32;
                    access rw;
                    hard_reset 'h0;
                }
            }
            register ccf_Probe_T_sip1_main_Probe_Reserved_121 @0x228 {
                bytes 4;
                field ccf_Probe_T_sip1_main_Probe_Reserved_121 {
                    bits 32;
                    access rw;
                    hard_reset 'h0;
                }
            }
            register ccf_Probe_T_sip1_main_Probe_Reserved_122 @0x22C {
                bytes 4;
                field ccf_Probe_T_sip1_main_Probe_Reserved_122 {
                    bits 32;
                    access rw;
                    hard_reset 'h0;
                }
            }
            register ccf_Probe_T_sip1_main_Probe_Reserved_123 @0x230 {
                bytes 4;
                field ccf_Probe_T_sip1_main_Probe_Reserved_123 {
                    bits 32;
                    access rw;
                    hard_reset 'h0;
                }
            }
            register ccf_Probe_T_sip1_main_Probe_Reserved_124 @0x234 {
                bytes 4;
                field ccf_Probe_T_sip1_main_Probe_Reserved_124 {
                    bits 32;
                    access rw;
                    hard_reset 'h0;
                }
            }
            register ccf_Probe_T_sip1_main_Probe_Reserved_125 @0x238 {
                bytes 4;
                field ccf_Probe_T_sip1_main_Probe_Reserved_125 {
                    bits 32;
                    access rw;
                    hard_reset 'h0;
                }
            }
            register ccf_Probe_T_sip1_main_Probe_Reserved_126 @0x23C {
                bytes 4;
                field ccf_Probe_T_sip1_main_Probe_Reserved_126 {
                    bits 32;
                    access rw;
                    hard_reset 'h0;
                }
            }
            register ccf_Probe_T_sip1_main_Probe_Reserved_127 @0x240 {
                bytes 4;
                field ccf_Probe_T_sip1_main_Probe_Reserved_127 {
                    bits 32;
                    access rw;
                    hard_reset 'h0;
                }
            }
            register ccf_Probe_T_sip1_main_Probe_Reserved_128 @0x244 {
                bytes 4;
                field ccf_Probe_T_sip1_main_Probe_Reserved_128 {
                    bits 32;
                    access rw;
                    hard_reset 'h0;
                }
            }
            register ccf_Probe_T_sip1_main_Probe_Reserved_129 @0x248 {
                bytes 4;
                field ccf_Probe_T_sip1_main_Probe_Reserved_129 {
                    bits 32;
                    access rw;
                    hard_reset 'h0;
                }
            }
            register ccf_Probe_T_sip1_main_Probe_Reserved_130 @0x24C {
                bytes 4;
                field ccf_Probe_T_sip1_main_Probe_Reserved_130 {
                    bits 32;
                    access rw;
                    hard_reset 'h0;
                }
            }
            register ccf_Probe_T_sip1_main_Probe_Reserved_131 @0x250 {
                bytes 4;
                field ccf_Probe_T_sip1_main_Probe_Reserved_131 {
                    bits 32;
                    access rw;
                    hard_reset 'h0;
                }
            }
            register ccf_Probe_T_sip1_main_Probe_Reserved_132 @0x254 {
                bytes 4;
                field ccf_Probe_T_sip1_main_Probe_Reserved_132 {
                    bits 32;
                    access rw;
                    hard_reset 'h0;
                }
            }
            register ccf_Probe_T_sip1_main_Probe_Reserved_133 @0x258 {
                bytes 4;
                field ccf_Probe_T_sip1_main_Probe_Reserved_133 {
                    bits 32;
                    access rw;
                    hard_reset 'h0;
                }
            }
            register ccf_Probe_T_sip1_main_Probe_Reserved_134 @0x25C {
                bytes 4;
                field ccf_Probe_T_sip1_main_Probe_Reserved_134 {
                    bits 32;
                    access rw;
                    hard_reset 'h0;
                }
            }
            register ccf_Probe_T_sip1_main_Probe_Reserved_135 @0x260 {
                bytes 4;
                field ccf_Probe_T_sip1_main_Probe_Reserved_135 {
                    bits 32;
                    access rw;
                    hard_reset 'h0;
                }
            }
            register ccf_Probe_T_sip1_main_Probe_Reserved_136 @0x264 {
                bytes 4;
                field ccf_Probe_T_sip1_main_Probe_Reserved_136 {
                    bits 32;
                    access rw;
                    hard_reset 'h0;
                }
            }
            register ccf_Probe_T_sip1_main_Probe_Reserved_137 @0x268 {
                bytes 4;
                field ccf_Probe_T_sip1_main_Probe_Reserved_137 {
                    bits 32;
                    access rw;
                    hard_reset 'h0;
                }
            }
            register ccf_Probe_T_sip1_main_Probe_Reserved_138 @0x26C {
                bytes 4;
                field ccf_Probe_T_sip1_main_Probe_Reserved_138 {
                    bits 32;
                    access rw;
                    hard_reset 'h0;
                }
            }
            register ccf_Probe_T_sip1_main_Probe_Reserved_139 @0x270 {
                bytes 4;
                field ccf_Probe_T_sip1_main_Probe_Reserved_139 {
                    bits 32;
                    access rw;
                    hard_reset 'h0;
                }
            }
            register ccf_Probe_T_sip1_main_Probe_Reserved_140 @0x274 {
                bytes 4;
                field ccf_Probe_T_sip1_main_Probe_Reserved_140 {
                    bits 32;
                    access rw;
                    hard_reset 'h0;
                }
            }
            register ccf_Probe_T_sip1_main_Probe_Reserved_141 @0x278 {
                bytes 4;
                field ccf_Probe_T_sip1_main_Probe_Reserved_141 {
                    bits 32;
                    access rw;
                    hard_reset 'h0;
                }
            }
            register ccf_Probe_T_sip1_main_Probe_Reserved_142 @0x27C {
                bytes 4;
                field ccf_Probe_T_sip1_main_Probe_Reserved_142 {
                    bits 32;
                    access rw;
                    hard_reset 'h0;
                }
            }
            register ccf_Probe_T_sip1_main_Probe_Reserved_143 @0x280 {
                bytes 4;
                field ccf_Probe_T_sip1_main_Probe_Reserved_143 {
                    bits 32;
                    access rw;
                    hard_reset 'h0;
                }
            }
            register ccf_Probe_T_sip1_main_Probe_Reserved_144 @0x284 {
                bytes 4;
                field ccf_Probe_T_sip1_main_Probe_Reserved_144 {
                    bits 32;
                    access rw;
                    hard_reset 'h0;
                }
            }
            register ccf_Probe_T_sip1_main_Probe_Reserved_145 @0x288 {
                bytes 4;
                field ccf_Probe_T_sip1_main_Probe_Reserved_145 {
                    bits 32;
                    access rw;
                    hard_reset 'h0;
                }
            }
            register ccf_Probe_T_sip1_main_Probe_Reserved_146 @0x28C {
                bytes 4;
                field ccf_Probe_T_sip1_main_Probe_Reserved_146 {
                    bits 32;
                    access rw;
                    hard_reset 'h0;
                }
            }
            register ccf_Probe_T_sip1_main_Probe_Reserved_147 @0x290 {
                bytes 4;
                field ccf_Probe_T_sip1_main_Probe_Reserved_147 {
                    bits 32;
                    access rw;
                    hard_reset 'h0;
                }
            }
            register ccf_Probe_T_sip1_main_Probe_Reserved_148 @0x294 {
                bytes 4;
                field ccf_Probe_T_sip1_main_Probe_Reserved_148 {
                    bits 32;
                    access rw;
                    hard_reset 'h0;
                }
            }
            register ccf_Probe_T_sip1_main_Probe_Reserved_149 @0x298 {
                bytes 4;
                field ccf_Probe_T_sip1_main_Probe_Reserved_149 {
                    bits 32;
                    access rw;
                    hard_reset 'h0;
                }
            }
            register ccf_Probe_T_sip1_main_Probe_Reserved_150 @0x29C {
                bytes 4;
                field ccf_Probe_T_sip1_main_Probe_Reserved_150 {
                    bits 32;
                    access rw;
                    hard_reset 'h0;
                }
            }
            register ccf_Probe_T_sip1_main_Probe_Reserved_151 @0x2A0 {
                bytes 4;
                field ccf_Probe_T_sip1_main_Probe_Reserved_151 {
                    bits 32;
                    access rw;
                    hard_reset 'h0;
                }
            }
            register ccf_Probe_T_sip1_main_Probe_Reserved_152 @0x2A4 {
                bytes 4;
                field ccf_Probe_T_sip1_main_Probe_Reserved_152 {
                    bits 32;
                    access rw;
                    hard_reset 'h0;
                }
            }
            register ccf_Probe_T_sip1_main_Probe_Reserved_153 @0x2A8 {
                bytes 4;
                field ccf_Probe_T_sip1_main_Probe_Reserved_153 {
                    bits 32;
                    access rw;
                    hard_reset 'h0;
                }
            }
            register ccf_Probe_T_sip1_main_Probe_Reserved_154 @0x2AC {
                bytes 4;
                field ccf_Probe_T_sip1_main_Probe_Reserved_154 {
                    bits 32;
                    access rw;
                    hard_reset 'h0;
                }
            }
            register ccf_Probe_T_sip1_main_Probe_Reserved_155 @0x2B0 {
                bytes 4;
                field ccf_Probe_T_sip1_main_Probe_Reserved_155 {
                    bits 32;
                    access rw;
                    hard_reset 'h0;
                }
            }
            register ccf_Probe_T_sip1_main_Probe_Reserved_156 @0x2B4 {
                bytes 4;
                field ccf_Probe_T_sip1_main_Probe_Reserved_156 {
                    bits 32;
                    access rw;
                    hard_reset 'h0;
                }
            }
            register ccf_Probe_T_sip1_main_Probe_Reserved_157 @0x2B8 {
                bytes 4;
                field ccf_Probe_T_sip1_main_Probe_Reserved_157 {
                    bits 32;
                    access rw;
                    hard_reset 'h0;
                }
            }
            register ccf_Probe_T_sip1_main_Probe_Reserved_158 @0x2BC {
                bytes 4;
                field ccf_Probe_T_sip1_main_Probe_Reserved_158 {
                    bits 32;
                    access rw;
                    hard_reset 'h0;
                }
            }
            register ccf_Probe_T_sip1_main_Probe_Reserved_159 @0x2C0 {
                bytes 4;
                field ccf_Probe_T_sip1_main_Probe_Reserved_159 {
                    bits 32;
                    access rw;
                    hard_reset 'h0;
                }
            }
            register ccf_Probe_T_sip1_main_Probe_Reserved_160 @0x2C4 {
                bytes 4;
                field ccf_Probe_T_sip1_main_Probe_Reserved_160 {
                    bits 32;
                    access rw;
                    hard_reset 'h0;
                }
            }
            register ccf_Probe_T_sip1_main_Probe_Reserved_161 @0x2C8 {
                bytes 4;
                field ccf_Probe_T_sip1_main_Probe_Reserved_161 {
                    bits 32;
                    access rw;
                    hard_reset 'h0;
                }
            }
            register ccf_Probe_T_sip1_main_Probe_Reserved_162 @0x2CC {
                bytes 4;
                field ccf_Probe_T_sip1_main_Probe_Reserved_162 {
                    bits 32;
                    access rw;
                    hard_reset 'h0;
                }
            }
            register ccf_Probe_T_sip1_main_Probe_Reserved_163 @0x2D0 {
                bytes 4;
                field ccf_Probe_T_sip1_main_Probe_Reserved_163 {
                    bits 32;
                    access rw;
                    hard_reset 'h0;
                }
            }
            register ccf_Probe_T_sip1_main_Probe_Reserved_164 @0x2D4 {
                bytes 4;
                field ccf_Probe_T_sip1_main_Probe_Reserved_164 {
                    bits 32;
                    access rw;
                    hard_reset 'h0;
                }
            }
            register ccf_Probe_T_sip1_main_Probe_Reserved_165 @0x2D8 {
                bytes 4;
                field ccf_Probe_T_sip1_main_Probe_Reserved_165 {
                    bits 32;
                    access rw;
                    hard_reset 'h0;
                }
            }
            register ccf_Probe_T_sip1_main_Probe_Reserved_166 @0x2DC {
                bytes 4;
                field ccf_Probe_T_sip1_main_Probe_Reserved_166 {
                    bits 32;
                    access rw;
                    hard_reset 'h0;
                }
            }
            register ccf_Probe_T_sip1_main_Probe_Reserved_167 @0x2E0 {
                bytes 4;
                field ccf_Probe_T_sip1_main_Probe_Reserved_167 {
                    bits 32;
                    access rw;
                    hard_reset 'h0;
                }
            }
            register ccf_Probe_T_sip1_main_Probe_Reserved_168 @0x2E4 {
                bytes 4;
                field ccf_Probe_T_sip1_main_Probe_Reserved_168 {
                    bits 32;
                    access rw;
                    hard_reset 'h0;
                }
            }
            register ccf_Probe_T_sip1_main_Probe_Reserved_169 @0x2E8 {
                bytes 4;
                field ccf_Probe_T_sip1_main_Probe_Reserved_169 {
                    bits 32;
                    access rw;
                    hard_reset 'h0;
                }
            }
            register ccf_Probe_T_sip1_main_Probe_Reserved_170 @0x2EC {
                bytes 4;
                field ccf_Probe_T_sip1_main_Probe_Reserved_170 {
                    bits 32;
                    access rw;
                    hard_reset 'h0;
                }
            }
            register ccf_Probe_T_sip1_main_Probe_Reserved_171 @0x2F0 {
                bytes 4;
                field ccf_Probe_T_sip1_main_Probe_Reserved_171 {
                    bits 32;
                    access rw;
                    hard_reset 'h0;
                }
            }
            register ccf_Probe_T_sip1_main_Probe_Reserved_172 @0x2F4 {
                bytes 4;
                field ccf_Probe_T_sip1_main_Probe_Reserved_172 {
                    bits 32;
                    access rw;
                    hard_reset 'h0;
                }
            }
            register ccf_Probe_T_sip1_main_Probe_Reserved_173 @0x2F8 {
                bytes 4;
                field ccf_Probe_T_sip1_main_Probe_Reserved_173 {
                    bits 32;
                    access rw;
                    hard_reset 'h0;
                }
            }
            register ccf_Probe_T_sip1_main_Probe_Reserved_174 @0x2FC {
                bytes 4;
                field ccf_Probe_T_sip1_main_Probe_Reserved_174 {
                    bits 32;
                    access rw;
                    hard_reset 'h0;
                }
            }
            register ccf_Probe_T_sip1_main_Probe_Reserved_175 @0x300 {
                bytes 4;
                field ccf_Probe_T_sip1_main_Probe_Reserved_175 {
                    bits 32;
                    access rw;
                    hard_reset 'h0;
                }
            }
            register ccf_Probe_T_sip1_main_Probe_Reserved_176 @0x304 {
                bytes 4;
                field ccf_Probe_T_sip1_main_Probe_Reserved_176 {
                    bits 32;
                    access rw;
                    hard_reset 'h0;
                }
            }
            register ccf_Probe_T_sip1_main_Probe_Reserved_177 @0x308 {
                bytes 4;
                field ccf_Probe_T_sip1_main_Probe_Reserved_177 {
                    bits 32;
                    access rw;
                    hard_reset 'h0;
                }
            }
            register ccf_Probe_T_sip1_main_Probe_Reserved_178 @0x30C {
                bytes 4;
                field ccf_Probe_T_sip1_main_Probe_Reserved_178 {
                    bits 32;
                    access rw;
                    hard_reset 'h0;
                }
            }
            register ccf_Probe_T_sip1_main_Probe_Reserved_179 @0x310 {
                bytes 4;
                field ccf_Probe_T_sip1_main_Probe_Reserved_179 {
                    bits 32;
                    access rw;
                    hard_reset 'h0;
                }
            }
            register ccf_Probe_T_sip1_main_Probe_Reserved_180 @0x314 {
                bytes 4;
                field ccf_Probe_T_sip1_main_Probe_Reserved_180 {
                    bits 32;
                    access rw;
                    hard_reset 'h0;
                }
            }
            register ccf_Probe_T_sip1_main_Probe_Reserved_181 @0x318 {
                bytes 4;
                field ccf_Probe_T_sip1_main_Probe_Reserved_181 {
                    bits 32;
                    access rw;
                    hard_reset 'h0;
                }
            }
            register ccf_Probe_T_sip1_main_Probe_Reserved_182 @0x31C {
                bytes 4;
                field ccf_Probe_T_sip1_main_Probe_Reserved_182 {
                    bits 32;
                    access rw;
                    hard_reset 'h0;
                }
            }
            register ccf_Probe_T_sip1_main_Probe_Reserved_183 @0x320 {
                bytes 4;
                field ccf_Probe_T_sip1_main_Probe_Reserved_183 {
                    bits 32;
                    access rw;
                    hard_reset 'h0;
                }
            }
            register ccf_Probe_T_sip1_main_Probe_Reserved_184 @0x324 {
                bytes 4;
                field ccf_Probe_T_sip1_main_Probe_Reserved_184 {
                    bits 32;
                    access rw;
                    hard_reset 'h0;
                }
            }
            register ccf_Probe_T_sip1_main_Probe_Reserved_185 @0x328 {
                bytes 4;
                field ccf_Probe_T_sip1_main_Probe_Reserved_185 {
                    bits 32;
                    access rw;
                    hard_reset 'h0;
                }
            }
            register ccf_Probe_T_sip1_main_Probe_Reserved_186 @0x32C {
                bytes 4;
                field ccf_Probe_T_sip1_main_Probe_Reserved_186 {
                    bits 32;
                    access rw;
                    hard_reset 'h0;
                }
            }
            register ccf_Probe_T_sip1_main_Probe_Reserved_187 @0x330 {
                bytes 4;
                field ccf_Probe_T_sip1_main_Probe_Reserved_187 {
                    bits 32;
                    access rw;
                    hard_reset 'h0;
                }
            }
            register ccf_Probe_T_sip1_main_Probe_Reserved_188 @0x334 {
                bytes 4;
                field ccf_Probe_T_sip1_main_Probe_Reserved_188 {
                    bits 32;
                    access rw;
                    hard_reset 'h0;
                }
            }
            register ccf_Probe_T_sip1_main_Probe_Reserved_189 @0x338 {
                bytes 4;
                field ccf_Probe_T_sip1_main_Probe_Reserved_189 {
                    bits 32;
                    access rw;
                    hard_reset 'h0;
                }
            }
            register ccf_Probe_T_sip1_main_Probe_Reserved_190 @0x33C {
                bytes 4;
                field ccf_Probe_T_sip1_main_Probe_Reserved_190 {
                    bits 32;
                    access rw;
                    hard_reset 'h0;
                }
            }
            register ccf_Probe_T_sip1_main_Probe_Reserved_191 @0x340 {
                bytes 4;
                field ccf_Probe_T_sip1_main_Probe_Reserved_191 {
                    bits 32;
                    access rw;
                    hard_reset 'h0;
                }
            }
            register ccf_Probe_T_sip1_main_Probe_Reserved_192 @0x344 {
                bytes 4;
                field ccf_Probe_T_sip1_main_Probe_Reserved_192 {
                    bits 32;
                    access rw;
                    hard_reset 'h0;
                }
            }
            register ccf_Probe_T_sip1_main_Probe_Reserved_193 @0x348 {
                bytes 4;
                field ccf_Probe_T_sip1_main_Probe_Reserved_193 {
                    bits 32;
                    access rw;
                    hard_reset 'h0;
                }
            }
            register ccf_Probe_T_sip1_main_Probe_Reserved_194 @0x34C {
                bytes 4;
                field ccf_Probe_T_sip1_main_Probe_Reserved_194 {
                    bits 32;
                    access rw;
                    hard_reset 'h0;
                }
            }
            register ccf_Probe_T_sip1_main_Probe_Reserved_195 @0x350 {
                bytes 4;
                field ccf_Probe_T_sip1_main_Probe_Reserved_195 {
                    bits 32;
                    access rw;
                    hard_reset 'h0;
                }
            }
            register ccf_Probe_T_sip1_main_Probe_Reserved_196 @0x354 {
                bytes 4;
                field ccf_Probe_T_sip1_main_Probe_Reserved_196 {
                    bits 32;
                    access rw;
                    hard_reset 'h0;
                }
            }
            register ccf_Probe_T_sip1_main_Probe_Reserved_197 @0x358 {
                bytes 4;
                field ccf_Probe_T_sip1_main_Probe_Reserved_197 {
                    bits 32;
                    access rw;
                    hard_reset 'h0;
                }
            }
            register ccf_Probe_T_sip1_main_Probe_Reserved_198 @0x35C {
                bytes 4;
                field ccf_Probe_T_sip1_main_Probe_Reserved_198 {
                    bits 32;
                    access rw;
                    hard_reset 'h0;
                }
            }
            register ccf_Probe_T_sip1_main_Probe_Reserved_199 @0x360 {
                bytes 4;
                field ccf_Probe_T_sip1_main_Probe_Reserved_199 {
                    bits 32;
                    access rw;
                    hard_reset 'h0;
                }
            }
            register ccf_Probe_T_sip1_main_Probe_Reserved_200 @0x364 {
                bytes 4;
                field ccf_Probe_T_sip1_main_Probe_Reserved_200 {
                    bits 32;
                    access rw;
                    hard_reset 'h0;
                }
            }
            register ccf_Probe_T_sip1_main_Probe_Reserved_201 @0x368 {
                bytes 4;
                field ccf_Probe_T_sip1_main_Probe_Reserved_201 {
                    bits 32;
                    access rw;
                    hard_reset 'h0;
                }
            }
            register ccf_Probe_T_sip1_main_Probe_Reserved_202 @0x36C {
                bytes 4;
                field ccf_Probe_T_sip1_main_Probe_Reserved_202 {
                    bits 32;
                    access rw;
                    hard_reset 'h0;
                }
            }
            register ccf_Probe_T_sip1_main_Probe_Reserved_203 @0x370 {
                bytes 4;
                field ccf_Probe_T_sip1_main_Probe_Reserved_203 {
                    bits 32;
                    access rw;
                    hard_reset 'h0;
                }
            }
            register ccf_Probe_T_sip1_main_Probe_Reserved_204 @0x374 {
                bytes 4;
                field ccf_Probe_T_sip1_main_Probe_Reserved_204 {
                    bits 32;
                    access rw;
                    hard_reset 'h0;
                }
            }
            register ccf_Probe_T_sip1_main_Probe_Reserved_205 @0x378 {
                bytes 4;
                field ccf_Probe_T_sip1_main_Probe_Reserved_205 {
                    bits 32;
                    access rw;
                    hard_reset 'h0;
                }
            }
            register ccf_Probe_T_sip1_main_Probe_Reserved_206 @0x37C {
                bytes 4;
                field ccf_Probe_T_sip1_main_Probe_Reserved_206 {
                    bits 32;
                    access rw;
                    hard_reset 'h0;
                }
            }
            register ccf_Probe_T_sip1_main_Probe_Reserved_207 @0x380 {
                bytes 4;
                field ccf_Probe_T_sip1_main_Probe_Reserved_207 {
                    bits 32;
                    access rw;
                    hard_reset 'h0;
                }
            }
            register ccf_Probe_T_sip1_main_Probe_Reserved_208 @0x384 {
                bytes 4;
                field ccf_Probe_T_sip1_main_Probe_Reserved_208 {
                    bits 32;
                    access rw;
                    hard_reset 'h0;
                }
            }
            register ccf_Probe_T_sip1_main_Probe_Reserved_209 @0x388 {
                bytes 4;
                field ccf_Probe_T_sip1_main_Probe_Reserved_209 {
                    bits 32;
                    access rw;
                    hard_reset 'h0;
                }
            }
            register ccf_Probe_T_sip1_main_Probe_Reserved_210 @0x38C {
                bytes 4;
                field ccf_Probe_T_sip1_main_Probe_Reserved_210 {
                    bits 32;
                    access rw;
                    hard_reset 'h0;
                }
            }
            register ccf_Probe_T_sip1_main_Probe_Reserved_211 @0x390 {
                bytes 4;
                field ccf_Probe_T_sip1_main_Probe_Reserved_211 {
                    bits 32;
                    access rw;
                    hard_reset 'h0;
                }
            }
            register ccf_Probe_T_sip1_main_Probe_Reserved_212 @0x394 {
                bytes 4;
                field ccf_Probe_T_sip1_main_Probe_Reserved_212 {
                    bits 32;
                    access rw;
                    hard_reset 'h0;
                }
            }
            register ccf_Probe_T_sip1_main_Probe_Reserved_213 @0x398 {
                bytes 4;
                field ccf_Probe_T_sip1_main_Probe_Reserved_213 {
                    bits 32;
                    access rw;
                    hard_reset 'h0;
                }
            }
            register ccf_Probe_T_sip1_main_Probe_Reserved_214 @0x39C {
                bytes 4;
                field ccf_Probe_T_sip1_main_Probe_Reserved_214 {
                    bits 32;
                    access rw;
                    hard_reset 'h0;
                }
            }
            register ccf_Probe_T_sip1_main_Probe_Reserved_215 @0x3A0 {
                bytes 4;
                field ccf_Probe_T_sip1_main_Probe_Reserved_215 {
                    bits 32;
                    access rw;
                    hard_reset 'h0;
                }
            }
            register ccf_Probe_T_sip1_main_Probe_Reserved_216 @0x3A4 {
                bytes 4;
                field ccf_Probe_T_sip1_main_Probe_Reserved_216 {
                    bits 32;
                    access rw;
                    hard_reset 'h0;
                }
            }
            register ccf_Probe_T_sip1_main_Probe_Reserved_217 @0x3A8 {
                bytes 4;
                field ccf_Probe_T_sip1_main_Probe_Reserved_217 {
                    bits 32;
                    access rw;
                    hard_reset 'h0;
                }
            }
            register ccf_Probe_T_sip1_main_Probe_Reserved_218 @0x3AC {
                bytes 4;
                field ccf_Probe_T_sip1_main_Probe_Reserved_218 {
                    bits 32;
                    access rw;
                    hard_reset 'h0;
                }
            }
            register ccf_Probe_T_sip1_main_Probe_Reserved_219 @0x3B0 {
                bytes 4;
                field ccf_Probe_T_sip1_main_Probe_Reserved_219 {
                    bits 32;
                    access rw;
                    hard_reset 'h0;
                }
            }
            register ccf_Probe_T_sip1_main_Probe_Reserved_220 @0x3B4 {
                bytes 4;
                field ccf_Probe_T_sip1_main_Probe_Reserved_220 {
                    bits 32;
                    access rw;
                    hard_reset 'h0;
                }
            }
            register ccf_Probe_T_sip1_main_Probe_Reserved_221 @0x3B8 {
                bytes 4;
                field ccf_Probe_T_sip1_main_Probe_Reserved_221 {
                    bits 32;
                    access rw;
                    hard_reset 'h0;
                }
            }
            register ccf_Probe_T_sip1_main_Probe_Reserved_222 @0x3BC {
                bytes 4;
                field ccf_Probe_T_sip1_main_Probe_Reserved_222 {
                    bits 32;
                    access rw;
                    hard_reset 'h0;
                }
            }
            register ccf_Probe_T_sip1_main_Probe_Reserved_223 @0x3C0 {
                bytes 4;
                field ccf_Probe_T_sip1_main_Probe_Reserved_223 {
                    bits 32;
                    access rw;
                    hard_reset 'h0;
                }
            }
            register ccf_Probe_T_sip1_main_Probe_Reserved_224 @0x3C4 {
                bytes 4;
                field ccf_Probe_T_sip1_main_Probe_Reserved_224 {
                    bits 32;
                    access rw;
                    hard_reset 'h0;
                }
            }
            register ccf_Probe_T_sip1_main_Probe_Reserved_225 @0x3C8 {
                bytes 4;
                field ccf_Probe_T_sip1_main_Probe_Reserved_225 {
                    bits 32;
                    access rw;
                    hard_reset 'h0;
                }
            }
            register ccf_Probe_T_sip1_main_Probe_Reserved_226 @0x3CC {
                bytes 4;
                field ccf_Probe_T_sip1_main_Probe_Reserved_226 {
                    bits 32;
                    access rw;
                    hard_reset 'h0;
                }
            }
            register ccf_Probe_T_sip1_main_Probe_Reserved_227 @0x3D0 {
                bytes 4;
                field ccf_Probe_T_sip1_main_Probe_Reserved_227 {
                    bits 32;
                    access rw;
                    hard_reset 'h0;
                }
            }
            register ccf_Probe_T_sip1_main_Probe_Reserved_228 @0x3D4 {
                bytes 4;
                field ccf_Probe_T_sip1_main_Probe_Reserved_228 {
                    bits 32;
                    access rw;
                    hard_reset 'h0;
                }
            }
            register ccf_Probe_T_sip1_main_Probe_Reserved_229 @0x3D8 {
                bytes 4;
                field ccf_Probe_T_sip1_main_Probe_Reserved_229 {
                    bits 32;
                    access rw;
                    hard_reset 'h0;
                }
            }
            register ccf_Probe_T_sip1_main_Probe_Reserved_230 @0x3DC {
                bytes 4;
                field ccf_Probe_T_sip1_main_Probe_Reserved_230 {
                    bits 32;
                    access rw;
                    hard_reset 'h0;
                }
            }
            register ccf_Probe_T_sip1_main_Probe_Reserved_231 @0x3E0 {
                bytes 4;
                field ccf_Probe_T_sip1_main_Probe_Reserved_231 {
                    bits 32;
                    access rw;
                    hard_reset 'h0;
                }
            }
            register ccf_Probe_T_sip1_main_Probe_Reserved_232 @0x3E4 {
                bytes 4;
                field ccf_Probe_T_sip1_main_Probe_Reserved_232 {
                    bits 32;
                    access rw;
                    hard_reset 'h0;
                }
            }
            register ccf_Probe_T_sip1_main_Probe_Reserved_233 @0x3E8 {
                bytes 4;
                field ccf_Probe_T_sip1_main_Probe_Reserved_233 {
                    bits 32;
                    access rw;
                    hard_reset 'h0;
                }
            }
            register ccf_Probe_T_sip1_main_Probe_Reserved_234 @0x3EC {
                bytes 4;
                field ccf_Probe_T_sip1_main_Probe_Reserved_234 {
                    bits 32;
                    access rw;
                    hard_reset 'h0;
                }
            }
            register ccf_Probe_T_sip1_main_Probe_Reserved_235 @0x3F0 {
                bytes 4;
                field ccf_Probe_T_sip1_main_Probe_Reserved_235 {
                    bits 32;
                    access rw;
                    hard_reset 'h0;
                }
            }
            register ccf_Probe_T_sip1_main_Probe_Reserved_236 @0x3F4 {
                bytes 4;
                field ccf_Probe_T_sip1_main_Probe_Reserved_236 {
                    bits 32;
                    access rw;
                    hard_reset 'h0;
                }
            }
            register ccf_Probe_T_sip1_main_Probe_Reserved_237 @0x3F8 {
                bytes 4;
                field ccf_Probe_T_sip1_main_Probe_Reserved_237 {
                    bits 32;
                    access rw;
                    hard_reset 'h0;
                }
            }
            register ccf_Probe_T_sip1_main_Probe_Reserved_238 @0x3FC {
                bytes 4;
                field ccf_Probe_T_sip1_main_Probe_Reserved_238 {
                    bits 32;
                    access rw;
                    hard_reset 'h0;
                }
            }
        }
        block ecf_ccf_axi_ccf_Probe_T_sip2_main_Probe @0xD9800 {
            bytes 4;
            register ccf_Probe_T_sip2_main_Probe_Id_CoreId @0x0 {
                bytes 4;
                field CORETYPEID @'h0 {
                    bits 8;
                    access ro;
                    hard_reset 'h6;
                    doc {
                        Field identifying the type of IP.
                    }
                }
                field CORECHECKSUM @'h8 {
                    bits 24;
                    access ro;
                    hard_reset 'h6d92d6;
                    doc {
                        Field containing a checksum of the parameters of the IP.
                    }
                }
            }
            register ccf_Probe_T_sip2_main_Probe_Id_RevisionId @0x4 {
                bytes 4;
                field USERID @'h0 {
                    bits 8;
                    access ro;
                    hard_reset 'h0;
                    doc {
                        Field containing a user defined value, not used anywhere inside the IP itself.
                    }
                }
                field FLEXNOCID @'h8 {
                    bits 24;
                    access ro;
                    hard_reset 'h84f8c6;
                    doc {
                        Field containing the build revision of the software used to generate the IP HDL code.
                    }
                }
            }
            register ccf_Probe_T_sip2_main_Probe_MainCtl @0x8 {
                bytes 4;
                field ERREN @'h0 {
                    access rw;
                    hard_reset 'h0;
                    doc {
                        Register field ErrEn enables the probe to send on the ObsTx output any packet with Error status, independently of filtering mechanisms, thus constituting a simple supplementary global filter.
                    }
                }
                field TRACEEN @'h1 {
                    access ro;
                    hard_reset 'h0;
                    doc {
                        Register field TraceEn enables the probe to send filtered packets (Trace) on the ObsTx observation output.
                    }
                }
                field PAYLOADEN @'h2 {
                    access rw;
                    hard_reset 'h0;
                    doc {
                        Register field PayloadEn, when set to 1, enables traces to contain headers and payload. When set ot 0, only headers are reported.
                    }
                }
                field STATEN @'h3 {
                    access rw;
                    hard_reset 'h0;
                    doc {
                        When set to 1, register field StatEn enables statistics profiling. The probe sendS statistics results to the output for signal ObsTx. All statistics counters are cleared when the StatEn bit goes from 0 to 1. When set to 0, counters are disabled.
                    }
                }
                field ALARMEN @'h4 {
                    access rw;
                    hard_reset 'h0;
                    doc {
                        When set, register field AlarmEn enables the probe to collect alarm-related information. When the register field bit is null, both TraceAlarm and StatAlarm outputs are driven to 0.
                    }
                }
                field STATCONDDUMP @'h5 {
                    access rw;
                    hard_reset 'h0;
                    doc {
                        When set, register field StatCondDump enables the dump of a statistics frame to the range of counter values set for registers StatAlarmMin, StatAlarmMax, and AlarmMode. This field also renders register StatAlarmStatus inoperative. When parameter statisticsCounterAlarm is set to False, the StatCondDump register bit is reserved.
                    }
                }
                field INTRUSIVEMODE @'h6 {
                    access ro;
                    hard_reset 'h0;
                    doc {
                        When set to 1, register field IntrusiveMode enables trace operation in Intrusive flow-control mode. When set to 0, the register  enables trace operation in Overflow flow-control mode
                    }
                }
                field FILTBYTEALWAYSCHAINABLEEN @'h7 {
                    access rw;
                    hard_reset 'h0;
                    doc {
                        When set to 0, filters are mapped to all statistic counters when counting bytes or enabled bytes. Therefore, only filter events mapped to even counters can be counted using a pair of chained counters.When set to 1, filters are mapped only to even statistic counters when counting bytes or enabled bytes. Thus events from any filter can be counted using a pair of chained counters.
                    }
                }
                doc {
                    Register MainCtl contains probe global control bits. The register has seven bit fields:Register MainCtl contains probe global control bits. The register has seven bit fields:
                }
            }
            register ccf_Probe_T_sip2_main_Probe_CfgCtl @0xC {
                bytes 4;
                field GLOBALEN @'h0 {
                    access rw;
                    hard_reset 'h0;
                }
                field ACTIVE @'h1 {
                    access ro;
                    hard_reset 'h0;
                }
            }
            register ccf_Probe_T_sip2_main_Probe_Reserved_00 @0x10 {
                bytes 4;
                field ccf_Probe_T_sip2_main_Probe_Reserved_00 {
                    bits 32;
                    access rw;
                    hard_reset 'h0;
                }
            }
            register ccf_Probe_T_sip2_main_Probe_Reserved_01 @0x14 {
                bytes 4;
                field ccf_Probe_T_sip2_main_Probe_Reserved_01 {
                    bits 32;
                    access rw;
                    hard_reset 'h0;
                }
            }
            register ccf_Probe_T_sip2_main_Probe_Reserved_02 @0x18 {
                bytes 4;
                field ccf_Probe_T_sip2_main_Probe_Reserved_02 {
                    bits 32;
                    access rw;
                    hard_reset 'h0;
                }
            }
            register ccf_Probe_T_sip2_main_Probe_Reserved_03 @0x1C {
                bytes 4;
                field ccf_Probe_T_sip2_main_Probe_Reserved_03 {
                    bits 32;
                    access rw;
                    hard_reset 'h0;
                }
            }
            register ccf_Probe_T_sip2_main_Probe_Reserved_04 @0x20 {
                bytes 4;
                field ccf_Probe_T_sip2_main_Probe_Reserved_04 {
                    bits 32;
                    access rw;
                    hard_reset 'h0;
                }
            }
            register ccf_Probe_T_sip2_main_Probe_StatPeriod @0x24 {
                bytes 4;
                field STATPERIOD @'h0 {
                    bits 5;
                    access rw;
                    hard_reset 'h0;
                    doc {
                        Register StatPeriod is a 5-bit register that sets a period, within a range of 2 cycles to 2 gigacycles, during which statistics are collected before being dumped automatically. Setting the register implicitly enables automatic mode operation for statistics collection. The period is calculated with the formula: N_Cycle = 2**StatPeriodWhen register StatPeriod is set to its default value 0, automatic dump mode is disabled, and register StatGo is activated for manual mode operation. Note: When parameter statisticsCollection is set to False, StatPeriod is reserved.
                    }
                }
            }
            register ccf_Probe_T_sip2_main_Probe_StatGo @0x28 {
                bytes 4;
                field STATGO @'h0 {
                    access w1c;
                    hard_reset 'h0;
                    doc {
                        Writing a 1 to the 1-bit pulse register StatGo generates a statistics dump.The register is active when statistics collection operates in manual mode, that is, when register StatPeriod is set to 0.NOTE  The written value is not stored in StatGo. A read always returns 0.
                    }
                }
            }
            register ccf_Probe_T_sip2_main_Probe_StatAlarmMin @0x2C {
                bytes 4;
                field STATALARMMIN @'h0 {
                    bits 22;
                    access rw;
                    hard_reset 'h0;
                    doc {
                        Register StatAlarmMin contains the minimum count value used in statistics alarm comparisons. The number of bits is equal to twice the value set forparameter wStatisticsCounter. When parameter statisticsCounterAlarm is set to False, StatAlarmMin is reserved.
                    }
                }
            }
            register ccf_Probe_T_sip2_main_Probe_StatAlarmMax @0x30 {
                bytes 4;
                field STATALARMMAX @'h0 {
                    bits 22;
                    access rw;
                    hard_reset 'h0;
                    doc {
                        Register StatAlarmMax contains the maximum count value used in statistics alarm comparisons.The number of bits is equal to twice the value set for parameter wStatisticsCounter. When parameter statisticsCounterAlarm is set to False, StatAlarmMax is reserved.
                    }
                }
            }
            register ccf_Probe_T_sip2_main_Probe_StatAlarmStatus @0x34 {
                bytes 4;
                field STATALARMSTATUS @'h0 {
                    access ro;
                    hard_reset 'h0;
                    doc {
                        Register StatAlarmStatus is a read-only 1-bit register indicating that at least one statistics counter has exceeded the programmed values for registers StatAlarmMin or StatAlarmMax. Output signal StatAlarm is equal to the values stored in register MainCtl fields StatAlarmStatus and AlarmEn. When parameter statisticsCounterAlarm is set to False, StatAlarmStatus is reserved.
                    }
                }
            }
            register ccf_Probe_T_sip2_main_Probe_StatAlarmClr @0x38 {
                bytes 4;
                field STATALARMCLR @'h0 {
                    access w1c;
                    hard_reset 'h0;
                    doc {
                        Register StatAlarmClr is a 1-bit register. Writing a 1 to this register clears the StatAlarmStatus register bit.When parameter statisticsCounterAlarm is set to False, StatAlarmClr is reserved.NOTE  The written value is not stored in StatAlarmClr. A read always returns 0.
                    }
                }
            }
            register ccf_Probe_T_sip2_main_Probe_StatAlarmEn @0x3C {
                bytes 4;
                field STATALARMEN @'h0 {
                    access rw;
                    hard_reset 'h1;
                    doc {
                        Register StatAlarmEn is a 1-bit register. When set to 0 it masks StatAlarm and CtiTrigOut(1) signal interrupts.
                    }
                }
            }
            register ccf_Probe_T_sip2_main_Probe_Reserved_05 @0x40 {
                bytes 4;
                field ccf_Probe_T_sip2_main_Probe_Reserved_05 {
                    bits 32;
                    access rw;
                    hard_reset 'h0;
                }
            }
            register ccf_Probe_T_sip2_main_Probe_Reserved_06 @0x44 {
                bytes 4;
                field ccf_Probe_T_sip2_main_Probe_Reserved_06 {
                    bits 32;
                    access rw;
                    hard_reset 'h0;
                }
            }
            register ccf_Probe_T_sip2_main_Probe_Reserved_07 @0x48 {
                bytes 4;
                field ccf_Probe_T_sip2_main_Probe_Reserved_07 {
                    bits 32;
                    access rw;
                    hard_reset 'h0;
                }
            }
            register ccf_Probe_T_sip2_main_Probe_Reserved_08 @0x4C {
                bytes 4;
                field ccf_Probe_T_sip2_main_Probe_Reserved_08 {
                    bits 32;
                    access rw;
                    hard_reset 'h0;
                }
            }
            register ccf_Probe_T_sip2_main_Probe_Reserved_09 @0x50 {
                bytes 4;
                field ccf_Probe_T_sip2_main_Probe_Reserved_09 {
                    bits 32;
                    access rw;
                    hard_reset 'h0;
                }
            }
            register ccf_Probe_T_sip2_main_Probe_Reserved_10 @0x54 {
                bytes 4;
                field ccf_Probe_T_sip2_main_Probe_Reserved_10 {
                    bits 32;
                    access rw;
                    hard_reset 'h0;
                }
            }
            register ccf_Probe_T_sip2_main_Probe_Reserved_11 @0x58 {
                bytes 4;
                field ccf_Probe_T_sip2_main_Probe_Reserved_11 {
                    bits 32;
                    access rw;
                    hard_reset 'h0;
                }
            }
            register ccf_Probe_T_sip2_main_Probe_Reserved_12 @0x5C {
                bytes 4;
                field ccf_Probe_T_sip2_main_Probe_Reserved_12 {
                    bits 32;
                    access rw;
                    hard_reset 'h0;
                }
            }
            register ccf_Probe_T_sip2_main_Probe_Reserved_13 @0x60 {
                bytes 4;
                field ccf_Probe_T_sip2_main_Probe_Reserved_13 {
                    bits 32;
                    access rw;
                    hard_reset 'h0;
                }
            }
            register ccf_Probe_T_sip2_main_Probe_Reserved_14 @0x64 {
                bytes 4;
                field ccf_Probe_T_sip2_main_Probe_Reserved_14 {
                    bits 32;
                    access rw;
                    hard_reset 'h0;
                }
            }
            register ccf_Probe_T_sip2_main_Probe_Reserved_15 @0x68 {
                bytes 4;
                field ccf_Probe_T_sip2_main_Probe_Reserved_15 {
                    bits 32;
                    access rw;
                    hard_reset 'h0;
                }
            }
            register ccf_Probe_T_sip2_main_Probe_Reserved_16 @0x6C {
                bytes 4;
                field ccf_Probe_T_sip2_main_Probe_Reserved_16 {
                    bits 32;
                    access rw;
                    hard_reset 'h0;
                }
            }
            register ccf_Probe_T_sip2_main_Probe_Reserved_17 @0x70 {
                bytes 4;
                field ccf_Probe_T_sip2_main_Probe_Reserved_17 {
                    bits 32;
                    access rw;
                    hard_reset 'h0;
                }
            }
            register ccf_Probe_T_sip2_main_Probe_Reserved_18 @0x74 {
                bytes 4;
                field ccf_Probe_T_sip2_main_Probe_Reserved_18 {
                    bits 32;
                    access rw;
                    hard_reset 'h0;
                }
            }
            register ccf_Probe_T_sip2_main_Probe_Reserved_19 @0x78 {
                bytes 4;
                field ccf_Probe_T_sip2_main_Probe_Reserved_19 {
                    bits 32;
                    access rw;
                    hard_reset 'h0;
                }
            }
            register ccf_Probe_T_sip2_main_Probe_Reserved_20 @0x7C {
                bytes 4;
                field ccf_Probe_T_sip2_main_Probe_Reserved_20 {
                    bits 32;
                    access rw;
                    hard_reset 'h0;
                }
            }
            register ccf_Probe_T_sip2_main_Probe_Reserved_21 @0x80 {
                bytes 4;
                field ccf_Probe_T_sip2_main_Probe_Reserved_21 {
                    bits 32;
                    access rw;
                    hard_reset 'h0;
                }
            }
            register ccf_Probe_T_sip2_main_Probe_Reserved_22 @0x84 {
                bytes 4;
                field ccf_Probe_T_sip2_main_Probe_Reserved_22 {
                    bits 32;
                    access rw;
                    hard_reset 'h0;
                }
            }
            register ccf_Probe_T_sip2_main_Probe_Reserved_23 @0x88 {
                bytes 4;
                field ccf_Probe_T_sip2_main_Probe_Reserved_23 {
                    bits 32;
                    access rw;
                    hard_reset 'h0;
                }
            }
            register ccf_Probe_T_sip2_main_Probe_Reserved_24 @0x8C {
                bytes 4;
                field ccf_Probe_T_sip2_main_Probe_Reserved_24 {
                    bits 32;
                    access rw;
                    hard_reset 'h0;
                }
            }
            register ccf_Probe_T_sip2_main_Probe_Reserved_25 @0x90 {
                bytes 4;
                field ccf_Probe_T_sip2_main_Probe_Reserved_25 {
                    bits 32;
                    access rw;
                    hard_reset 'h0;
                }
            }
            register ccf_Probe_T_sip2_main_Probe_Reserved_26 @0x94 {
                bytes 4;
                field ccf_Probe_T_sip2_main_Probe_Reserved_26 {
                    bits 32;
                    access rw;
                    hard_reset 'h0;
                }
            }
            register ccf_Probe_T_sip2_main_Probe_Reserved_27 @0x98 {
                bytes 4;
                field ccf_Probe_T_sip2_main_Probe_Reserved_27 {
                    bits 32;
                    access rw;
                    hard_reset 'h0;
                }
            }
            register ccf_Probe_T_sip2_main_Probe_Reserved_28 @0x9C {
                bytes 4;
                field ccf_Probe_T_sip2_main_Probe_Reserved_28 {
                    bits 32;
                    access rw;
                    hard_reset 'h0;
                }
            }
            register ccf_Probe_T_sip2_main_Probe_Reserved_29 @0xA0 {
                bytes 4;
                field ccf_Probe_T_sip2_main_Probe_Reserved_29 {
                    bits 32;
                    access rw;
                    hard_reset 'h0;
                }
            }
            register ccf_Probe_T_sip2_main_Probe_Reserved_30 @0xA4 {
                bytes 4;
                field ccf_Probe_T_sip2_main_Probe_Reserved_30 {
                    bits 32;
                    access rw;
                    hard_reset 'h0;
                }
            }
            register ccf_Probe_T_sip2_main_Probe_Reserved_31 @0xA8 {
                bytes 4;
                field ccf_Probe_T_sip2_main_Probe_Reserved_31 {
                    bits 32;
                    access rw;
                    hard_reset 'h0;
                }
            }
            register ccf_Probe_T_sip2_main_Probe_Reserved_32 @0xAC {
                bytes 4;
                field ccf_Probe_T_sip2_main_Probe_Reserved_32 {
                    bits 32;
                    access rw;
                    hard_reset 'h0;
                }
            }
            register ccf_Probe_T_sip2_main_Probe_Reserved_33 @0xB0 {
                bytes 4;
                field ccf_Probe_T_sip2_main_Probe_Reserved_33 {
                    bits 32;
                    access rw;
                    hard_reset 'h0;
                }
            }
            register ccf_Probe_T_sip2_main_Probe_Reserved_34 @0xB4 {
                bytes 4;
                field ccf_Probe_T_sip2_main_Probe_Reserved_34 {
                    bits 32;
                    access rw;
                    hard_reset 'h0;
                }
            }
            register ccf_Probe_T_sip2_main_Probe_Reserved_35 @0xB8 {
                bytes 4;
                field ccf_Probe_T_sip2_main_Probe_Reserved_35 {
                    bits 32;
                    access rw;
                    hard_reset 'h0;
                }
            }
            register ccf_Probe_T_sip2_main_Probe_Reserved_36 @0xBC {
                bytes 4;
                field ccf_Probe_T_sip2_main_Probe_Reserved_36 {
                    bits 32;
                    access rw;
                    hard_reset 'h0;
                }
            }
            register ccf_Probe_T_sip2_main_Probe_Reserved_37 @0xC0 {
                bytes 4;
                field ccf_Probe_T_sip2_main_Probe_Reserved_37 {
                    bits 32;
                    access rw;
                    hard_reset 'h0;
                }
            }
            register ccf_Probe_T_sip2_main_Probe_Reserved_38 @0xC4 {
                bytes 4;
                field ccf_Probe_T_sip2_main_Probe_Reserved_38 {
                    bits 32;
                    access rw;
                    hard_reset 'h0;
                }
            }
            register ccf_Probe_T_sip2_main_Probe_Reserved_39 @0xC8 {
                bytes 4;
                field ccf_Probe_T_sip2_main_Probe_Reserved_39 {
                    bits 32;
                    access rw;
                    hard_reset 'h0;
                }
            }
            register ccf_Probe_T_sip2_main_Probe_Reserved_40 @0xCC {
                bytes 4;
                field ccf_Probe_T_sip2_main_Probe_Reserved_40 {
                    bits 32;
                    access rw;
                    hard_reset 'h0;
                }
            }
            register ccf_Probe_T_sip2_main_Probe_Reserved_41 @0xD0 {
                bytes 4;
                field ccf_Probe_T_sip2_main_Probe_Reserved_41 {
                    bits 32;
                    access rw;
                    hard_reset 'h0;
                }
            }
            register ccf_Probe_T_sip2_main_Probe_Reserved_42 @0xD4 {
                bytes 4;
                field ccf_Probe_T_sip2_main_Probe_Reserved_42 {
                    bits 32;
                    access rw;
                    hard_reset 'h0;
                }
            }
            register ccf_Probe_T_sip2_main_Probe_Reserved_43 @0xD8 {
                bytes 4;
                field ccf_Probe_T_sip2_main_Probe_Reserved_43 {
                    bits 32;
                    access rw;
                    hard_reset 'h0;
                }
            }
            register ccf_Probe_T_sip2_main_Probe_Reserved_44 @0xDC {
                bytes 4;
                field ccf_Probe_T_sip2_main_Probe_Reserved_44 {
                    bits 32;
                    access rw;
                    hard_reset 'h0;
                }
            }
            register ccf_Probe_T_sip2_main_Probe_Reserved_45 @0xE0 {
                bytes 4;
                field ccf_Probe_T_sip2_main_Probe_Reserved_45 {
                    bits 32;
                    access rw;
                    hard_reset 'h0;
                }
            }
            register ccf_Probe_T_sip2_main_Probe_Reserved_46 @0xE4 {
                bytes 4;
                field ccf_Probe_T_sip2_main_Probe_Reserved_46 {
                    bits 32;
                    access rw;
                    hard_reset 'h0;
                }
            }
            register ccf_Probe_T_sip2_main_Probe_Reserved_47 @0xE8 {
                bytes 4;
                field ccf_Probe_T_sip2_main_Probe_Reserved_47 {
                    bits 32;
                    access rw;
                    hard_reset 'h0;
                }
            }
            register ccf_Probe_T_sip2_main_Probe_Reserved_48 @0xEC {
                bytes 4;
                field ccf_Probe_T_sip2_main_Probe_Reserved_48 {
                    bits 32;
                    access rw;
                    hard_reset 'h0;
                }
            }
            register ccf_Probe_T_sip2_main_Probe_Reserved_49 @0xF0 {
                bytes 4;
                field ccf_Probe_T_sip2_main_Probe_Reserved_49 {
                    bits 32;
                    access rw;
                    hard_reset 'h0;
                }
            }
            register ccf_Probe_T_sip2_main_Probe_Reserved_50 @0xF4 {
                bytes 4;
                field ccf_Probe_T_sip2_main_Probe_Reserved_50 {
                    bits 32;
                    access rw;
                    hard_reset 'h0;
                }
            }
            register ccf_Probe_T_sip2_main_Probe_Reserved_51 @0xF8 {
                bytes 4;
                field ccf_Probe_T_sip2_main_Probe_Reserved_51 {
                    bits 32;
                    access rw;
                    hard_reset 'h0;
                }
            }
            register ccf_Probe_T_sip2_main_Probe_Reserved_52 @0xFC {
                bytes 4;
                field ccf_Probe_T_sip2_main_Probe_Reserved_52 {
                    bits 32;
                    access rw;
                    hard_reset 'h0;
                }
            }
            register ccf_Probe_T_sip2_main_Probe_Reserved_53 @0x100 {
                bytes 4;
                field ccf_Probe_T_sip2_main_Probe_Reserved_53 {
                    bits 32;
                    access rw;
                    hard_reset 'h0;
                }
            }
            register ccf_Probe_T_sip2_main_Probe_Reserved_54 @0x104 {
                bytes 4;
                field ccf_Probe_T_sip2_main_Probe_Reserved_54 {
                    bits 32;
                    access rw;
                    hard_reset 'h0;
                }
            }
            register ccf_Probe_T_sip2_main_Probe_Reserved_55 @0x108 {
                bytes 4;
                field ccf_Probe_T_sip2_main_Probe_Reserved_55 {
                    bits 32;
                    access rw;
                    hard_reset 'h0;
                }
            }
            register ccf_Probe_T_sip2_main_Probe_Reserved_56 @0x10C {
                bytes 4;
                field ccf_Probe_T_sip2_main_Probe_Reserved_56 {
                    bits 32;
                    access rw;
                    hard_reset 'h0;
                }
            }
            register ccf_Probe_T_sip2_main_Probe_Reserved_57 @0x110 {
                bytes 4;
                field ccf_Probe_T_sip2_main_Probe_Reserved_57 {
                    bits 32;
                    access rw;
                    hard_reset 'h0;
                }
            }
            register ccf_Probe_T_sip2_main_Probe_Reserved_58 @0x114 {
                bytes 4;
                field ccf_Probe_T_sip2_main_Probe_Reserved_58 {
                    bits 32;
                    access rw;
                    hard_reset 'h0;
                }
            }
            register ccf_Probe_T_sip2_main_Probe_Reserved_59 @0x118 {
                bytes 4;
                field ccf_Probe_T_sip2_main_Probe_Reserved_59 {
                    bits 32;
                    access rw;
                    hard_reset 'h0;
                }
            }
            register ccf_Probe_T_sip2_main_Probe_Reserved_60 @0x11C {
                bytes 4;
                field ccf_Probe_T_sip2_main_Probe_Reserved_60 {
                    bits 32;
                    access rw;
                    hard_reset 'h0;
                }
            }
            register ccf_Probe_T_sip2_main_Probe_Reserved_61 @0x120 {
                bytes 4;
                field ccf_Probe_T_sip2_main_Probe_Reserved_61 {
                    bits 32;
                    access rw;
                    hard_reset 'h0;
                }
            }
            register ccf_Probe_T_sip2_main_Probe_Reserved_62 @0x124 {
                bytes 4;
                field ccf_Probe_T_sip2_main_Probe_Reserved_62 {
                    bits 32;
                    access rw;
                    hard_reset 'h0;
                }
            }
            register ccf_Probe_T_sip2_main_Probe_Reserved_63 @0x128 {
                bytes 4;
                field ccf_Probe_T_sip2_main_Probe_Reserved_63 {
                    bits 32;
                    access rw;
                    hard_reset 'h0;
                }
            }
            register ccf_Probe_T_sip2_main_Probe_Reserved_64 @0x12C {
                bytes 4;
                field ccf_Probe_T_sip2_main_Probe_Reserved_64 {
                    bits 32;
                    access rw;
                    hard_reset 'h0;
                }
            }
            register ccf_Probe_T_sip2_main_Probe_Reserved_65 @0x130 {
                bytes 4;
                field ccf_Probe_T_sip2_main_Probe_Reserved_65 {
                    bits 32;
                    access rw;
                    hard_reset 'h0;
                }
            }
            register ccf_Probe_T_sip2_main_Probe_Reserved_66 @0x134 {
                bytes 4;
                field ccf_Probe_T_sip2_main_Probe_Reserved_66 {
                    bits 32;
                    access rw;
                    hard_reset 'h0;
                }
            }
            register ccf_Probe_T_sip2_main_Probe_Counters_0_Src @0x138 {
                bytes 4;
                field INTEVENT @'h0 {
                    bits 5;
                    access rw;
                    hard_reset 'h0;
                    enum { OFF = 0, CYCLE = 1, IDLE = 2, XFER = 3, BUSY = 4, WAIT = 5, PKT = 6, LUT = 7, BYTE = 8, PRESS0 = 9, PRESS1 = 10, PRESS2 = 11, FILT0 = 12, FILT1 = 13, FILT2 = 14, FILT3 = 15, CHAIN = 16, LUT_BYTE_EN = 17, LUT_BYTE = 18, FILT_BYTE_EN = 19, FILT_BYTE = 20, PRESS3 = 21, PRESS4 = 22, PRESS5 = 23, PRESS6 = 24, RSV_0 = 25, RSV_1 = 26, RSV_2 = 27, RSV_3 = 28, RSV_4 = 29, RSV_5 = 30, RSV_6 = 31 };
                    doc {
                        Internal packet event
                    }
                }
                field EXTEVENT @'h5 {
                    access rw;
                    hard_reset 'h0;
                    doc {
                        When greater than 0, the entire register value is used to select an external hardware event source. The index of the external event is equal to {ExtEvent,IntEvent}.
                    }
                }
                doc {
                    Register CntSrc indicates the event source used to increment the counter. Unassigned values (non-existing Press level or ExtEvent index, or unimplemented Filter) are equivalent to OFF.
	Register CntSrc indicates the event source used to increment the counter. Unassigned values (non-existing Press level or ExtEvent index, or unimplemented Filter) are equivalent to OFF.
	
                }
            }
            register ccf_Probe_T_sip2_main_Probe_Counters_0_AlarmMode @0x13C {
                bytes 4;
                field COUNTERS_0_ALARMMODE @'h0 {
                    bits 2;
                    access rw;
                    hard_reset 'h0;
                    enum { OFF = 0, MIN = 1, MAX = 2, MIN_MAX = 3 };
                    doc {
                        Register AlarmMode is a 2-bit register that is present when parameter statisticsCounterAlarm is set to True. The register defines the statistics-alarm behavior of the counter.
                    }
                }
            }
            register ccf_Probe_T_sip2_main_Probe_Counters_0_Val @0x140 {
                bytes 4;
                field COUNTERS_0_VAL @'h0 {
                    bits 11;
                    access ro;
                    hard_reset 'h0;
                    doc {
                        Register Val is a read-only register that is always present. The register containsthe statistics counter value either pending StatAlarm output, or when statisticscollection is suspended subsequent to triggers or signal statSuspend.
                    }
                }
            }
            register ccf_Probe_T_sip2_main_Probe_Reserved_67 @0x144 {
                bytes 4;
                field ccf_Probe_T_sip2_main_Probe_Reserved_67 {
                    bits 32;
                    access rw;
                    hard_reset 'h0;
                }
            }
            register ccf_Probe_T_sip2_main_Probe_Reserved_68 @0x148 {
                bytes 4;
                field ccf_Probe_T_sip2_main_Probe_Reserved_68 {
                    bits 32;
                    access rw;
                    hard_reset 'h0;
                }
            }
            register ccf_Probe_T_sip2_main_Probe_Counters_1_Src @0x14C {
                bytes 4;
                field INTEVENT @'h0 {
                    bits 5;
                    access rw;
                    hard_reset 'h0;
                    enum { OFF = 0, CYCLE = 1, IDLE = 2, XFER = 3, BUSY = 4, WAIT = 5, PKT = 6, LUT = 7, BYTE = 8, PRESS0 = 9, PRESS1 = 10, PRESS2 = 11, FILT0 = 12, FILT1 = 13, FILT2 = 14, FILT3 = 15, CHAIN = 16, LUT_BYTE_EN = 17, LUT_BYTE = 18, FILT_BYTE_EN = 19, FILT_BYTE = 20, PRESS3 = 21, PRESS4 = 22, PRESS5 = 23, PRESS6 = 24, RSV_0 = 25, RSV_1 = 26, RSV_2 = 27, RSV_3 = 28, RSV_4 = 29, RSV_5 = 30, RSV_6 = 31 };
                    doc {
                        Internal packet event
                    }
                }
                field EXTEVENT @'h5 {
                    access rw;
                    hard_reset 'h0;
                    doc {
                        When greater than 0, the entire register value is used to select an external hardware event source. The index of the external event is equal to {ExtEvent,IntEvent}.
                    }
                }
                doc {
                    Register CntSrc indicates the event source used to increment the counter. Unassigned values (non-existing Press level or ExtEvent index, or unimplemented Filter) are equivalent to OFF.
	Register CntSrc indicates the event source used to increment the counter. Unassigned values (non-existing Press level or ExtEvent index, or unimplemented Filter) are equivalent to OFF.
	
                }
            }
            register ccf_Probe_T_sip2_main_Probe_Counters_1_AlarmMode @0x150 {
                bytes 4;
                field COUNTERS_1_ALARMMODE @'h0 {
                    bits 2;
                    access rw;
                    hard_reset 'h0;
                    enum { OFF = 0, MIN = 1, MAX = 2, MIN_MAX = 3 };
                    doc {
                        Register AlarmMode is a 2-bit register that is present when parameter statisticsCounterAlarm is set to True. The register defines the statistics-alarm behavior of the counter.
                    }
                }
            }
            register ccf_Probe_T_sip2_main_Probe_Counters_1_Val @0x154 {
                bytes 4;
                field COUNTERS_1_VAL @'h0 {
                    bits 11;
                    access ro;
                    hard_reset 'h0;
                    doc {
                        Register Val is a read-only register that is always present. The register containsthe statistics counter value either pending StatAlarm output, or when statisticscollection is suspended subsequent to triggers or signal statSuspend.
                    }
                }
            }
            register ccf_Probe_T_sip2_main_Probe_Reserved_69 @0x158 {
                bytes 4;
                field ccf_Probe_T_sip2_main_Probe_Reserved_69 {
                    bits 32;
                    access rw;
                    hard_reset 'h0;
                }
            }
            register ccf_Probe_T_sip2_main_Probe_Reserved_70 @0x15C {
                bytes 4;
                field ccf_Probe_T_sip2_main_Probe_Reserved_70 {
                    bits 32;
                    access rw;
                    hard_reset 'h0;
                }
            }
            register ccf_Probe_T_sip2_main_Probe_Reserved_71 @0x160 {
                bytes 4;
                field ccf_Probe_T_sip2_main_Probe_Reserved_71 {
                    bits 32;
                    access rw;
                    hard_reset 'h0;
                }
            }
            register ccf_Probe_T_sip2_main_Probe_Reserved_72 @0x164 {
                bytes 4;
                field ccf_Probe_T_sip2_main_Probe_Reserved_72 {
                    bits 32;
                    access rw;
                    hard_reset 'h0;
                }
            }
            register ccf_Probe_T_sip2_main_Probe_Reserved_73 @0x168 {
                bytes 4;
                field ccf_Probe_T_sip2_main_Probe_Reserved_73 {
                    bits 32;
                    access rw;
                    hard_reset 'h0;
                }
            }
            register ccf_Probe_T_sip2_main_Probe_Reserved_74 @0x16C {
                bytes 4;
                field ccf_Probe_T_sip2_main_Probe_Reserved_74 {
                    bits 32;
                    access rw;
                    hard_reset 'h0;
                }
            }
            register ccf_Probe_T_sip2_main_Probe_Reserved_75 @0x170 {
                bytes 4;
                field ccf_Probe_T_sip2_main_Probe_Reserved_75 {
                    bits 32;
                    access rw;
                    hard_reset 'h0;
                }
            }
            register ccf_Probe_T_sip2_main_Probe_Reserved_76 @0x174 {
                bytes 4;
                field ccf_Probe_T_sip2_main_Probe_Reserved_76 {
                    bits 32;
                    access rw;
                    hard_reset 'h0;
                }
            }
            register ccf_Probe_T_sip2_main_Probe_Reserved_77 @0x178 {
                bytes 4;
                field ccf_Probe_T_sip2_main_Probe_Reserved_77 {
                    bits 32;
                    access rw;
                    hard_reset 'h0;
                }
            }
            register ccf_Probe_T_sip2_main_Probe_Reserved_78 @0x17C {
                bytes 4;
                field ccf_Probe_T_sip2_main_Probe_Reserved_78 {
                    bits 32;
                    access rw;
                    hard_reset 'h0;
                }
            }
            register ccf_Probe_T_sip2_main_Probe_Reserved_79 @0x180 {
                bytes 4;
                field ccf_Probe_T_sip2_main_Probe_Reserved_79 {
                    bits 32;
                    access rw;
                    hard_reset 'h0;
                }
            }
            register ccf_Probe_T_sip2_main_Probe_Reserved_80 @0x184 {
                bytes 4;
                field ccf_Probe_T_sip2_main_Probe_Reserved_80 {
                    bits 32;
                    access rw;
                    hard_reset 'h0;
                }
            }
            register ccf_Probe_T_sip2_main_Probe_Reserved_81 @0x188 {
                bytes 4;
                field ccf_Probe_T_sip2_main_Probe_Reserved_81 {
                    bits 32;
                    access rw;
                    hard_reset 'h0;
                }
            }
            register ccf_Probe_T_sip2_main_Probe_Reserved_82 @0x18C {
                bytes 4;
                field ccf_Probe_T_sip2_main_Probe_Reserved_82 {
                    bits 32;
                    access rw;
                    hard_reset 'h0;
                }
            }
            register ccf_Probe_T_sip2_main_Probe_Reserved_83 @0x190 {
                bytes 4;
                field ccf_Probe_T_sip2_main_Probe_Reserved_83 {
                    bits 32;
                    access rw;
                    hard_reset 'h0;
                }
            }
            register ccf_Probe_T_sip2_main_Probe_Reserved_84 @0x194 {
                bytes 4;
                field ccf_Probe_T_sip2_main_Probe_Reserved_84 {
                    bits 32;
                    access rw;
                    hard_reset 'h0;
                }
            }
            register ccf_Probe_T_sip2_main_Probe_Reserved_85 @0x198 {
                bytes 4;
                field ccf_Probe_T_sip2_main_Probe_Reserved_85 {
                    bits 32;
                    access rw;
                    hard_reset 'h0;
                }
            }
            register ccf_Probe_T_sip2_main_Probe_Reserved_86 @0x19C {
                bytes 4;
                field ccf_Probe_T_sip2_main_Probe_Reserved_86 {
                    bits 32;
                    access rw;
                    hard_reset 'h0;
                }
            }
            register ccf_Probe_T_sip2_main_Probe_Reserved_87 @0x1A0 {
                bytes 4;
                field ccf_Probe_T_sip2_main_Probe_Reserved_87 {
                    bits 32;
                    access rw;
                    hard_reset 'h0;
                }
            }
            register ccf_Probe_T_sip2_main_Probe_Reserved_88 @0x1A4 {
                bytes 4;
                field ccf_Probe_T_sip2_main_Probe_Reserved_88 {
                    bits 32;
                    access rw;
                    hard_reset 'h0;
                }
            }
            register ccf_Probe_T_sip2_main_Probe_Reserved_89 @0x1A8 {
                bytes 4;
                field ccf_Probe_T_sip2_main_Probe_Reserved_89 {
                    bits 32;
                    access rw;
                    hard_reset 'h0;
                }
            }
            register ccf_Probe_T_sip2_main_Probe_Reserved_90 @0x1AC {
                bytes 4;
                field ccf_Probe_T_sip2_main_Probe_Reserved_90 {
                    bits 32;
                    access rw;
                    hard_reset 'h0;
                }
            }
            register ccf_Probe_T_sip2_main_Probe_Reserved_91 @0x1B0 {
                bytes 4;
                field ccf_Probe_T_sip2_main_Probe_Reserved_91 {
                    bits 32;
                    access rw;
                    hard_reset 'h0;
                }
            }
            register ccf_Probe_T_sip2_main_Probe_Reserved_92 @0x1B4 {
                bytes 4;
                field ccf_Probe_T_sip2_main_Probe_Reserved_92 {
                    bits 32;
                    access rw;
                    hard_reset 'h0;
                }
            }
            register ccf_Probe_T_sip2_main_Probe_Reserved_93 @0x1B8 {
                bytes 4;
                field ccf_Probe_T_sip2_main_Probe_Reserved_93 {
                    bits 32;
                    access rw;
                    hard_reset 'h0;
                }
            }
            register ccf_Probe_T_sip2_main_Probe_Reserved_94 @0x1BC {
                bytes 4;
                field ccf_Probe_T_sip2_main_Probe_Reserved_94 {
                    bits 32;
                    access rw;
                    hard_reset 'h0;
                }
            }
            register ccf_Probe_T_sip2_main_Probe_Reserved_95 @0x1C0 {
                bytes 4;
                field ccf_Probe_T_sip2_main_Probe_Reserved_95 {
                    bits 32;
                    access rw;
                    hard_reset 'h0;
                }
            }
            register ccf_Probe_T_sip2_main_Probe_Reserved_96 @0x1C4 {
                bytes 4;
                field ccf_Probe_T_sip2_main_Probe_Reserved_96 {
                    bits 32;
                    access rw;
                    hard_reset 'h0;
                }
            }
            register ccf_Probe_T_sip2_main_Probe_Reserved_97 @0x1C8 {
                bytes 4;
                field ccf_Probe_T_sip2_main_Probe_Reserved_97 {
                    bits 32;
                    access rw;
                    hard_reset 'h0;
                }
            }
            register ccf_Probe_T_sip2_main_Probe_Reserved_98 @0x1CC {
                bytes 4;
                field ccf_Probe_T_sip2_main_Probe_Reserved_98 {
                    bits 32;
                    access rw;
                    hard_reset 'h0;
                }
            }
            register ccf_Probe_T_sip2_main_Probe_Reserved_99 @0x1D0 {
                bytes 4;
                field ccf_Probe_T_sip2_main_Probe_Reserved_99 {
                    bits 32;
                    access rw;
                    hard_reset 'h0;
                }
            }
            register ccf_Probe_T_sip2_main_Probe_Reserved_100 @0x1D4 {
                bytes 4;
                field ccf_Probe_T_sip2_main_Probe_Reserved_100 {
                    bits 32;
                    access rw;
                    hard_reset 'h0;
                }
            }
            register ccf_Probe_T_sip2_main_Probe_Reserved_101 @0x1D8 {
                bytes 4;
                field ccf_Probe_T_sip2_main_Probe_Reserved_101 {
                    bits 32;
                    access rw;
                    hard_reset 'h0;
                }
            }
            register ccf_Probe_T_sip2_main_Probe_Reserved_102 @0x1DC {
                bytes 4;
                field ccf_Probe_T_sip2_main_Probe_Reserved_102 {
                    bits 32;
                    access rw;
                    hard_reset 'h0;
                }
            }
            register ccf_Probe_T_sip2_main_Probe_Reserved_103 @0x1E0 {
                bytes 4;
                field ccf_Probe_T_sip2_main_Probe_Reserved_103 {
                    bits 32;
                    access rw;
                    hard_reset 'h0;
                }
            }
            register ccf_Probe_T_sip2_main_Probe_Reserved_104 @0x1E4 {
                bytes 4;
                field ccf_Probe_T_sip2_main_Probe_Reserved_104 {
                    bits 32;
                    access rw;
                    hard_reset 'h0;
                }
            }
            register ccf_Probe_T_sip2_main_Probe_Reserved_105 @0x1E8 {
                bytes 4;
                field ccf_Probe_T_sip2_main_Probe_Reserved_105 {
                    bits 32;
                    access rw;
                    hard_reset 'h0;
                }
            }
            register ccf_Probe_T_sip2_main_Probe_Reserved_106 @0x1EC {
                bytes 4;
                field ccf_Probe_T_sip2_main_Probe_Reserved_106 {
                    bits 32;
                    access rw;
                    hard_reset 'h0;
                }
            }
            register ccf_Probe_T_sip2_main_Probe_Reserved_107 @0x1F0 {
                bytes 4;
                field ccf_Probe_T_sip2_main_Probe_Reserved_107 {
                    bits 32;
                    access rw;
                    hard_reset 'h0;
                }
            }
            register ccf_Probe_T_sip2_main_Probe_Reserved_108 @0x1F4 {
                bytes 4;
                field ccf_Probe_T_sip2_main_Probe_Reserved_108 {
                    bits 32;
                    access rw;
                    hard_reset 'h0;
                }
            }
            register ccf_Probe_T_sip2_main_Probe_Reserved_109 @0x1F8 {
                bytes 4;
                field ccf_Probe_T_sip2_main_Probe_Reserved_109 {
                    bits 32;
                    access rw;
                    hard_reset 'h0;
                }
            }
            register ccf_Probe_T_sip2_main_Probe_Reserved_110 @0x1FC {
                bytes 4;
                field ccf_Probe_T_sip2_main_Probe_Reserved_110 {
                    bits 32;
                    access rw;
                    hard_reset 'h0;
                }
            }
            register ccf_Probe_T_sip2_main_Probe_Reserved_111 @0x200 {
                bytes 4;
                field ccf_Probe_T_sip2_main_Probe_Reserved_111 {
                    bits 32;
                    access rw;
                    hard_reset 'h0;
                }
            }
            register ccf_Probe_T_sip2_main_Probe_Reserved_112 @0x204 {
                bytes 4;
                field ccf_Probe_T_sip2_main_Probe_Reserved_112 {
                    bits 32;
                    access rw;
                    hard_reset 'h0;
                }
            }
            register ccf_Probe_T_sip2_main_Probe_Reserved_113 @0x208 {
                bytes 4;
                field ccf_Probe_T_sip2_main_Probe_Reserved_113 {
                    bits 32;
                    access rw;
                    hard_reset 'h0;
                }
            }
            register ccf_Probe_T_sip2_main_Probe_Reserved_114 @0x20C {
                bytes 4;
                field ccf_Probe_T_sip2_main_Probe_Reserved_114 {
                    bits 32;
                    access rw;
                    hard_reset 'h0;
                }
            }
            register ccf_Probe_T_sip2_main_Probe_Reserved_115 @0x210 {
                bytes 4;
                field ccf_Probe_T_sip2_main_Probe_Reserved_115 {
                    bits 32;
                    access rw;
                    hard_reset 'h0;
                }
            }
            register ccf_Probe_T_sip2_main_Probe_Reserved_116 @0x214 {
                bytes 4;
                field ccf_Probe_T_sip2_main_Probe_Reserved_116 {
                    bits 32;
                    access rw;
                    hard_reset 'h0;
                }
            }
            register ccf_Probe_T_sip2_main_Probe_Reserved_117 @0x218 {
                bytes 4;
                field ccf_Probe_T_sip2_main_Probe_Reserved_117 {
                    bits 32;
                    access rw;
                    hard_reset 'h0;
                }
            }
            register ccf_Probe_T_sip2_main_Probe_Reserved_118 @0x21C {
                bytes 4;
                field ccf_Probe_T_sip2_main_Probe_Reserved_118 {
                    bits 32;
                    access rw;
                    hard_reset 'h0;
                }
            }
            register ccf_Probe_T_sip2_main_Probe_Reserved_119 @0x220 {
                bytes 4;
                field ccf_Probe_T_sip2_main_Probe_Reserved_119 {
                    bits 32;
                    access rw;
                    hard_reset 'h0;
                }
            }
            register ccf_Probe_T_sip2_main_Probe_Reserved_120 @0x224 {
                bytes 4;
                field ccf_Probe_T_sip2_main_Probe_Reserved_120 {
                    bits 32;
                    access rw;
                    hard_reset 'h0;
                }
            }
            register ccf_Probe_T_sip2_main_Probe_Reserved_121 @0x228 {
                bytes 4;
                field ccf_Probe_T_sip2_main_Probe_Reserved_121 {
                    bits 32;
                    access rw;
                    hard_reset 'h0;
                }
            }
            register ccf_Probe_T_sip2_main_Probe_Reserved_122 @0x22C {
                bytes 4;
                field ccf_Probe_T_sip2_main_Probe_Reserved_122 {
                    bits 32;
                    access rw;
                    hard_reset 'h0;
                }
            }
            register ccf_Probe_T_sip2_main_Probe_Reserved_123 @0x230 {
                bytes 4;
                field ccf_Probe_T_sip2_main_Probe_Reserved_123 {
                    bits 32;
                    access rw;
                    hard_reset 'h0;
                }
            }
            register ccf_Probe_T_sip2_main_Probe_Reserved_124 @0x234 {
                bytes 4;
                field ccf_Probe_T_sip2_main_Probe_Reserved_124 {
                    bits 32;
                    access rw;
                    hard_reset 'h0;
                }
            }
            register ccf_Probe_T_sip2_main_Probe_Reserved_125 @0x238 {
                bytes 4;
                field ccf_Probe_T_sip2_main_Probe_Reserved_125 {
                    bits 32;
                    access rw;
                    hard_reset 'h0;
                }
            }
            register ccf_Probe_T_sip2_main_Probe_Reserved_126 @0x23C {
                bytes 4;
                field ccf_Probe_T_sip2_main_Probe_Reserved_126 {
                    bits 32;
                    access rw;
                    hard_reset 'h0;
                }
            }
            register ccf_Probe_T_sip2_main_Probe_Reserved_127 @0x240 {
                bytes 4;
                field ccf_Probe_T_sip2_main_Probe_Reserved_127 {
                    bits 32;
                    access rw;
                    hard_reset 'h0;
                }
            }
            register ccf_Probe_T_sip2_main_Probe_Reserved_128 @0x244 {
                bytes 4;
                field ccf_Probe_T_sip2_main_Probe_Reserved_128 {
                    bits 32;
                    access rw;
                    hard_reset 'h0;
                }
            }
            register ccf_Probe_T_sip2_main_Probe_Reserved_129 @0x248 {
                bytes 4;
                field ccf_Probe_T_sip2_main_Probe_Reserved_129 {
                    bits 32;
                    access rw;
                    hard_reset 'h0;
                }
            }
            register ccf_Probe_T_sip2_main_Probe_Reserved_130 @0x24C {
                bytes 4;
                field ccf_Probe_T_sip2_main_Probe_Reserved_130 {
                    bits 32;
                    access rw;
                    hard_reset 'h0;
                }
            }
            register ccf_Probe_T_sip2_main_Probe_Reserved_131 @0x250 {
                bytes 4;
                field ccf_Probe_T_sip2_main_Probe_Reserved_131 {
                    bits 32;
                    access rw;
                    hard_reset 'h0;
                }
            }
            register ccf_Probe_T_sip2_main_Probe_Reserved_132 @0x254 {
                bytes 4;
                field ccf_Probe_T_sip2_main_Probe_Reserved_132 {
                    bits 32;
                    access rw;
                    hard_reset 'h0;
                }
            }
            register ccf_Probe_T_sip2_main_Probe_Reserved_133 @0x258 {
                bytes 4;
                field ccf_Probe_T_sip2_main_Probe_Reserved_133 {
                    bits 32;
                    access rw;
                    hard_reset 'h0;
                }
            }
            register ccf_Probe_T_sip2_main_Probe_Reserved_134 @0x25C {
                bytes 4;
                field ccf_Probe_T_sip2_main_Probe_Reserved_134 {
                    bits 32;
                    access rw;
                    hard_reset 'h0;
                }
            }
            register ccf_Probe_T_sip2_main_Probe_Reserved_135 @0x260 {
                bytes 4;
                field ccf_Probe_T_sip2_main_Probe_Reserved_135 {
                    bits 32;
                    access rw;
                    hard_reset 'h0;
                }
            }
            register ccf_Probe_T_sip2_main_Probe_Reserved_136 @0x264 {
                bytes 4;
                field ccf_Probe_T_sip2_main_Probe_Reserved_136 {
                    bits 32;
                    access rw;
                    hard_reset 'h0;
                }
            }
            register ccf_Probe_T_sip2_main_Probe_Reserved_137 @0x268 {
                bytes 4;
                field ccf_Probe_T_sip2_main_Probe_Reserved_137 {
                    bits 32;
                    access rw;
                    hard_reset 'h0;
                }
            }
            register ccf_Probe_T_sip2_main_Probe_Reserved_138 @0x26C {
                bytes 4;
                field ccf_Probe_T_sip2_main_Probe_Reserved_138 {
                    bits 32;
                    access rw;
                    hard_reset 'h0;
                }
            }
            register ccf_Probe_T_sip2_main_Probe_Reserved_139 @0x270 {
                bytes 4;
                field ccf_Probe_T_sip2_main_Probe_Reserved_139 {
                    bits 32;
                    access rw;
                    hard_reset 'h0;
                }
            }
            register ccf_Probe_T_sip2_main_Probe_Reserved_140 @0x274 {
                bytes 4;
                field ccf_Probe_T_sip2_main_Probe_Reserved_140 {
                    bits 32;
                    access rw;
                    hard_reset 'h0;
                }
            }
            register ccf_Probe_T_sip2_main_Probe_Reserved_141 @0x278 {
                bytes 4;
                field ccf_Probe_T_sip2_main_Probe_Reserved_141 {
                    bits 32;
                    access rw;
                    hard_reset 'h0;
                }
            }
            register ccf_Probe_T_sip2_main_Probe_Reserved_142 @0x27C {
                bytes 4;
                field ccf_Probe_T_sip2_main_Probe_Reserved_142 {
                    bits 32;
                    access rw;
                    hard_reset 'h0;
                }
            }
            register ccf_Probe_T_sip2_main_Probe_Reserved_143 @0x280 {
                bytes 4;
                field ccf_Probe_T_sip2_main_Probe_Reserved_143 {
                    bits 32;
                    access rw;
                    hard_reset 'h0;
                }
            }
            register ccf_Probe_T_sip2_main_Probe_Reserved_144 @0x284 {
                bytes 4;
                field ccf_Probe_T_sip2_main_Probe_Reserved_144 {
                    bits 32;
                    access rw;
                    hard_reset 'h0;
                }
            }
            register ccf_Probe_T_sip2_main_Probe_Reserved_145 @0x288 {
                bytes 4;
                field ccf_Probe_T_sip2_main_Probe_Reserved_145 {
                    bits 32;
                    access rw;
                    hard_reset 'h0;
                }
            }
            register ccf_Probe_T_sip2_main_Probe_Reserved_146 @0x28C {
                bytes 4;
                field ccf_Probe_T_sip2_main_Probe_Reserved_146 {
                    bits 32;
                    access rw;
                    hard_reset 'h0;
                }
            }
            register ccf_Probe_T_sip2_main_Probe_Reserved_147 @0x290 {
                bytes 4;
                field ccf_Probe_T_sip2_main_Probe_Reserved_147 {
                    bits 32;
                    access rw;
                    hard_reset 'h0;
                }
            }
            register ccf_Probe_T_sip2_main_Probe_Reserved_148 @0x294 {
                bytes 4;
                field ccf_Probe_T_sip2_main_Probe_Reserved_148 {
                    bits 32;
                    access rw;
                    hard_reset 'h0;
                }
            }
            register ccf_Probe_T_sip2_main_Probe_Reserved_149 @0x298 {
                bytes 4;
                field ccf_Probe_T_sip2_main_Probe_Reserved_149 {
                    bits 32;
                    access rw;
                    hard_reset 'h0;
                }
            }
            register ccf_Probe_T_sip2_main_Probe_Reserved_150 @0x29C {
                bytes 4;
                field ccf_Probe_T_sip2_main_Probe_Reserved_150 {
                    bits 32;
                    access rw;
                    hard_reset 'h0;
                }
            }
            register ccf_Probe_T_sip2_main_Probe_Reserved_151 @0x2A0 {
                bytes 4;
                field ccf_Probe_T_sip2_main_Probe_Reserved_151 {
                    bits 32;
                    access rw;
                    hard_reset 'h0;
                }
            }
            register ccf_Probe_T_sip2_main_Probe_Reserved_152 @0x2A4 {
                bytes 4;
                field ccf_Probe_T_sip2_main_Probe_Reserved_152 {
                    bits 32;
                    access rw;
                    hard_reset 'h0;
                }
            }
            register ccf_Probe_T_sip2_main_Probe_Reserved_153 @0x2A8 {
                bytes 4;
                field ccf_Probe_T_sip2_main_Probe_Reserved_153 {
                    bits 32;
                    access rw;
                    hard_reset 'h0;
                }
            }
            register ccf_Probe_T_sip2_main_Probe_Reserved_154 @0x2AC {
                bytes 4;
                field ccf_Probe_T_sip2_main_Probe_Reserved_154 {
                    bits 32;
                    access rw;
                    hard_reset 'h0;
                }
            }
            register ccf_Probe_T_sip2_main_Probe_Reserved_155 @0x2B0 {
                bytes 4;
                field ccf_Probe_T_sip2_main_Probe_Reserved_155 {
                    bits 32;
                    access rw;
                    hard_reset 'h0;
                }
            }
            register ccf_Probe_T_sip2_main_Probe_Reserved_156 @0x2B4 {
                bytes 4;
                field ccf_Probe_T_sip2_main_Probe_Reserved_156 {
                    bits 32;
                    access rw;
                    hard_reset 'h0;
                }
            }
            register ccf_Probe_T_sip2_main_Probe_Reserved_157 @0x2B8 {
                bytes 4;
                field ccf_Probe_T_sip2_main_Probe_Reserved_157 {
                    bits 32;
                    access rw;
                    hard_reset 'h0;
                }
            }
            register ccf_Probe_T_sip2_main_Probe_Reserved_158 @0x2BC {
                bytes 4;
                field ccf_Probe_T_sip2_main_Probe_Reserved_158 {
                    bits 32;
                    access rw;
                    hard_reset 'h0;
                }
            }
            register ccf_Probe_T_sip2_main_Probe_Reserved_159 @0x2C0 {
                bytes 4;
                field ccf_Probe_T_sip2_main_Probe_Reserved_159 {
                    bits 32;
                    access rw;
                    hard_reset 'h0;
                }
            }
            register ccf_Probe_T_sip2_main_Probe_Reserved_160 @0x2C4 {
                bytes 4;
                field ccf_Probe_T_sip2_main_Probe_Reserved_160 {
                    bits 32;
                    access rw;
                    hard_reset 'h0;
                }
            }
            register ccf_Probe_T_sip2_main_Probe_Reserved_161 @0x2C8 {
                bytes 4;
                field ccf_Probe_T_sip2_main_Probe_Reserved_161 {
                    bits 32;
                    access rw;
                    hard_reset 'h0;
                }
            }
            register ccf_Probe_T_sip2_main_Probe_Reserved_162 @0x2CC {
                bytes 4;
                field ccf_Probe_T_sip2_main_Probe_Reserved_162 {
                    bits 32;
                    access rw;
                    hard_reset 'h0;
                }
            }
            register ccf_Probe_T_sip2_main_Probe_Reserved_163 @0x2D0 {
                bytes 4;
                field ccf_Probe_T_sip2_main_Probe_Reserved_163 {
                    bits 32;
                    access rw;
                    hard_reset 'h0;
                }
            }
            register ccf_Probe_T_sip2_main_Probe_Reserved_164 @0x2D4 {
                bytes 4;
                field ccf_Probe_T_sip2_main_Probe_Reserved_164 {
                    bits 32;
                    access rw;
                    hard_reset 'h0;
                }
            }
            register ccf_Probe_T_sip2_main_Probe_Reserved_165 @0x2D8 {
                bytes 4;
                field ccf_Probe_T_sip2_main_Probe_Reserved_165 {
                    bits 32;
                    access rw;
                    hard_reset 'h0;
                }
            }
            register ccf_Probe_T_sip2_main_Probe_Reserved_166 @0x2DC {
                bytes 4;
                field ccf_Probe_T_sip2_main_Probe_Reserved_166 {
                    bits 32;
                    access rw;
                    hard_reset 'h0;
                }
            }
            register ccf_Probe_T_sip2_main_Probe_Reserved_167 @0x2E0 {
                bytes 4;
                field ccf_Probe_T_sip2_main_Probe_Reserved_167 {
                    bits 32;
                    access rw;
                    hard_reset 'h0;
                }
            }
            register ccf_Probe_T_sip2_main_Probe_Reserved_168 @0x2E4 {
                bytes 4;
                field ccf_Probe_T_sip2_main_Probe_Reserved_168 {
                    bits 32;
                    access rw;
                    hard_reset 'h0;
                }
            }
            register ccf_Probe_T_sip2_main_Probe_Reserved_169 @0x2E8 {
                bytes 4;
                field ccf_Probe_T_sip2_main_Probe_Reserved_169 {
                    bits 32;
                    access rw;
                    hard_reset 'h0;
                }
            }
            register ccf_Probe_T_sip2_main_Probe_Reserved_170 @0x2EC {
                bytes 4;
                field ccf_Probe_T_sip2_main_Probe_Reserved_170 {
                    bits 32;
                    access rw;
                    hard_reset 'h0;
                }
            }
            register ccf_Probe_T_sip2_main_Probe_Reserved_171 @0x2F0 {
                bytes 4;
                field ccf_Probe_T_sip2_main_Probe_Reserved_171 {
                    bits 32;
                    access rw;
                    hard_reset 'h0;
                }
            }
            register ccf_Probe_T_sip2_main_Probe_Reserved_172 @0x2F4 {
                bytes 4;
                field ccf_Probe_T_sip2_main_Probe_Reserved_172 {
                    bits 32;
                    access rw;
                    hard_reset 'h0;
                }
            }
            register ccf_Probe_T_sip2_main_Probe_Reserved_173 @0x2F8 {
                bytes 4;
                field ccf_Probe_T_sip2_main_Probe_Reserved_173 {
                    bits 32;
                    access rw;
                    hard_reset 'h0;
                }
            }
            register ccf_Probe_T_sip2_main_Probe_Reserved_174 @0x2FC {
                bytes 4;
                field ccf_Probe_T_sip2_main_Probe_Reserved_174 {
                    bits 32;
                    access rw;
                    hard_reset 'h0;
                }
            }
            register ccf_Probe_T_sip2_main_Probe_Reserved_175 @0x300 {
                bytes 4;
                field ccf_Probe_T_sip2_main_Probe_Reserved_175 {
                    bits 32;
                    access rw;
                    hard_reset 'h0;
                }
            }
            register ccf_Probe_T_sip2_main_Probe_Reserved_176 @0x304 {
                bytes 4;
                field ccf_Probe_T_sip2_main_Probe_Reserved_176 {
                    bits 32;
                    access rw;
                    hard_reset 'h0;
                }
            }
            register ccf_Probe_T_sip2_main_Probe_Reserved_177 @0x308 {
                bytes 4;
                field ccf_Probe_T_sip2_main_Probe_Reserved_177 {
                    bits 32;
                    access rw;
                    hard_reset 'h0;
                }
            }
            register ccf_Probe_T_sip2_main_Probe_Reserved_178 @0x30C {
                bytes 4;
                field ccf_Probe_T_sip2_main_Probe_Reserved_178 {
                    bits 32;
                    access rw;
                    hard_reset 'h0;
                }
            }
            register ccf_Probe_T_sip2_main_Probe_Reserved_179 @0x310 {
                bytes 4;
                field ccf_Probe_T_sip2_main_Probe_Reserved_179 {
                    bits 32;
                    access rw;
                    hard_reset 'h0;
                }
            }
            register ccf_Probe_T_sip2_main_Probe_Reserved_180 @0x314 {
                bytes 4;
                field ccf_Probe_T_sip2_main_Probe_Reserved_180 {
                    bits 32;
                    access rw;
                    hard_reset 'h0;
                }
            }
            register ccf_Probe_T_sip2_main_Probe_Reserved_181 @0x318 {
                bytes 4;
                field ccf_Probe_T_sip2_main_Probe_Reserved_181 {
                    bits 32;
                    access rw;
                    hard_reset 'h0;
                }
            }
            register ccf_Probe_T_sip2_main_Probe_Reserved_182 @0x31C {
                bytes 4;
                field ccf_Probe_T_sip2_main_Probe_Reserved_182 {
                    bits 32;
                    access rw;
                    hard_reset 'h0;
                }
            }
            register ccf_Probe_T_sip2_main_Probe_Reserved_183 @0x320 {
                bytes 4;
                field ccf_Probe_T_sip2_main_Probe_Reserved_183 {
                    bits 32;
                    access rw;
                    hard_reset 'h0;
                }
            }
            register ccf_Probe_T_sip2_main_Probe_Reserved_184 @0x324 {
                bytes 4;
                field ccf_Probe_T_sip2_main_Probe_Reserved_184 {
                    bits 32;
                    access rw;
                    hard_reset 'h0;
                }
            }
            register ccf_Probe_T_sip2_main_Probe_Reserved_185 @0x328 {
                bytes 4;
                field ccf_Probe_T_sip2_main_Probe_Reserved_185 {
                    bits 32;
                    access rw;
                    hard_reset 'h0;
                }
            }
            register ccf_Probe_T_sip2_main_Probe_Reserved_186 @0x32C {
                bytes 4;
                field ccf_Probe_T_sip2_main_Probe_Reserved_186 {
                    bits 32;
                    access rw;
                    hard_reset 'h0;
                }
            }
            register ccf_Probe_T_sip2_main_Probe_Reserved_187 @0x330 {
                bytes 4;
                field ccf_Probe_T_sip2_main_Probe_Reserved_187 {
                    bits 32;
                    access rw;
                    hard_reset 'h0;
                }
            }
            register ccf_Probe_T_sip2_main_Probe_Reserved_188 @0x334 {
                bytes 4;
                field ccf_Probe_T_sip2_main_Probe_Reserved_188 {
                    bits 32;
                    access rw;
                    hard_reset 'h0;
                }
            }
            register ccf_Probe_T_sip2_main_Probe_Reserved_189 @0x338 {
                bytes 4;
                field ccf_Probe_T_sip2_main_Probe_Reserved_189 {
                    bits 32;
                    access rw;
                    hard_reset 'h0;
                }
            }
            register ccf_Probe_T_sip2_main_Probe_Reserved_190 @0x33C {
                bytes 4;
                field ccf_Probe_T_sip2_main_Probe_Reserved_190 {
                    bits 32;
                    access rw;
                    hard_reset 'h0;
                }
            }
            register ccf_Probe_T_sip2_main_Probe_Reserved_191 @0x340 {
                bytes 4;
                field ccf_Probe_T_sip2_main_Probe_Reserved_191 {
                    bits 32;
                    access rw;
                    hard_reset 'h0;
                }
            }
            register ccf_Probe_T_sip2_main_Probe_Reserved_192 @0x344 {
                bytes 4;
                field ccf_Probe_T_sip2_main_Probe_Reserved_192 {
                    bits 32;
                    access rw;
                    hard_reset 'h0;
                }
            }
            register ccf_Probe_T_sip2_main_Probe_Reserved_193 @0x348 {
                bytes 4;
                field ccf_Probe_T_sip2_main_Probe_Reserved_193 {
                    bits 32;
                    access rw;
                    hard_reset 'h0;
                }
            }
            register ccf_Probe_T_sip2_main_Probe_Reserved_194 @0x34C {
                bytes 4;
                field ccf_Probe_T_sip2_main_Probe_Reserved_194 {
                    bits 32;
                    access rw;
                    hard_reset 'h0;
                }
            }
            register ccf_Probe_T_sip2_main_Probe_Reserved_195 @0x350 {
                bytes 4;
                field ccf_Probe_T_sip2_main_Probe_Reserved_195 {
                    bits 32;
                    access rw;
                    hard_reset 'h0;
                }
            }
            register ccf_Probe_T_sip2_main_Probe_Reserved_196 @0x354 {
                bytes 4;
                field ccf_Probe_T_sip2_main_Probe_Reserved_196 {
                    bits 32;
                    access rw;
                    hard_reset 'h0;
                }
            }
            register ccf_Probe_T_sip2_main_Probe_Reserved_197 @0x358 {
                bytes 4;
                field ccf_Probe_T_sip2_main_Probe_Reserved_197 {
                    bits 32;
                    access rw;
                    hard_reset 'h0;
                }
            }
            register ccf_Probe_T_sip2_main_Probe_Reserved_198 @0x35C {
                bytes 4;
                field ccf_Probe_T_sip2_main_Probe_Reserved_198 {
                    bits 32;
                    access rw;
                    hard_reset 'h0;
                }
            }
            register ccf_Probe_T_sip2_main_Probe_Reserved_199 @0x360 {
                bytes 4;
                field ccf_Probe_T_sip2_main_Probe_Reserved_199 {
                    bits 32;
                    access rw;
                    hard_reset 'h0;
                }
            }
            register ccf_Probe_T_sip2_main_Probe_Reserved_200 @0x364 {
                bytes 4;
                field ccf_Probe_T_sip2_main_Probe_Reserved_200 {
                    bits 32;
                    access rw;
                    hard_reset 'h0;
                }
            }
            register ccf_Probe_T_sip2_main_Probe_Reserved_201 @0x368 {
                bytes 4;
                field ccf_Probe_T_sip2_main_Probe_Reserved_201 {
                    bits 32;
                    access rw;
                    hard_reset 'h0;
                }
            }
            register ccf_Probe_T_sip2_main_Probe_Reserved_202 @0x36C {
                bytes 4;
                field ccf_Probe_T_sip2_main_Probe_Reserved_202 {
                    bits 32;
                    access rw;
                    hard_reset 'h0;
                }
            }
            register ccf_Probe_T_sip2_main_Probe_Reserved_203 @0x370 {
                bytes 4;
                field ccf_Probe_T_sip2_main_Probe_Reserved_203 {
                    bits 32;
                    access rw;
                    hard_reset 'h0;
                }
            }
            register ccf_Probe_T_sip2_main_Probe_Reserved_204 @0x374 {
                bytes 4;
                field ccf_Probe_T_sip2_main_Probe_Reserved_204 {
                    bits 32;
                    access rw;
                    hard_reset 'h0;
                }
            }
            register ccf_Probe_T_sip2_main_Probe_Reserved_205 @0x378 {
                bytes 4;
                field ccf_Probe_T_sip2_main_Probe_Reserved_205 {
                    bits 32;
                    access rw;
                    hard_reset 'h0;
                }
            }
            register ccf_Probe_T_sip2_main_Probe_Reserved_206 @0x37C {
                bytes 4;
                field ccf_Probe_T_sip2_main_Probe_Reserved_206 {
                    bits 32;
                    access rw;
                    hard_reset 'h0;
                }
            }
            register ccf_Probe_T_sip2_main_Probe_Reserved_207 @0x380 {
                bytes 4;
                field ccf_Probe_T_sip2_main_Probe_Reserved_207 {
                    bits 32;
                    access rw;
                    hard_reset 'h0;
                }
            }
            register ccf_Probe_T_sip2_main_Probe_Reserved_208 @0x384 {
                bytes 4;
                field ccf_Probe_T_sip2_main_Probe_Reserved_208 {
                    bits 32;
                    access rw;
                    hard_reset 'h0;
                }
            }
            register ccf_Probe_T_sip2_main_Probe_Reserved_209 @0x388 {
                bytes 4;
                field ccf_Probe_T_sip2_main_Probe_Reserved_209 {
                    bits 32;
                    access rw;
                    hard_reset 'h0;
                }
            }
            register ccf_Probe_T_sip2_main_Probe_Reserved_210 @0x38C {
                bytes 4;
                field ccf_Probe_T_sip2_main_Probe_Reserved_210 {
                    bits 32;
                    access rw;
                    hard_reset 'h0;
                }
            }
            register ccf_Probe_T_sip2_main_Probe_Reserved_211 @0x390 {
                bytes 4;
                field ccf_Probe_T_sip2_main_Probe_Reserved_211 {
                    bits 32;
                    access rw;
                    hard_reset 'h0;
                }
            }
            register ccf_Probe_T_sip2_main_Probe_Reserved_212 @0x394 {
                bytes 4;
                field ccf_Probe_T_sip2_main_Probe_Reserved_212 {
                    bits 32;
                    access rw;
                    hard_reset 'h0;
                }
            }
            register ccf_Probe_T_sip2_main_Probe_Reserved_213 @0x398 {
                bytes 4;
                field ccf_Probe_T_sip2_main_Probe_Reserved_213 {
                    bits 32;
                    access rw;
                    hard_reset 'h0;
                }
            }
            register ccf_Probe_T_sip2_main_Probe_Reserved_214 @0x39C {
                bytes 4;
                field ccf_Probe_T_sip2_main_Probe_Reserved_214 {
                    bits 32;
                    access rw;
                    hard_reset 'h0;
                }
            }
            register ccf_Probe_T_sip2_main_Probe_Reserved_215 @0x3A0 {
                bytes 4;
                field ccf_Probe_T_sip2_main_Probe_Reserved_215 {
                    bits 32;
                    access rw;
                    hard_reset 'h0;
                }
            }
            register ccf_Probe_T_sip2_main_Probe_Reserved_216 @0x3A4 {
                bytes 4;
                field ccf_Probe_T_sip2_main_Probe_Reserved_216 {
                    bits 32;
                    access rw;
                    hard_reset 'h0;
                }
            }
            register ccf_Probe_T_sip2_main_Probe_Reserved_217 @0x3A8 {
                bytes 4;
                field ccf_Probe_T_sip2_main_Probe_Reserved_217 {
                    bits 32;
                    access rw;
                    hard_reset 'h0;
                }
            }
            register ccf_Probe_T_sip2_main_Probe_Reserved_218 @0x3AC {
                bytes 4;
                field ccf_Probe_T_sip2_main_Probe_Reserved_218 {
                    bits 32;
                    access rw;
                    hard_reset 'h0;
                }
            }
            register ccf_Probe_T_sip2_main_Probe_Reserved_219 @0x3B0 {
                bytes 4;
                field ccf_Probe_T_sip2_main_Probe_Reserved_219 {
                    bits 32;
                    access rw;
                    hard_reset 'h0;
                }
            }
            register ccf_Probe_T_sip2_main_Probe_Reserved_220 @0x3B4 {
                bytes 4;
                field ccf_Probe_T_sip2_main_Probe_Reserved_220 {
                    bits 32;
                    access rw;
                    hard_reset 'h0;
                }
            }
            register ccf_Probe_T_sip2_main_Probe_Reserved_221 @0x3B8 {
                bytes 4;
                field ccf_Probe_T_sip2_main_Probe_Reserved_221 {
                    bits 32;
                    access rw;
                    hard_reset 'h0;
                }
            }
            register ccf_Probe_T_sip2_main_Probe_Reserved_222 @0x3BC {
                bytes 4;
                field ccf_Probe_T_sip2_main_Probe_Reserved_222 {
                    bits 32;
                    access rw;
                    hard_reset 'h0;
                }
            }
            register ccf_Probe_T_sip2_main_Probe_Reserved_223 @0x3C0 {
                bytes 4;
                field ccf_Probe_T_sip2_main_Probe_Reserved_223 {
                    bits 32;
                    access rw;
                    hard_reset 'h0;
                }
            }
            register ccf_Probe_T_sip2_main_Probe_Reserved_224 @0x3C4 {
                bytes 4;
                field ccf_Probe_T_sip2_main_Probe_Reserved_224 {
                    bits 32;
                    access rw;
                    hard_reset 'h0;
                }
            }
            register ccf_Probe_T_sip2_main_Probe_Reserved_225 @0x3C8 {
                bytes 4;
                field ccf_Probe_T_sip2_main_Probe_Reserved_225 {
                    bits 32;
                    access rw;
                    hard_reset 'h0;
                }
            }
            register ccf_Probe_T_sip2_main_Probe_Reserved_226 @0x3CC {
                bytes 4;
                field ccf_Probe_T_sip2_main_Probe_Reserved_226 {
                    bits 32;
                    access rw;
                    hard_reset 'h0;
                }
            }
            register ccf_Probe_T_sip2_main_Probe_Reserved_227 @0x3D0 {
                bytes 4;
                field ccf_Probe_T_sip2_main_Probe_Reserved_227 {
                    bits 32;
                    access rw;
                    hard_reset 'h0;
                }
            }
            register ccf_Probe_T_sip2_main_Probe_Reserved_228 @0x3D4 {
                bytes 4;
                field ccf_Probe_T_sip2_main_Probe_Reserved_228 {
                    bits 32;
                    access rw;
                    hard_reset 'h0;
                }
            }
            register ccf_Probe_T_sip2_main_Probe_Reserved_229 @0x3D8 {
                bytes 4;
                field ccf_Probe_T_sip2_main_Probe_Reserved_229 {
                    bits 32;
                    access rw;
                    hard_reset 'h0;
                }
            }
            register ccf_Probe_T_sip2_main_Probe_Reserved_230 @0x3DC {
                bytes 4;
                field ccf_Probe_T_sip2_main_Probe_Reserved_230 {
                    bits 32;
                    access rw;
                    hard_reset 'h0;
                }
            }
            register ccf_Probe_T_sip2_main_Probe_Reserved_231 @0x3E0 {
                bytes 4;
                field ccf_Probe_T_sip2_main_Probe_Reserved_231 {
                    bits 32;
                    access rw;
                    hard_reset 'h0;
                }
            }
            register ccf_Probe_T_sip2_main_Probe_Reserved_232 @0x3E4 {
                bytes 4;
                field ccf_Probe_T_sip2_main_Probe_Reserved_232 {
                    bits 32;
                    access rw;
                    hard_reset 'h0;
                }
            }
            register ccf_Probe_T_sip2_main_Probe_Reserved_233 @0x3E8 {
                bytes 4;
                field ccf_Probe_T_sip2_main_Probe_Reserved_233 {
                    bits 32;
                    access rw;
                    hard_reset 'h0;
                }
            }
            register ccf_Probe_T_sip2_main_Probe_Reserved_234 @0x3EC {
                bytes 4;
                field ccf_Probe_T_sip2_main_Probe_Reserved_234 {
                    bits 32;
                    access rw;
                    hard_reset 'h0;
                }
            }
            register ccf_Probe_T_sip2_main_Probe_Reserved_235 @0x3F0 {
                bytes 4;
                field ccf_Probe_T_sip2_main_Probe_Reserved_235 {
                    bits 32;
                    access rw;
                    hard_reset 'h0;
                }
            }
            register ccf_Probe_T_sip2_main_Probe_Reserved_236 @0x3F4 {
                bytes 4;
                field ccf_Probe_T_sip2_main_Probe_Reserved_236 {
                    bits 32;
                    access rw;
                    hard_reset 'h0;
                }
            }
            register ccf_Probe_T_sip2_main_Probe_Reserved_237 @0x3F8 {
                bytes 4;
                field ccf_Probe_T_sip2_main_Probe_Reserved_237 {
                    bits 32;
                    access rw;
                    hard_reset 'h0;
                }
            }
            register ccf_Probe_T_sip2_main_Probe_Reserved_238 @0x3FC {
                bytes 4;
                field ccf_Probe_T_sip2_main_Probe_Reserved_238 {
                    bits 32;
                    access rw;
                    hard_reset 'h0;
                }
            }
        }
        block ecf_ccf_axi_ccf_Probe_T_sip3_main_Probe @0xD9C00 {
            bytes 4;
            register ccf_Probe_T_sip3_main_Probe_Id_CoreId @0x0 {
                bytes 4;
                field CORETYPEID @'h0 {
                    bits 8;
                    access ro;
                    hard_reset 'h6;
                    doc {
                        Field identifying the type of IP.
                    }
                }
                field CORECHECKSUM @'h8 {
                    bits 24;
                    access ro;
                    hard_reset 'h281ce3;
                    doc {
                        Field containing a checksum of the parameters of the IP.
                    }
                }
            }
            register ccf_Probe_T_sip3_main_Probe_Id_RevisionId @0x4 {
                bytes 4;
                field USERID @'h0 {
                    bits 8;
                    access ro;
                    hard_reset 'h0;
                    doc {
                        Field containing a user defined value, not used anywhere inside the IP itself.
                    }
                }
                field FLEXNOCID @'h8 {
                    bits 24;
                    access ro;
                    hard_reset 'h84f8c6;
                    doc {
                        Field containing the build revision of the software used to generate the IP HDL code.
                    }
                }
            }
            register ccf_Probe_T_sip3_main_Probe_MainCtl @0x8 {
                bytes 4;
                field ERREN @'h0 {
                    access rw;
                    hard_reset 'h0;
                    doc {
                        Register field ErrEn enables the probe to send on the ObsTx output any packet with Error status, independently of filtering mechanisms, thus constituting a simple supplementary global filter.
                    }
                }
                field TRACEEN @'h1 {
                    access ro;
                    hard_reset 'h0;
                    doc {
                        Register field TraceEn enables the probe to send filtered packets (Trace) on the ObsTx observation output.
                    }
                }
                field PAYLOADEN @'h2 {
                    access rw;
                    hard_reset 'h0;
                    doc {
                        Register field PayloadEn, when set to 1, enables traces to contain headers and payload. When set ot 0, only headers are reported.
                    }
                }
                field STATEN @'h3 {
                    access rw;
                    hard_reset 'h0;
                    doc {
                        When set to 1, register field StatEn enables statistics profiling. The probe sendS statistics results to the output for signal ObsTx. All statistics counters are cleared when the StatEn bit goes from 0 to 1. When set to 0, counters are disabled.
                    }
                }
                field ALARMEN @'h4 {
                    access rw;
                    hard_reset 'h0;
                    doc {
                        When set, register field AlarmEn enables the probe to collect alarm-related information. When the register field bit is null, both TraceAlarm and StatAlarm outputs are driven to 0.
                    }
                }
                field STATCONDDUMP @'h5 {
                    access rw;
                    hard_reset 'h0;
                    doc {
                        When set, register field StatCondDump enables the dump of a statistics frame to the range of counter values set for registers StatAlarmMin, StatAlarmMax, and AlarmMode. This field also renders register StatAlarmStatus inoperative. When parameter statisticsCounterAlarm is set to False, the StatCondDump register bit is reserved.
                    }
                }
                field INTRUSIVEMODE @'h6 {
                    access ro;
                    hard_reset 'h0;
                    doc {
                        When set to 1, register field IntrusiveMode enables trace operation in Intrusive flow-control mode. When set to 0, the register  enables trace operation in Overflow flow-control mode
                    }
                }
                field FILTBYTEALWAYSCHAINABLEEN @'h7 {
                    access rw;
                    hard_reset 'h0;
                    doc {
                        When set to 0, filters are mapped to all statistic counters when counting bytes or enabled bytes. Therefore, only filter events mapped to even counters can be counted using a pair of chained counters.When set to 1, filters are mapped only to even statistic counters when counting bytes or enabled bytes. Thus events from any filter can be counted using a pair of chained counters.
                    }
                }
                doc {
                    Register MainCtl contains probe global control bits. The register has seven bit fields:Register MainCtl contains probe global control bits. The register has seven bit fields:
                }
            }
            register ccf_Probe_T_sip3_main_Probe_CfgCtl @0xC {
                bytes 4;
                field GLOBALEN @'h0 {
                    access rw;
                    hard_reset 'h0;
                }
                field ACTIVE @'h1 {
                    access ro;
                    hard_reset 'h0;
                }
            }
            register ccf_Probe_T_sip3_main_Probe_Reserved_00 @0x10 {
                bytes 4;
                field ccf_Probe_T_sip3_main_Probe_Reserved_00 {
                    bits 32;
                    access rw;
                    hard_reset 'h0;
                }
            }
            register ccf_Probe_T_sip3_main_Probe_Reserved_01 @0x14 {
                bytes 4;
                field ccf_Probe_T_sip3_main_Probe_Reserved_01 {
                    bits 32;
                    access rw;
                    hard_reset 'h0;
                }
            }
            register ccf_Probe_T_sip3_main_Probe_Reserved_02 @0x18 {
                bytes 4;
                field ccf_Probe_T_sip3_main_Probe_Reserved_02 {
                    bits 32;
                    access rw;
                    hard_reset 'h0;
                }
            }
            register ccf_Probe_T_sip3_main_Probe_Reserved_03 @0x1C {
                bytes 4;
                field ccf_Probe_T_sip3_main_Probe_Reserved_03 {
                    bits 32;
                    access rw;
                    hard_reset 'h0;
                }
            }
            register ccf_Probe_T_sip3_main_Probe_Reserved_04 @0x20 {
                bytes 4;
                field ccf_Probe_T_sip3_main_Probe_Reserved_04 {
                    bits 32;
                    access rw;
                    hard_reset 'h0;
                }
            }
            register ccf_Probe_T_sip3_main_Probe_StatPeriod @0x24 {
                bytes 4;
                field STATPERIOD @'h0 {
                    bits 5;
                    access rw;
                    hard_reset 'h0;
                    doc {
                        Register StatPeriod is a 5-bit register that sets a period, within a range of 2 cycles to 2 gigacycles, during which statistics are collected before being dumped automatically. Setting the register implicitly enables automatic mode operation for statistics collection. The period is calculated with the formula: N_Cycle = 2**StatPeriodWhen register StatPeriod is set to its default value 0, automatic dump mode is disabled, and register StatGo is activated for manual mode operation. Note: When parameter statisticsCollection is set to False, StatPeriod is reserved.
                    }
                }
            }
            register ccf_Probe_T_sip3_main_Probe_StatGo @0x28 {
                bytes 4;
                field STATGO @'h0 {
                    access w1c;
                    hard_reset 'h0;
                    doc {
                        Writing a 1 to the 1-bit pulse register StatGo generates a statistics dump.The register is active when statistics collection operates in manual mode, that is, when register StatPeriod is set to 0.NOTE  The written value is not stored in StatGo. A read always returns 0.
                    }
                }
            }
            register ccf_Probe_T_sip3_main_Probe_StatAlarmMin @0x2C {
                bytes 4;
                field STATALARMMIN @'h0 {
                    bits 22;
                    access rw;
                    hard_reset 'h0;
                    doc {
                        Register StatAlarmMin contains the minimum count value used in statistics alarm comparisons. The number of bits is equal to twice the value set forparameter wStatisticsCounter. When parameter statisticsCounterAlarm is set to False, StatAlarmMin is reserved.
                    }
                }
            }
            register ccf_Probe_T_sip3_main_Probe_StatAlarmMax @0x30 {
                bytes 4;
                field STATALARMMAX @'h0 {
                    bits 22;
                    access rw;
                    hard_reset 'h0;
                    doc {
                        Register StatAlarmMax contains the maximum count value used in statistics alarm comparisons.The number of bits is equal to twice the value set for parameter wStatisticsCounter. When parameter statisticsCounterAlarm is set to False, StatAlarmMax is reserved.
                    }
                }
            }
            register ccf_Probe_T_sip3_main_Probe_StatAlarmStatus @0x34 {
                bytes 4;
                field STATALARMSTATUS @'h0 {
                    access ro;
                    hard_reset 'h0;
                    doc {
                        Register StatAlarmStatus is a read-only 1-bit register indicating that at least one statistics counter has exceeded the programmed values for registers StatAlarmMin or StatAlarmMax. Output signal StatAlarm is equal to the values stored in register MainCtl fields StatAlarmStatus and AlarmEn. When parameter statisticsCounterAlarm is set to False, StatAlarmStatus is reserved.
                    }
                }
            }
            register ccf_Probe_T_sip3_main_Probe_StatAlarmClr @0x38 {
                bytes 4;
                field STATALARMCLR @'h0 {
                    access w1c;
                    hard_reset 'h0;
                    doc {
                        Register StatAlarmClr is a 1-bit register. Writing a 1 to this register clears the StatAlarmStatus register bit.When parameter statisticsCounterAlarm is set to False, StatAlarmClr is reserved.NOTE  The written value is not stored in StatAlarmClr. A read always returns 0.
                    }
                }
            }
            register ccf_Probe_T_sip3_main_Probe_StatAlarmEn @0x3C {
                bytes 4;
                field STATALARMEN @'h0 {
                    access rw;
                    hard_reset 'h1;
                    doc {
                        Register StatAlarmEn is a 1-bit register. When set to 0 it masks StatAlarm and CtiTrigOut(1) signal interrupts.
                    }
                }
            }
            register ccf_Probe_T_sip3_main_Probe_Reserved_05 @0x40 {
                bytes 4;
                field ccf_Probe_T_sip3_main_Probe_Reserved_05 {
                    bits 32;
                    access rw;
                    hard_reset 'h0;
                }
            }
            register ccf_Probe_T_sip3_main_Probe_Reserved_06 @0x44 {
                bytes 4;
                field ccf_Probe_T_sip3_main_Probe_Reserved_06 {
                    bits 32;
                    access rw;
                    hard_reset 'h0;
                }
            }
            register ccf_Probe_T_sip3_main_Probe_Reserved_07 @0x48 {
                bytes 4;
                field ccf_Probe_T_sip3_main_Probe_Reserved_07 {
                    bits 32;
                    access rw;
                    hard_reset 'h0;
                }
            }
            register ccf_Probe_T_sip3_main_Probe_Reserved_08 @0x4C {
                bytes 4;
                field ccf_Probe_T_sip3_main_Probe_Reserved_08 {
                    bits 32;
                    access rw;
                    hard_reset 'h0;
                }
            }
            register ccf_Probe_T_sip3_main_Probe_Reserved_09 @0x50 {
                bytes 4;
                field ccf_Probe_T_sip3_main_Probe_Reserved_09 {
                    bits 32;
                    access rw;
                    hard_reset 'h0;
                }
            }
            register ccf_Probe_T_sip3_main_Probe_Reserved_10 @0x54 {
                bytes 4;
                field ccf_Probe_T_sip3_main_Probe_Reserved_10 {
                    bits 32;
                    access rw;
                    hard_reset 'h0;
                }
            }
            register ccf_Probe_T_sip3_main_Probe_Reserved_11 @0x58 {
                bytes 4;
                field ccf_Probe_T_sip3_main_Probe_Reserved_11 {
                    bits 32;
                    access rw;
                    hard_reset 'h0;
                }
            }
            register ccf_Probe_T_sip3_main_Probe_Reserved_12 @0x5C {
                bytes 4;
                field ccf_Probe_T_sip3_main_Probe_Reserved_12 {
                    bits 32;
                    access rw;
                    hard_reset 'h0;
                }
            }
            register ccf_Probe_T_sip3_main_Probe_Reserved_13 @0x60 {
                bytes 4;
                field ccf_Probe_T_sip3_main_Probe_Reserved_13 {
                    bits 32;
                    access rw;
                    hard_reset 'h0;
                }
            }
            register ccf_Probe_T_sip3_main_Probe_Reserved_14 @0x64 {
                bytes 4;
                field ccf_Probe_T_sip3_main_Probe_Reserved_14 {
                    bits 32;
                    access rw;
                    hard_reset 'h0;
                }
            }
            register ccf_Probe_T_sip3_main_Probe_Reserved_15 @0x68 {
                bytes 4;
                field ccf_Probe_T_sip3_main_Probe_Reserved_15 {
                    bits 32;
                    access rw;
                    hard_reset 'h0;
                }
            }
            register ccf_Probe_T_sip3_main_Probe_Reserved_16 @0x6C {
                bytes 4;
                field ccf_Probe_T_sip3_main_Probe_Reserved_16 {
                    bits 32;
                    access rw;
                    hard_reset 'h0;
                }
            }
            register ccf_Probe_T_sip3_main_Probe_Reserved_17 @0x70 {
                bytes 4;
                field ccf_Probe_T_sip3_main_Probe_Reserved_17 {
                    bits 32;
                    access rw;
                    hard_reset 'h0;
                }
            }
            register ccf_Probe_T_sip3_main_Probe_Reserved_18 @0x74 {
                bytes 4;
                field ccf_Probe_T_sip3_main_Probe_Reserved_18 {
                    bits 32;
                    access rw;
                    hard_reset 'h0;
                }
            }
            register ccf_Probe_T_sip3_main_Probe_Reserved_19 @0x78 {
                bytes 4;
                field ccf_Probe_T_sip3_main_Probe_Reserved_19 {
                    bits 32;
                    access rw;
                    hard_reset 'h0;
                }
            }
            register ccf_Probe_T_sip3_main_Probe_Reserved_20 @0x7C {
                bytes 4;
                field ccf_Probe_T_sip3_main_Probe_Reserved_20 {
                    bits 32;
                    access rw;
                    hard_reset 'h0;
                }
            }
            register ccf_Probe_T_sip3_main_Probe_Reserved_21 @0x80 {
                bytes 4;
                field ccf_Probe_T_sip3_main_Probe_Reserved_21 {
                    bits 32;
                    access rw;
                    hard_reset 'h0;
                }
            }
            register ccf_Probe_T_sip3_main_Probe_Reserved_22 @0x84 {
                bytes 4;
                field ccf_Probe_T_sip3_main_Probe_Reserved_22 {
                    bits 32;
                    access rw;
                    hard_reset 'h0;
                }
            }
            register ccf_Probe_T_sip3_main_Probe_Reserved_23 @0x88 {
                bytes 4;
                field ccf_Probe_T_sip3_main_Probe_Reserved_23 {
                    bits 32;
                    access rw;
                    hard_reset 'h0;
                }
            }
            register ccf_Probe_T_sip3_main_Probe_Reserved_24 @0x8C {
                bytes 4;
                field ccf_Probe_T_sip3_main_Probe_Reserved_24 {
                    bits 32;
                    access rw;
                    hard_reset 'h0;
                }
            }
            register ccf_Probe_T_sip3_main_Probe_Reserved_25 @0x90 {
                bytes 4;
                field ccf_Probe_T_sip3_main_Probe_Reserved_25 {
                    bits 32;
                    access rw;
                    hard_reset 'h0;
                }
            }
            register ccf_Probe_T_sip3_main_Probe_Reserved_26 @0x94 {
                bytes 4;
                field ccf_Probe_T_sip3_main_Probe_Reserved_26 {
                    bits 32;
                    access rw;
                    hard_reset 'h0;
                }
            }
            register ccf_Probe_T_sip3_main_Probe_Reserved_27 @0x98 {
                bytes 4;
                field ccf_Probe_T_sip3_main_Probe_Reserved_27 {
                    bits 32;
                    access rw;
                    hard_reset 'h0;
                }
            }
            register ccf_Probe_T_sip3_main_Probe_Reserved_28 @0x9C {
                bytes 4;
                field ccf_Probe_T_sip3_main_Probe_Reserved_28 {
                    bits 32;
                    access rw;
                    hard_reset 'h0;
                }
            }
            register ccf_Probe_T_sip3_main_Probe_Reserved_29 @0xA0 {
                bytes 4;
                field ccf_Probe_T_sip3_main_Probe_Reserved_29 {
                    bits 32;
                    access rw;
                    hard_reset 'h0;
                }
            }
            register ccf_Probe_T_sip3_main_Probe_Reserved_30 @0xA4 {
                bytes 4;
                field ccf_Probe_T_sip3_main_Probe_Reserved_30 {
                    bits 32;
                    access rw;
                    hard_reset 'h0;
                }
            }
            register ccf_Probe_T_sip3_main_Probe_Reserved_31 @0xA8 {
                bytes 4;
                field ccf_Probe_T_sip3_main_Probe_Reserved_31 {
                    bits 32;
                    access rw;
                    hard_reset 'h0;
                }
            }
            register ccf_Probe_T_sip3_main_Probe_Reserved_32 @0xAC {
                bytes 4;
                field ccf_Probe_T_sip3_main_Probe_Reserved_32 {
                    bits 32;
                    access rw;
                    hard_reset 'h0;
                }
            }
            register ccf_Probe_T_sip3_main_Probe_Reserved_33 @0xB0 {
                bytes 4;
                field ccf_Probe_T_sip3_main_Probe_Reserved_33 {
                    bits 32;
                    access rw;
                    hard_reset 'h0;
                }
            }
            register ccf_Probe_T_sip3_main_Probe_Reserved_34 @0xB4 {
                bytes 4;
                field ccf_Probe_T_sip3_main_Probe_Reserved_34 {
                    bits 32;
                    access rw;
                    hard_reset 'h0;
                }
            }
            register ccf_Probe_T_sip3_main_Probe_Reserved_35 @0xB8 {
                bytes 4;
                field ccf_Probe_T_sip3_main_Probe_Reserved_35 {
                    bits 32;
                    access rw;
                    hard_reset 'h0;
                }
            }
            register ccf_Probe_T_sip3_main_Probe_Reserved_36 @0xBC {
                bytes 4;
                field ccf_Probe_T_sip3_main_Probe_Reserved_36 {
                    bits 32;
                    access rw;
                    hard_reset 'h0;
                }
            }
            register ccf_Probe_T_sip3_main_Probe_Reserved_37 @0xC0 {
                bytes 4;
                field ccf_Probe_T_sip3_main_Probe_Reserved_37 {
                    bits 32;
                    access rw;
                    hard_reset 'h0;
                }
            }
            register ccf_Probe_T_sip3_main_Probe_Reserved_38 @0xC4 {
                bytes 4;
                field ccf_Probe_T_sip3_main_Probe_Reserved_38 {
                    bits 32;
                    access rw;
                    hard_reset 'h0;
                }
            }
            register ccf_Probe_T_sip3_main_Probe_Reserved_39 @0xC8 {
                bytes 4;
                field ccf_Probe_T_sip3_main_Probe_Reserved_39 {
                    bits 32;
                    access rw;
                    hard_reset 'h0;
                }
            }
            register ccf_Probe_T_sip3_main_Probe_Reserved_40 @0xCC {
                bytes 4;
                field ccf_Probe_T_sip3_main_Probe_Reserved_40 {
                    bits 32;
                    access rw;
                    hard_reset 'h0;
                }
            }
            register ccf_Probe_T_sip3_main_Probe_Reserved_41 @0xD0 {
                bytes 4;
                field ccf_Probe_T_sip3_main_Probe_Reserved_41 {
                    bits 32;
                    access rw;
                    hard_reset 'h0;
                }
            }
            register ccf_Probe_T_sip3_main_Probe_Reserved_42 @0xD4 {
                bytes 4;
                field ccf_Probe_T_sip3_main_Probe_Reserved_42 {
                    bits 32;
                    access rw;
                    hard_reset 'h0;
                }
            }
            register ccf_Probe_T_sip3_main_Probe_Reserved_43 @0xD8 {
                bytes 4;
                field ccf_Probe_T_sip3_main_Probe_Reserved_43 {
                    bits 32;
                    access rw;
                    hard_reset 'h0;
                }
            }
            register ccf_Probe_T_sip3_main_Probe_Reserved_44 @0xDC {
                bytes 4;
                field ccf_Probe_T_sip3_main_Probe_Reserved_44 {
                    bits 32;
                    access rw;
                    hard_reset 'h0;
                }
            }
            register ccf_Probe_T_sip3_main_Probe_Reserved_45 @0xE0 {
                bytes 4;
                field ccf_Probe_T_sip3_main_Probe_Reserved_45 {
                    bits 32;
                    access rw;
                    hard_reset 'h0;
                }
            }
            register ccf_Probe_T_sip3_main_Probe_Reserved_46 @0xE4 {
                bytes 4;
                field ccf_Probe_T_sip3_main_Probe_Reserved_46 {
                    bits 32;
                    access rw;
                    hard_reset 'h0;
                }
            }
            register ccf_Probe_T_sip3_main_Probe_Reserved_47 @0xE8 {
                bytes 4;
                field ccf_Probe_T_sip3_main_Probe_Reserved_47 {
                    bits 32;
                    access rw;
                    hard_reset 'h0;
                }
            }
            register ccf_Probe_T_sip3_main_Probe_Reserved_48 @0xEC {
                bytes 4;
                field ccf_Probe_T_sip3_main_Probe_Reserved_48 {
                    bits 32;
                    access rw;
                    hard_reset 'h0;
                }
            }
            register ccf_Probe_T_sip3_main_Probe_Reserved_49 @0xF0 {
                bytes 4;
                field ccf_Probe_T_sip3_main_Probe_Reserved_49 {
                    bits 32;
                    access rw;
                    hard_reset 'h0;
                }
            }
            register ccf_Probe_T_sip3_main_Probe_Reserved_50 @0xF4 {
                bytes 4;
                field ccf_Probe_T_sip3_main_Probe_Reserved_50 {
                    bits 32;
                    access rw;
                    hard_reset 'h0;
                }
            }
            register ccf_Probe_T_sip3_main_Probe_Reserved_51 @0xF8 {
                bytes 4;
                field ccf_Probe_T_sip3_main_Probe_Reserved_51 {
                    bits 32;
                    access rw;
                    hard_reset 'h0;
                }
            }
            register ccf_Probe_T_sip3_main_Probe_Reserved_52 @0xFC {
                bytes 4;
                field ccf_Probe_T_sip3_main_Probe_Reserved_52 {
                    bits 32;
                    access rw;
                    hard_reset 'h0;
                }
            }
            register ccf_Probe_T_sip3_main_Probe_Reserved_53 @0x100 {
                bytes 4;
                field ccf_Probe_T_sip3_main_Probe_Reserved_53 {
                    bits 32;
                    access rw;
                    hard_reset 'h0;
                }
            }
            register ccf_Probe_T_sip3_main_Probe_Reserved_54 @0x104 {
                bytes 4;
                field ccf_Probe_T_sip3_main_Probe_Reserved_54 {
                    bits 32;
                    access rw;
                    hard_reset 'h0;
                }
            }
            register ccf_Probe_T_sip3_main_Probe_Reserved_55 @0x108 {
                bytes 4;
                field ccf_Probe_T_sip3_main_Probe_Reserved_55 {
                    bits 32;
                    access rw;
                    hard_reset 'h0;
                }
            }
            register ccf_Probe_T_sip3_main_Probe_Reserved_56 @0x10C {
                bytes 4;
                field ccf_Probe_T_sip3_main_Probe_Reserved_56 {
                    bits 32;
                    access rw;
                    hard_reset 'h0;
                }
            }
            register ccf_Probe_T_sip3_main_Probe_Reserved_57 @0x110 {
                bytes 4;
                field ccf_Probe_T_sip3_main_Probe_Reserved_57 {
                    bits 32;
                    access rw;
                    hard_reset 'h0;
                }
            }
            register ccf_Probe_T_sip3_main_Probe_Reserved_58 @0x114 {
                bytes 4;
                field ccf_Probe_T_sip3_main_Probe_Reserved_58 {
                    bits 32;
                    access rw;
                    hard_reset 'h0;
                }
            }
            register ccf_Probe_T_sip3_main_Probe_Reserved_59 @0x118 {
                bytes 4;
                field ccf_Probe_T_sip3_main_Probe_Reserved_59 {
                    bits 32;
                    access rw;
                    hard_reset 'h0;
                }
            }
            register ccf_Probe_T_sip3_main_Probe_Reserved_60 @0x11C {
                bytes 4;
                field ccf_Probe_T_sip3_main_Probe_Reserved_60 {
                    bits 32;
                    access rw;
                    hard_reset 'h0;
                }
            }
            register ccf_Probe_T_sip3_main_Probe_Reserved_61 @0x120 {
                bytes 4;
                field ccf_Probe_T_sip3_main_Probe_Reserved_61 {
                    bits 32;
                    access rw;
                    hard_reset 'h0;
                }
            }
            register ccf_Probe_T_sip3_main_Probe_Reserved_62 @0x124 {
                bytes 4;
                field ccf_Probe_T_sip3_main_Probe_Reserved_62 {
                    bits 32;
                    access rw;
                    hard_reset 'h0;
                }
            }
            register ccf_Probe_T_sip3_main_Probe_Reserved_63 @0x128 {
                bytes 4;
                field ccf_Probe_T_sip3_main_Probe_Reserved_63 {
                    bits 32;
                    access rw;
                    hard_reset 'h0;
                }
            }
            register ccf_Probe_T_sip3_main_Probe_Reserved_64 @0x12C {
                bytes 4;
                field ccf_Probe_T_sip3_main_Probe_Reserved_64 {
                    bits 32;
                    access rw;
                    hard_reset 'h0;
                }
            }
            register ccf_Probe_T_sip3_main_Probe_Reserved_65 @0x130 {
                bytes 4;
                field ccf_Probe_T_sip3_main_Probe_Reserved_65 {
                    bits 32;
                    access rw;
                    hard_reset 'h0;
                }
            }
            register ccf_Probe_T_sip3_main_Probe_Reserved_66 @0x134 {
                bytes 4;
                field ccf_Probe_T_sip3_main_Probe_Reserved_66 {
                    bits 32;
                    access rw;
                    hard_reset 'h0;
                }
            }
            register ccf_Probe_T_sip3_main_Probe_Counters_0_Src @0x138 {
                bytes 4;
                field INTEVENT @'h0 {
                    bits 5;
                    access rw;
                    hard_reset 'h0;
                    enum { OFF = 0, CYCLE = 1, IDLE = 2, XFER = 3, BUSY = 4, WAIT = 5, PKT = 6, LUT = 7, BYTE = 8, PRESS0 = 9, PRESS1 = 10, PRESS2 = 11, FILT0 = 12, FILT1 = 13, FILT2 = 14, FILT3 = 15, CHAIN = 16, LUT_BYTE_EN = 17, LUT_BYTE = 18, FILT_BYTE_EN = 19, FILT_BYTE = 20, PRESS3 = 21, PRESS4 = 22, PRESS5 = 23, PRESS6 = 24, RSV_0 = 25, RSV_1 = 26, RSV_2 = 27, RSV_3 = 28, RSV_4 = 29, RSV_5 = 30, RSV_6 = 31 };
                    doc {
                        Internal packet event
                    }
                }
                field EXTEVENT @'h5 {
                    access rw;
                    hard_reset 'h0;
                    doc {
                        When greater than 0, the entire register value is used to select an external hardware event source. The index of the external event is equal to {ExtEvent,IntEvent}.
                    }
                }
                doc {
                    Register CntSrc indicates the event source used to increment the counter. Unassigned values (non-existing Press level or ExtEvent index, or unimplemented Filter) are equivalent to OFF.
	Register CntSrc indicates the event source used to increment the counter. Unassigned values (non-existing Press level or ExtEvent index, or unimplemented Filter) are equivalent to OFF.
	
                }
            }
            register ccf_Probe_T_sip3_main_Probe_Counters_0_AlarmMode @0x13C {
                bytes 4;
                field COUNTERS_0_ALARMMODE @'h0 {
                    bits 2;
                    access rw;
                    hard_reset 'h0;
                    enum { OFF = 0, MIN = 1, MAX = 2, MIN_MAX = 3 };
                    doc {
                        Register AlarmMode is a 2-bit register that is present when parameter statisticsCounterAlarm is set to True. The register defines the statistics-alarm behavior of the counter.
                    }
                }
            }
            register ccf_Probe_T_sip3_main_Probe_Counters_0_Val @0x140 {
                bytes 4;
                field COUNTERS_0_VAL @'h0 {
                    bits 11;
                    access ro;
                    hard_reset 'h0;
                    doc {
                        Register Val is a read-only register that is always present. The register containsthe statistics counter value either pending StatAlarm output, or when statisticscollection is suspended subsequent to triggers or signal statSuspend.
                    }
                }
            }
            register ccf_Probe_T_sip3_main_Probe_Reserved_67 @0x144 {
                bytes 4;
                field ccf_Probe_T_sip3_main_Probe_Reserved_67 {
                    bits 32;
                    access rw;
                    hard_reset 'h0;
                }
            }
            register ccf_Probe_T_sip3_main_Probe_Reserved_68 @0x148 {
                bytes 4;
                field ccf_Probe_T_sip3_main_Probe_Reserved_68 {
                    bits 32;
                    access rw;
                    hard_reset 'h0;
                }
            }
            register ccf_Probe_T_sip3_main_Probe_Counters_1_Src @0x14C {
                bytes 4;
                field INTEVENT @'h0 {
                    bits 5;
                    access rw;
                    hard_reset 'h0;
                    enum { OFF = 0, CYCLE = 1, IDLE = 2, XFER = 3, BUSY = 4, WAIT = 5, PKT = 6, LUT = 7, BYTE = 8, PRESS0 = 9, PRESS1 = 10, PRESS2 = 11, FILT0 = 12, FILT1 = 13, FILT2 = 14, FILT3 = 15, CHAIN = 16, LUT_BYTE_EN = 17, LUT_BYTE = 18, FILT_BYTE_EN = 19, FILT_BYTE = 20, PRESS3 = 21, PRESS4 = 22, PRESS5 = 23, PRESS6 = 24, RSV_0 = 25, RSV_1 = 26, RSV_2 = 27, RSV_3 = 28, RSV_4 = 29, RSV_5 = 30, RSV_6 = 31 };
                    doc {
                        Internal packet event
                    }
                }
                field EXTEVENT @'h5 {
                    access rw;
                    hard_reset 'h0;
                    doc {
                        When greater than 0, the entire register value is used to select an external hardware event source. The index of the external event is equal to {ExtEvent,IntEvent}.
                    }
                }
                doc {
                    Register CntSrc indicates the event source used to increment the counter. Unassigned values (non-existing Press level or ExtEvent index, or unimplemented Filter) are equivalent to OFF.
	Register CntSrc indicates the event source used to increment the counter. Unassigned values (non-existing Press level or ExtEvent index, or unimplemented Filter) are equivalent to OFF.
	
                }
            }
            register ccf_Probe_T_sip3_main_Probe_Counters_1_AlarmMode @0x150 {
                bytes 4;
                field COUNTERS_1_ALARMMODE @'h0 {
                    bits 2;
                    access rw;
                    hard_reset 'h0;
                    enum { OFF = 0, MIN = 1, MAX = 2, MIN_MAX = 3 };
                    doc {
                        Register AlarmMode is a 2-bit register that is present when parameter statisticsCounterAlarm is set to True. The register defines the statistics-alarm behavior of the counter.
                    }
                }
            }
            register ccf_Probe_T_sip3_main_Probe_Counters_1_Val @0x154 {
                bytes 4;
                field COUNTERS_1_VAL @'h0 {
                    bits 11;
                    access ro;
                    hard_reset 'h0;
                    doc {
                        Register Val is a read-only register that is always present. The register containsthe statistics counter value either pending StatAlarm output, or when statisticscollection is suspended subsequent to triggers or signal statSuspend.
                    }
                }
            }
            register ccf_Probe_T_sip3_main_Probe_Reserved_69 @0x158 {
                bytes 4;
                field ccf_Probe_T_sip3_main_Probe_Reserved_69 {
                    bits 32;
                    access rw;
                    hard_reset 'h0;
                }
            }
            register ccf_Probe_T_sip3_main_Probe_Reserved_70 @0x15C {
                bytes 4;
                field ccf_Probe_T_sip3_main_Probe_Reserved_70 {
                    bits 32;
                    access rw;
                    hard_reset 'h0;
                }
            }
            register ccf_Probe_T_sip3_main_Probe_Reserved_71 @0x160 {
                bytes 4;
                field ccf_Probe_T_sip3_main_Probe_Reserved_71 {
                    bits 32;
                    access rw;
                    hard_reset 'h0;
                }
            }
            register ccf_Probe_T_sip3_main_Probe_Reserved_72 @0x164 {
                bytes 4;
                field ccf_Probe_T_sip3_main_Probe_Reserved_72 {
                    bits 32;
                    access rw;
                    hard_reset 'h0;
                }
            }
            register ccf_Probe_T_sip3_main_Probe_Reserved_73 @0x168 {
                bytes 4;
                field ccf_Probe_T_sip3_main_Probe_Reserved_73 {
                    bits 32;
                    access rw;
                    hard_reset 'h0;
                }
            }
            register ccf_Probe_T_sip3_main_Probe_Reserved_74 @0x16C {
                bytes 4;
                field ccf_Probe_T_sip3_main_Probe_Reserved_74 {
                    bits 32;
                    access rw;
                    hard_reset 'h0;
                }
            }
            register ccf_Probe_T_sip3_main_Probe_Reserved_75 @0x170 {
                bytes 4;
                field ccf_Probe_T_sip3_main_Probe_Reserved_75 {
                    bits 32;
                    access rw;
                    hard_reset 'h0;
                }
            }
            register ccf_Probe_T_sip3_main_Probe_Reserved_76 @0x174 {
                bytes 4;
                field ccf_Probe_T_sip3_main_Probe_Reserved_76 {
                    bits 32;
                    access rw;
                    hard_reset 'h0;
                }
            }
            register ccf_Probe_T_sip3_main_Probe_Reserved_77 @0x178 {
                bytes 4;
                field ccf_Probe_T_sip3_main_Probe_Reserved_77 {
                    bits 32;
                    access rw;
                    hard_reset 'h0;
                }
            }
            register ccf_Probe_T_sip3_main_Probe_Reserved_78 @0x17C {
                bytes 4;
                field ccf_Probe_T_sip3_main_Probe_Reserved_78 {
                    bits 32;
                    access rw;
                    hard_reset 'h0;
                }
            }
            register ccf_Probe_T_sip3_main_Probe_Reserved_79 @0x180 {
                bytes 4;
                field ccf_Probe_T_sip3_main_Probe_Reserved_79 {
                    bits 32;
                    access rw;
                    hard_reset 'h0;
                }
            }
            register ccf_Probe_T_sip3_main_Probe_Reserved_80 @0x184 {
                bytes 4;
                field ccf_Probe_T_sip3_main_Probe_Reserved_80 {
                    bits 32;
                    access rw;
                    hard_reset 'h0;
                }
            }
            register ccf_Probe_T_sip3_main_Probe_Reserved_81 @0x188 {
                bytes 4;
                field ccf_Probe_T_sip3_main_Probe_Reserved_81 {
                    bits 32;
                    access rw;
                    hard_reset 'h0;
                }
            }
            register ccf_Probe_T_sip3_main_Probe_Reserved_82 @0x18C {
                bytes 4;
                field ccf_Probe_T_sip3_main_Probe_Reserved_82 {
                    bits 32;
                    access rw;
                    hard_reset 'h0;
                }
            }
            register ccf_Probe_T_sip3_main_Probe_Reserved_83 @0x190 {
                bytes 4;
                field ccf_Probe_T_sip3_main_Probe_Reserved_83 {
                    bits 32;
                    access rw;
                    hard_reset 'h0;
                }
            }
            register ccf_Probe_T_sip3_main_Probe_Reserved_84 @0x194 {
                bytes 4;
                field ccf_Probe_T_sip3_main_Probe_Reserved_84 {
                    bits 32;
                    access rw;
                    hard_reset 'h0;
                }
            }
            register ccf_Probe_T_sip3_main_Probe_Reserved_85 @0x198 {
                bytes 4;
                field ccf_Probe_T_sip3_main_Probe_Reserved_85 {
                    bits 32;
                    access rw;
                    hard_reset 'h0;
                }
            }
            register ccf_Probe_T_sip3_main_Probe_Reserved_86 @0x19C {
                bytes 4;
                field ccf_Probe_T_sip3_main_Probe_Reserved_86 {
                    bits 32;
                    access rw;
                    hard_reset 'h0;
                }
            }
            register ccf_Probe_T_sip3_main_Probe_Reserved_87 @0x1A0 {
                bytes 4;
                field ccf_Probe_T_sip3_main_Probe_Reserved_87 {
                    bits 32;
                    access rw;
                    hard_reset 'h0;
                }
            }
            register ccf_Probe_T_sip3_main_Probe_Reserved_88 @0x1A4 {
                bytes 4;
                field ccf_Probe_T_sip3_main_Probe_Reserved_88 {
                    bits 32;
                    access rw;
                    hard_reset 'h0;
                }
            }
            register ccf_Probe_T_sip3_main_Probe_Reserved_89 @0x1A8 {
                bytes 4;
                field ccf_Probe_T_sip3_main_Probe_Reserved_89 {
                    bits 32;
                    access rw;
                    hard_reset 'h0;
                }
            }
            register ccf_Probe_T_sip3_main_Probe_Reserved_90 @0x1AC {
                bytes 4;
                field ccf_Probe_T_sip3_main_Probe_Reserved_90 {
                    bits 32;
                    access rw;
                    hard_reset 'h0;
                }
            }
            register ccf_Probe_T_sip3_main_Probe_Reserved_91 @0x1B0 {
                bytes 4;
                field ccf_Probe_T_sip3_main_Probe_Reserved_91 {
                    bits 32;
                    access rw;
                    hard_reset 'h0;
                }
            }
            register ccf_Probe_T_sip3_main_Probe_Reserved_92 @0x1B4 {
                bytes 4;
                field ccf_Probe_T_sip3_main_Probe_Reserved_92 {
                    bits 32;
                    access rw;
                    hard_reset 'h0;
                }
            }
            register ccf_Probe_T_sip3_main_Probe_Reserved_93 @0x1B8 {
                bytes 4;
                field ccf_Probe_T_sip3_main_Probe_Reserved_93 {
                    bits 32;
                    access rw;
                    hard_reset 'h0;
                }
            }
            register ccf_Probe_T_sip3_main_Probe_Reserved_94 @0x1BC {
                bytes 4;
                field ccf_Probe_T_sip3_main_Probe_Reserved_94 {
                    bits 32;
                    access rw;
                    hard_reset 'h0;
                }
            }
            register ccf_Probe_T_sip3_main_Probe_Reserved_95 @0x1C0 {
                bytes 4;
                field ccf_Probe_T_sip3_main_Probe_Reserved_95 {
                    bits 32;
                    access rw;
                    hard_reset 'h0;
                }
            }
            register ccf_Probe_T_sip3_main_Probe_Reserved_96 @0x1C4 {
                bytes 4;
                field ccf_Probe_T_sip3_main_Probe_Reserved_96 {
                    bits 32;
                    access rw;
                    hard_reset 'h0;
                }
            }
            register ccf_Probe_T_sip3_main_Probe_Reserved_97 @0x1C8 {
                bytes 4;
                field ccf_Probe_T_sip3_main_Probe_Reserved_97 {
                    bits 32;
                    access rw;
                    hard_reset 'h0;
                }
            }
            register ccf_Probe_T_sip3_main_Probe_Reserved_98 @0x1CC {
                bytes 4;
                field ccf_Probe_T_sip3_main_Probe_Reserved_98 {
                    bits 32;
                    access rw;
                    hard_reset 'h0;
                }
            }
            register ccf_Probe_T_sip3_main_Probe_Reserved_99 @0x1D0 {
                bytes 4;
                field ccf_Probe_T_sip3_main_Probe_Reserved_99 {
                    bits 32;
                    access rw;
                    hard_reset 'h0;
                }
            }
            register ccf_Probe_T_sip3_main_Probe_Reserved_100 @0x1D4 {
                bytes 4;
                field ccf_Probe_T_sip3_main_Probe_Reserved_100 {
                    bits 32;
                    access rw;
                    hard_reset 'h0;
                }
            }
            register ccf_Probe_T_sip3_main_Probe_Reserved_101 @0x1D8 {
                bytes 4;
                field ccf_Probe_T_sip3_main_Probe_Reserved_101 {
                    bits 32;
                    access rw;
                    hard_reset 'h0;
                }
            }
            register ccf_Probe_T_sip3_main_Probe_Reserved_102 @0x1DC {
                bytes 4;
                field ccf_Probe_T_sip3_main_Probe_Reserved_102 {
                    bits 32;
                    access rw;
                    hard_reset 'h0;
                }
            }
            register ccf_Probe_T_sip3_main_Probe_Reserved_103 @0x1E0 {
                bytes 4;
                field ccf_Probe_T_sip3_main_Probe_Reserved_103 {
                    bits 32;
                    access rw;
                    hard_reset 'h0;
                }
            }
            register ccf_Probe_T_sip3_main_Probe_Reserved_104 @0x1E4 {
                bytes 4;
                field ccf_Probe_T_sip3_main_Probe_Reserved_104 {
                    bits 32;
                    access rw;
                    hard_reset 'h0;
                }
            }
            register ccf_Probe_T_sip3_main_Probe_Reserved_105 @0x1E8 {
                bytes 4;
                field ccf_Probe_T_sip3_main_Probe_Reserved_105 {
                    bits 32;
                    access rw;
                    hard_reset 'h0;
                }
            }
            register ccf_Probe_T_sip3_main_Probe_Reserved_106 @0x1EC {
                bytes 4;
                field ccf_Probe_T_sip3_main_Probe_Reserved_106 {
                    bits 32;
                    access rw;
                    hard_reset 'h0;
                }
            }
            register ccf_Probe_T_sip3_main_Probe_Reserved_107 @0x1F0 {
                bytes 4;
                field ccf_Probe_T_sip3_main_Probe_Reserved_107 {
                    bits 32;
                    access rw;
                    hard_reset 'h0;
                }
            }
            register ccf_Probe_T_sip3_main_Probe_Reserved_108 @0x1F4 {
                bytes 4;
                field ccf_Probe_T_sip3_main_Probe_Reserved_108 {
                    bits 32;
                    access rw;
                    hard_reset 'h0;
                }
            }
            register ccf_Probe_T_sip3_main_Probe_Reserved_109 @0x1F8 {
                bytes 4;
                field ccf_Probe_T_sip3_main_Probe_Reserved_109 {
                    bits 32;
                    access rw;
                    hard_reset 'h0;
                }
            }
            register ccf_Probe_T_sip3_main_Probe_Reserved_110 @0x1FC {
                bytes 4;
                field ccf_Probe_T_sip3_main_Probe_Reserved_110 {
                    bits 32;
                    access rw;
                    hard_reset 'h0;
                }
            }
            register ccf_Probe_T_sip3_main_Probe_Reserved_111 @0x200 {
                bytes 4;
                field ccf_Probe_T_sip3_main_Probe_Reserved_111 {
                    bits 32;
                    access rw;
                    hard_reset 'h0;
                }
            }
            register ccf_Probe_T_sip3_main_Probe_Reserved_112 @0x204 {
                bytes 4;
                field ccf_Probe_T_sip3_main_Probe_Reserved_112 {
                    bits 32;
                    access rw;
                    hard_reset 'h0;
                }
            }
            register ccf_Probe_T_sip3_main_Probe_Reserved_113 @0x208 {
                bytes 4;
                field ccf_Probe_T_sip3_main_Probe_Reserved_113 {
                    bits 32;
                    access rw;
                    hard_reset 'h0;
                }
            }
            register ccf_Probe_T_sip3_main_Probe_Reserved_114 @0x20C {
                bytes 4;
                field ccf_Probe_T_sip3_main_Probe_Reserved_114 {
                    bits 32;
                    access rw;
                    hard_reset 'h0;
                }
            }
            register ccf_Probe_T_sip3_main_Probe_Reserved_115 @0x210 {
                bytes 4;
                field ccf_Probe_T_sip3_main_Probe_Reserved_115 {
                    bits 32;
                    access rw;
                    hard_reset 'h0;
                }
            }
            register ccf_Probe_T_sip3_main_Probe_Reserved_116 @0x214 {
                bytes 4;
                field ccf_Probe_T_sip3_main_Probe_Reserved_116 {
                    bits 32;
                    access rw;
                    hard_reset 'h0;
                }
            }
            register ccf_Probe_T_sip3_main_Probe_Reserved_117 @0x218 {
                bytes 4;
                field ccf_Probe_T_sip3_main_Probe_Reserved_117 {
                    bits 32;
                    access rw;
                    hard_reset 'h0;
                }
            }
            register ccf_Probe_T_sip3_main_Probe_Reserved_118 @0x21C {
                bytes 4;
                field ccf_Probe_T_sip3_main_Probe_Reserved_118 {
                    bits 32;
                    access rw;
                    hard_reset 'h0;
                }
            }
            register ccf_Probe_T_sip3_main_Probe_Reserved_119 @0x220 {
                bytes 4;
                field ccf_Probe_T_sip3_main_Probe_Reserved_119 {
                    bits 32;
                    access rw;
                    hard_reset 'h0;
                }
            }
            register ccf_Probe_T_sip3_main_Probe_Reserved_120 @0x224 {
                bytes 4;
                field ccf_Probe_T_sip3_main_Probe_Reserved_120 {
                    bits 32;
                    access rw;
                    hard_reset 'h0;
                }
            }
            register ccf_Probe_T_sip3_main_Probe_Reserved_121 @0x228 {
                bytes 4;
                field ccf_Probe_T_sip3_main_Probe_Reserved_121 {
                    bits 32;
                    access rw;
                    hard_reset 'h0;
                }
            }
            register ccf_Probe_T_sip3_main_Probe_Reserved_122 @0x22C {
                bytes 4;
                field ccf_Probe_T_sip3_main_Probe_Reserved_122 {
                    bits 32;
                    access rw;
                    hard_reset 'h0;
                }
            }
            register ccf_Probe_T_sip3_main_Probe_Reserved_123 @0x230 {
                bytes 4;
                field ccf_Probe_T_sip3_main_Probe_Reserved_123 {
                    bits 32;
                    access rw;
                    hard_reset 'h0;
                }
            }
            register ccf_Probe_T_sip3_main_Probe_Reserved_124 @0x234 {
                bytes 4;
                field ccf_Probe_T_sip3_main_Probe_Reserved_124 {
                    bits 32;
                    access rw;
                    hard_reset 'h0;
                }
            }
            register ccf_Probe_T_sip3_main_Probe_Reserved_125 @0x238 {
                bytes 4;
                field ccf_Probe_T_sip3_main_Probe_Reserved_125 {
                    bits 32;
                    access rw;
                    hard_reset 'h0;
                }
            }
            register ccf_Probe_T_sip3_main_Probe_Reserved_126 @0x23C {
                bytes 4;
                field ccf_Probe_T_sip3_main_Probe_Reserved_126 {
                    bits 32;
                    access rw;
                    hard_reset 'h0;
                }
            }
            register ccf_Probe_T_sip3_main_Probe_Reserved_127 @0x240 {
                bytes 4;
                field ccf_Probe_T_sip3_main_Probe_Reserved_127 {
                    bits 32;
                    access rw;
                    hard_reset 'h0;
                }
            }
            register ccf_Probe_T_sip3_main_Probe_Reserved_128 @0x244 {
                bytes 4;
                field ccf_Probe_T_sip3_main_Probe_Reserved_128 {
                    bits 32;
                    access rw;
                    hard_reset 'h0;
                }
            }
            register ccf_Probe_T_sip3_main_Probe_Reserved_129 @0x248 {
                bytes 4;
                field ccf_Probe_T_sip3_main_Probe_Reserved_129 {
                    bits 32;
                    access rw;
                    hard_reset 'h0;
                }
            }
            register ccf_Probe_T_sip3_main_Probe_Reserved_130 @0x24C {
                bytes 4;
                field ccf_Probe_T_sip3_main_Probe_Reserved_130 {
                    bits 32;
                    access rw;
                    hard_reset 'h0;
                }
            }
            register ccf_Probe_T_sip3_main_Probe_Reserved_131 @0x250 {
                bytes 4;
                field ccf_Probe_T_sip3_main_Probe_Reserved_131 {
                    bits 32;
                    access rw;
                    hard_reset 'h0;
                }
            }
            register ccf_Probe_T_sip3_main_Probe_Reserved_132 @0x254 {
                bytes 4;
                field ccf_Probe_T_sip3_main_Probe_Reserved_132 {
                    bits 32;
                    access rw;
                    hard_reset 'h0;
                }
            }
            register ccf_Probe_T_sip3_main_Probe_Reserved_133 @0x258 {
                bytes 4;
                field ccf_Probe_T_sip3_main_Probe_Reserved_133 {
                    bits 32;
                    access rw;
                    hard_reset 'h0;
                }
            }
            register ccf_Probe_T_sip3_main_Probe_Reserved_134 @0x25C {
                bytes 4;
                field ccf_Probe_T_sip3_main_Probe_Reserved_134 {
                    bits 32;
                    access rw;
                    hard_reset 'h0;
                }
            }
            register ccf_Probe_T_sip3_main_Probe_Reserved_135 @0x260 {
                bytes 4;
                field ccf_Probe_T_sip3_main_Probe_Reserved_135 {
                    bits 32;
                    access rw;
                    hard_reset 'h0;
                }
            }
            register ccf_Probe_T_sip3_main_Probe_Reserved_136 @0x264 {
                bytes 4;
                field ccf_Probe_T_sip3_main_Probe_Reserved_136 {
                    bits 32;
                    access rw;
                    hard_reset 'h0;
                }
            }
            register ccf_Probe_T_sip3_main_Probe_Reserved_137 @0x268 {
                bytes 4;
                field ccf_Probe_T_sip3_main_Probe_Reserved_137 {
                    bits 32;
                    access rw;
                    hard_reset 'h0;
                }
            }
            register ccf_Probe_T_sip3_main_Probe_Reserved_138 @0x26C {
                bytes 4;
                field ccf_Probe_T_sip3_main_Probe_Reserved_138 {
                    bits 32;
                    access rw;
                    hard_reset 'h0;
                }
            }
            register ccf_Probe_T_sip3_main_Probe_Reserved_139 @0x270 {
                bytes 4;
                field ccf_Probe_T_sip3_main_Probe_Reserved_139 {
                    bits 32;
                    access rw;
                    hard_reset 'h0;
                }
            }
            register ccf_Probe_T_sip3_main_Probe_Reserved_140 @0x274 {
                bytes 4;
                field ccf_Probe_T_sip3_main_Probe_Reserved_140 {
                    bits 32;
                    access rw;
                    hard_reset 'h0;
                }
            }
            register ccf_Probe_T_sip3_main_Probe_Reserved_141 @0x278 {
                bytes 4;
                field ccf_Probe_T_sip3_main_Probe_Reserved_141 {
                    bits 32;
                    access rw;
                    hard_reset 'h0;
                }
            }
            register ccf_Probe_T_sip3_main_Probe_Reserved_142 @0x27C {
                bytes 4;
                field ccf_Probe_T_sip3_main_Probe_Reserved_142 {
                    bits 32;
                    access rw;
                    hard_reset 'h0;
                }
            }
            register ccf_Probe_T_sip3_main_Probe_Reserved_143 @0x280 {
                bytes 4;
                field ccf_Probe_T_sip3_main_Probe_Reserved_143 {
                    bits 32;
                    access rw;
                    hard_reset 'h0;
                }
            }
            register ccf_Probe_T_sip3_main_Probe_Reserved_144 @0x284 {
                bytes 4;
                field ccf_Probe_T_sip3_main_Probe_Reserved_144 {
                    bits 32;
                    access rw;
                    hard_reset 'h0;
                }
            }
            register ccf_Probe_T_sip3_main_Probe_Reserved_145 @0x288 {
                bytes 4;
                field ccf_Probe_T_sip3_main_Probe_Reserved_145 {
                    bits 32;
                    access rw;
                    hard_reset 'h0;
                }
            }
            register ccf_Probe_T_sip3_main_Probe_Reserved_146 @0x28C {
                bytes 4;
                field ccf_Probe_T_sip3_main_Probe_Reserved_146 {
                    bits 32;
                    access rw;
                    hard_reset 'h0;
                }
            }
            register ccf_Probe_T_sip3_main_Probe_Reserved_147 @0x290 {
                bytes 4;
                field ccf_Probe_T_sip3_main_Probe_Reserved_147 {
                    bits 32;
                    access rw;
                    hard_reset 'h0;
                }
            }
            register ccf_Probe_T_sip3_main_Probe_Reserved_148 @0x294 {
                bytes 4;
                field ccf_Probe_T_sip3_main_Probe_Reserved_148 {
                    bits 32;
                    access rw;
                    hard_reset 'h0;
                }
            }
            register ccf_Probe_T_sip3_main_Probe_Reserved_149 @0x298 {
                bytes 4;
                field ccf_Probe_T_sip3_main_Probe_Reserved_149 {
                    bits 32;
                    access rw;
                    hard_reset 'h0;
                }
            }
            register ccf_Probe_T_sip3_main_Probe_Reserved_150 @0x29C {
                bytes 4;
                field ccf_Probe_T_sip3_main_Probe_Reserved_150 {
                    bits 32;
                    access rw;
                    hard_reset 'h0;
                }
            }
            register ccf_Probe_T_sip3_main_Probe_Reserved_151 @0x2A0 {
                bytes 4;
                field ccf_Probe_T_sip3_main_Probe_Reserved_151 {
                    bits 32;
                    access rw;
                    hard_reset 'h0;
                }
            }
            register ccf_Probe_T_sip3_main_Probe_Reserved_152 @0x2A4 {
                bytes 4;
                field ccf_Probe_T_sip3_main_Probe_Reserved_152 {
                    bits 32;
                    access rw;
                    hard_reset 'h0;
                }
            }
            register ccf_Probe_T_sip3_main_Probe_Reserved_153 @0x2A8 {
                bytes 4;
                field ccf_Probe_T_sip3_main_Probe_Reserved_153 {
                    bits 32;
                    access rw;
                    hard_reset 'h0;
                }
            }
            register ccf_Probe_T_sip3_main_Probe_Reserved_154 @0x2AC {
                bytes 4;
                field ccf_Probe_T_sip3_main_Probe_Reserved_154 {
                    bits 32;
                    access rw;
                    hard_reset 'h0;
                }
            }
            register ccf_Probe_T_sip3_main_Probe_Reserved_155 @0x2B0 {
                bytes 4;
                field ccf_Probe_T_sip3_main_Probe_Reserved_155 {
                    bits 32;
                    access rw;
                    hard_reset 'h0;
                }
            }
            register ccf_Probe_T_sip3_main_Probe_Reserved_156 @0x2B4 {
                bytes 4;
                field ccf_Probe_T_sip3_main_Probe_Reserved_156 {
                    bits 32;
                    access rw;
                    hard_reset 'h0;
                }
            }
            register ccf_Probe_T_sip3_main_Probe_Reserved_157 @0x2B8 {
                bytes 4;
                field ccf_Probe_T_sip3_main_Probe_Reserved_157 {
                    bits 32;
                    access rw;
                    hard_reset 'h0;
                }
            }
            register ccf_Probe_T_sip3_main_Probe_Reserved_158 @0x2BC {
                bytes 4;
                field ccf_Probe_T_sip3_main_Probe_Reserved_158 {
                    bits 32;
                    access rw;
                    hard_reset 'h0;
                }
            }
            register ccf_Probe_T_sip3_main_Probe_Reserved_159 @0x2C0 {
                bytes 4;
                field ccf_Probe_T_sip3_main_Probe_Reserved_159 {
                    bits 32;
                    access rw;
                    hard_reset 'h0;
                }
            }
            register ccf_Probe_T_sip3_main_Probe_Reserved_160 @0x2C4 {
                bytes 4;
                field ccf_Probe_T_sip3_main_Probe_Reserved_160 {
                    bits 32;
                    access rw;
                    hard_reset 'h0;
                }
            }
            register ccf_Probe_T_sip3_main_Probe_Reserved_161 @0x2C8 {
                bytes 4;
                field ccf_Probe_T_sip3_main_Probe_Reserved_161 {
                    bits 32;
                    access rw;
                    hard_reset 'h0;
                }
            }
            register ccf_Probe_T_sip3_main_Probe_Reserved_162 @0x2CC {
                bytes 4;
                field ccf_Probe_T_sip3_main_Probe_Reserved_162 {
                    bits 32;
                    access rw;
                    hard_reset 'h0;
                }
            }
            register ccf_Probe_T_sip3_main_Probe_Reserved_163 @0x2D0 {
                bytes 4;
                field ccf_Probe_T_sip3_main_Probe_Reserved_163 {
                    bits 32;
                    access rw;
                    hard_reset 'h0;
                }
            }
            register ccf_Probe_T_sip3_main_Probe_Reserved_164 @0x2D4 {
                bytes 4;
                field ccf_Probe_T_sip3_main_Probe_Reserved_164 {
                    bits 32;
                    access rw;
                    hard_reset 'h0;
                }
            }
            register ccf_Probe_T_sip3_main_Probe_Reserved_165 @0x2D8 {
                bytes 4;
                field ccf_Probe_T_sip3_main_Probe_Reserved_165 {
                    bits 32;
                    access rw;
                    hard_reset 'h0;
                }
            }
            register ccf_Probe_T_sip3_main_Probe_Reserved_166 @0x2DC {
                bytes 4;
                field ccf_Probe_T_sip3_main_Probe_Reserved_166 {
                    bits 32;
                    access rw;
                    hard_reset 'h0;
                }
            }
            register ccf_Probe_T_sip3_main_Probe_Reserved_167 @0x2E0 {
                bytes 4;
                field ccf_Probe_T_sip3_main_Probe_Reserved_167 {
                    bits 32;
                    access rw;
                    hard_reset 'h0;
                }
            }
            register ccf_Probe_T_sip3_main_Probe_Reserved_168 @0x2E4 {
                bytes 4;
                field ccf_Probe_T_sip3_main_Probe_Reserved_168 {
                    bits 32;
                    access rw;
                    hard_reset 'h0;
                }
            }
            register ccf_Probe_T_sip3_main_Probe_Reserved_169 @0x2E8 {
                bytes 4;
                field ccf_Probe_T_sip3_main_Probe_Reserved_169 {
                    bits 32;
                    access rw;
                    hard_reset 'h0;
                }
            }
            register ccf_Probe_T_sip3_main_Probe_Reserved_170 @0x2EC {
                bytes 4;
                field ccf_Probe_T_sip3_main_Probe_Reserved_170 {
                    bits 32;
                    access rw;
                    hard_reset 'h0;
                }
            }
            register ccf_Probe_T_sip3_main_Probe_Reserved_171 @0x2F0 {
                bytes 4;
                field ccf_Probe_T_sip3_main_Probe_Reserved_171 {
                    bits 32;
                    access rw;
                    hard_reset 'h0;
                }
            }
            register ccf_Probe_T_sip3_main_Probe_Reserved_172 @0x2F4 {
                bytes 4;
                field ccf_Probe_T_sip3_main_Probe_Reserved_172 {
                    bits 32;
                    access rw;
                    hard_reset 'h0;
                }
            }
            register ccf_Probe_T_sip3_main_Probe_Reserved_173 @0x2F8 {
                bytes 4;
                field ccf_Probe_T_sip3_main_Probe_Reserved_173 {
                    bits 32;
                    access rw;
                    hard_reset 'h0;
                }
            }
            register ccf_Probe_T_sip3_main_Probe_Reserved_174 @0x2FC {
                bytes 4;
                field ccf_Probe_T_sip3_main_Probe_Reserved_174 {
                    bits 32;
                    access rw;
                    hard_reset 'h0;
                }
            }
            register ccf_Probe_T_sip3_main_Probe_Reserved_175 @0x300 {
                bytes 4;
                field ccf_Probe_T_sip3_main_Probe_Reserved_175 {
                    bits 32;
                    access rw;
                    hard_reset 'h0;
                }
            }
            register ccf_Probe_T_sip3_main_Probe_Reserved_176 @0x304 {
                bytes 4;
                field ccf_Probe_T_sip3_main_Probe_Reserved_176 {
                    bits 32;
                    access rw;
                    hard_reset 'h0;
                }
            }
            register ccf_Probe_T_sip3_main_Probe_Reserved_177 @0x308 {
                bytes 4;
                field ccf_Probe_T_sip3_main_Probe_Reserved_177 {
                    bits 32;
                    access rw;
                    hard_reset 'h0;
                }
            }
            register ccf_Probe_T_sip3_main_Probe_Reserved_178 @0x30C {
                bytes 4;
                field ccf_Probe_T_sip3_main_Probe_Reserved_178 {
                    bits 32;
                    access rw;
                    hard_reset 'h0;
                }
            }
            register ccf_Probe_T_sip3_main_Probe_Reserved_179 @0x310 {
                bytes 4;
                field ccf_Probe_T_sip3_main_Probe_Reserved_179 {
                    bits 32;
                    access rw;
                    hard_reset 'h0;
                }
            }
            register ccf_Probe_T_sip3_main_Probe_Reserved_180 @0x314 {
                bytes 4;
                field ccf_Probe_T_sip3_main_Probe_Reserved_180 {
                    bits 32;
                    access rw;
                    hard_reset 'h0;
                }
            }
            register ccf_Probe_T_sip3_main_Probe_Reserved_181 @0x318 {
                bytes 4;
                field ccf_Probe_T_sip3_main_Probe_Reserved_181 {
                    bits 32;
                    access rw;
                    hard_reset 'h0;
                }
            }
            register ccf_Probe_T_sip3_main_Probe_Reserved_182 @0x31C {
                bytes 4;
                field ccf_Probe_T_sip3_main_Probe_Reserved_182 {
                    bits 32;
                    access rw;
                    hard_reset 'h0;
                }
            }
            register ccf_Probe_T_sip3_main_Probe_Reserved_183 @0x320 {
                bytes 4;
                field ccf_Probe_T_sip3_main_Probe_Reserved_183 {
                    bits 32;
                    access rw;
                    hard_reset 'h0;
                }
            }
            register ccf_Probe_T_sip3_main_Probe_Reserved_184 @0x324 {
                bytes 4;
                field ccf_Probe_T_sip3_main_Probe_Reserved_184 {
                    bits 32;
                    access rw;
                    hard_reset 'h0;
                }
            }
            register ccf_Probe_T_sip3_main_Probe_Reserved_185 @0x328 {
                bytes 4;
                field ccf_Probe_T_sip3_main_Probe_Reserved_185 {
                    bits 32;
                    access rw;
                    hard_reset 'h0;
                }
            }
            register ccf_Probe_T_sip3_main_Probe_Reserved_186 @0x32C {
                bytes 4;
                field ccf_Probe_T_sip3_main_Probe_Reserved_186 {
                    bits 32;
                    access rw;
                    hard_reset 'h0;
                }
            }
            register ccf_Probe_T_sip3_main_Probe_Reserved_187 @0x330 {
                bytes 4;
                field ccf_Probe_T_sip3_main_Probe_Reserved_187 {
                    bits 32;
                    access rw;
                    hard_reset 'h0;
                }
            }
            register ccf_Probe_T_sip3_main_Probe_Reserved_188 @0x334 {
                bytes 4;
                field ccf_Probe_T_sip3_main_Probe_Reserved_188 {
                    bits 32;
                    access rw;
                    hard_reset 'h0;
                }
            }
            register ccf_Probe_T_sip3_main_Probe_Reserved_189 @0x338 {
                bytes 4;
                field ccf_Probe_T_sip3_main_Probe_Reserved_189 {
                    bits 32;
                    access rw;
                    hard_reset 'h0;
                }
            }
            register ccf_Probe_T_sip3_main_Probe_Reserved_190 @0x33C {
                bytes 4;
                field ccf_Probe_T_sip3_main_Probe_Reserved_190 {
                    bits 32;
                    access rw;
                    hard_reset 'h0;
                }
            }
            register ccf_Probe_T_sip3_main_Probe_Reserved_191 @0x340 {
                bytes 4;
                field ccf_Probe_T_sip3_main_Probe_Reserved_191 {
                    bits 32;
                    access rw;
                    hard_reset 'h0;
                }
            }
            register ccf_Probe_T_sip3_main_Probe_Reserved_192 @0x344 {
                bytes 4;
                field ccf_Probe_T_sip3_main_Probe_Reserved_192 {
                    bits 32;
                    access rw;
                    hard_reset 'h0;
                }
            }
            register ccf_Probe_T_sip3_main_Probe_Reserved_193 @0x348 {
                bytes 4;
                field ccf_Probe_T_sip3_main_Probe_Reserved_193 {
                    bits 32;
                    access rw;
                    hard_reset 'h0;
                }
            }
            register ccf_Probe_T_sip3_main_Probe_Reserved_194 @0x34C {
                bytes 4;
                field ccf_Probe_T_sip3_main_Probe_Reserved_194 {
                    bits 32;
                    access rw;
                    hard_reset 'h0;
                }
            }
            register ccf_Probe_T_sip3_main_Probe_Reserved_195 @0x350 {
                bytes 4;
                field ccf_Probe_T_sip3_main_Probe_Reserved_195 {
                    bits 32;
                    access rw;
                    hard_reset 'h0;
                }
            }
            register ccf_Probe_T_sip3_main_Probe_Reserved_196 @0x354 {
                bytes 4;
                field ccf_Probe_T_sip3_main_Probe_Reserved_196 {
                    bits 32;
                    access rw;
                    hard_reset 'h0;
                }
            }
            register ccf_Probe_T_sip3_main_Probe_Reserved_197 @0x358 {
                bytes 4;
                field ccf_Probe_T_sip3_main_Probe_Reserved_197 {
                    bits 32;
                    access rw;
                    hard_reset 'h0;
                }
            }
            register ccf_Probe_T_sip3_main_Probe_Reserved_198 @0x35C {
                bytes 4;
                field ccf_Probe_T_sip3_main_Probe_Reserved_198 {
                    bits 32;
                    access rw;
                    hard_reset 'h0;
                }
            }
            register ccf_Probe_T_sip3_main_Probe_Reserved_199 @0x360 {
                bytes 4;
                field ccf_Probe_T_sip3_main_Probe_Reserved_199 {
                    bits 32;
                    access rw;
                    hard_reset 'h0;
                }
            }
            register ccf_Probe_T_sip3_main_Probe_Reserved_200 @0x364 {
                bytes 4;
                field ccf_Probe_T_sip3_main_Probe_Reserved_200 {
                    bits 32;
                    access rw;
                    hard_reset 'h0;
                }
            }
            register ccf_Probe_T_sip3_main_Probe_Reserved_201 @0x368 {
                bytes 4;
                field ccf_Probe_T_sip3_main_Probe_Reserved_201 {
                    bits 32;
                    access rw;
                    hard_reset 'h0;
                }
            }
            register ccf_Probe_T_sip3_main_Probe_Reserved_202 @0x36C {
                bytes 4;
                field ccf_Probe_T_sip3_main_Probe_Reserved_202 {
                    bits 32;
                    access rw;
                    hard_reset 'h0;
                }
            }
            register ccf_Probe_T_sip3_main_Probe_Reserved_203 @0x370 {
                bytes 4;
                field ccf_Probe_T_sip3_main_Probe_Reserved_203 {
                    bits 32;
                    access rw;
                    hard_reset 'h0;
                }
            }
            register ccf_Probe_T_sip3_main_Probe_Reserved_204 @0x374 {
                bytes 4;
                field ccf_Probe_T_sip3_main_Probe_Reserved_204 {
                    bits 32;
                    access rw;
                    hard_reset 'h0;
                }
            }
            register ccf_Probe_T_sip3_main_Probe_Reserved_205 @0x378 {
                bytes 4;
                field ccf_Probe_T_sip3_main_Probe_Reserved_205 {
                    bits 32;
                    access rw;
                    hard_reset 'h0;
                }
            }
            register ccf_Probe_T_sip3_main_Probe_Reserved_206 @0x37C {
                bytes 4;
                field ccf_Probe_T_sip3_main_Probe_Reserved_206 {
                    bits 32;
                    access rw;
                    hard_reset 'h0;
                }
            }
            register ccf_Probe_T_sip3_main_Probe_Reserved_207 @0x380 {
                bytes 4;
                field ccf_Probe_T_sip3_main_Probe_Reserved_207 {
                    bits 32;
                    access rw;
                    hard_reset 'h0;
                }
            }
            register ccf_Probe_T_sip3_main_Probe_Reserved_208 @0x384 {
                bytes 4;
                field ccf_Probe_T_sip3_main_Probe_Reserved_208 {
                    bits 32;
                    access rw;
                    hard_reset 'h0;
                }
            }
            register ccf_Probe_T_sip3_main_Probe_Reserved_209 @0x388 {
                bytes 4;
                field ccf_Probe_T_sip3_main_Probe_Reserved_209 {
                    bits 32;
                    access rw;
                    hard_reset 'h0;
                }
            }
            register ccf_Probe_T_sip3_main_Probe_Reserved_210 @0x38C {
                bytes 4;
                field ccf_Probe_T_sip3_main_Probe_Reserved_210 {
                    bits 32;
                    access rw;
                    hard_reset 'h0;
                }
            }
            register ccf_Probe_T_sip3_main_Probe_Reserved_211 @0x390 {
                bytes 4;
                field ccf_Probe_T_sip3_main_Probe_Reserved_211 {
                    bits 32;
                    access rw;
                    hard_reset 'h0;
                }
            }
            register ccf_Probe_T_sip3_main_Probe_Reserved_212 @0x394 {
                bytes 4;
                field ccf_Probe_T_sip3_main_Probe_Reserved_212 {
                    bits 32;
                    access rw;
                    hard_reset 'h0;
                }
            }
            register ccf_Probe_T_sip3_main_Probe_Reserved_213 @0x398 {
                bytes 4;
                field ccf_Probe_T_sip3_main_Probe_Reserved_213 {
                    bits 32;
                    access rw;
                    hard_reset 'h0;
                }
            }
            register ccf_Probe_T_sip3_main_Probe_Reserved_214 @0x39C {
                bytes 4;
                field ccf_Probe_T_sip3_main_Probe_Reserved_214 {
                    bits 32;
                    access rw;
                    hard_reset 'h0;
                }
            }
            register ccf_Probe_T_sip3_main_Probe_Reserved_215 @0x3A0 {
                bytes 4;
                field ccf_Probe_T_sip3_main_Probe_Reserved_215 {
                    bits 32;
                    access rw;
                    hard_reset 'h0;
                }
            }
            register ccf_Probe_T_sip3_main_Probe_Reserved_216 @0x3A4 {
                bytes 4;
                field ccf_Probe_T_sip3_main_Probe_Reserved_216 {
                    bits 32;
                    access rw;
                    hard_reset 'h0;
                }
            }
            register ccf_Probe_T_sip3_main_Probe_Reserved_217 @0x3A8 {
                bytes 4;
                field ccf_Probe_T_sip3_main_Probe_Reserved_217 {
                    bits 32;
                    access rw;
                    hard_reset 'h0;
                }
            }
            register ccf_Probe_T_sip3_main_Probe_Reserved_218 @0x3AC {
                bytes 4;
                field ccf_Probe_T_sip3_main_Probe_Reserved_218 {
                    bits 32;
                    access rw;
                    hard_reset 'h0;
                }
            }
            register ccf_Probe_T_sip3_main_Probe_Reserved_219 @0x3B0 {
                bytes 4;
                field ccf_Probe_T_sip3_main_Probe_Reserved_219 {
                    bits 32;
                    access rw;
                    hard_reset 'h0;
                }
            }
            register ccf_Probe_T_sip3_main_Probe_Reserved_220 @0x3B4 {
                bytes 4;
                field ccf_Probe_T_sip3_main_Probe_Reserved_220 {
                    bits 32;
                    access rw;
                    hard_reset 'h0;
                }
            }
            register ccf_Probe_T_sip3_main_Probe_Reserved_221 @0x3B8 {
                bytes 4;
                field ccf_Probe_T_sip3_main_Probe_Reserved_221 {
                    bits 32;
                    access rw;
                    hard_reset 'h0;
                }
            }
            register ccf_Probe_T_sip3_main_Probe_Reserved_222 @0x3BC {
                bytes 4;
                field ccf_Probe_T_sip3_main_Probe_Reserved_222 {
                    bits 32;
                    access rw;
                    hard_reset 'h0;
                }
            }
            register ccf_Probe_T_sip3_main_Probe_Reserved_223 @0x3C0 {
                bytes 4;
                field ccf_Probe_T_sip3_main_Probe_Reserved_223 {
                    bits 32;
                    access rw;
                    hard_reset 'h0;
                }
            }
            register ccf_Probe_T_sip3_main_Probe_Reserved_224 @0x3C4 {
                bytes 4;
                field ccf_Probe_T_sip3_main_Probe_Reserved_224 {
                    bits 32;
                    access rw;
                    hard_reset 'h0;
                }
            }
            register ccf_Probe_T_sip3_main_Probe_Reserved_225 @0x3C8 {
                bytes 4;
                field ccf_Probe_T_sip3_main_Probe_Reserved_225 {
                    bits 32;
                    access rw;
                    hard_reset 'h0;
                }
            }
            register ccf_Probe_T_sip3_main_Probe_Reserved_226 @0x3CC {
                bytes 4;
                field ccf_Probe_T_sip3_main_Probe_Reserved_226 {
                    bits 32;
                    access rw;
                    hard_reset 'h0;
                }
            }
            register ccf_Probe_T_sip3_main_Probe_Reserved_227 @0x3D0 {
                bytes 4;
                field ccf_Probe_T_sip3_main_Probe_Reserved_227 {
                    bits 32;
                    access rw;
                    hard_reset 'h0;
                }
            }
            register ccf_Probe_T_sip3_main_Probe_Reserved_228 @0x3D4 {
                bytes 4;
                field ccf_Probe_T_sip3_main_Probe_Reserved_228 {
                    bits 32;
                    access rw;
                    hard_reset 'h0;
                }
            }
            register ccf_Probe_T_sip3_main_Probe_Reserved_229 @0x3D8 {
                bytes 4;
                field ccf_Probe_T_sip3_main_Probe_Reserved_229 {
                    bits 32;
                    access rw;
                    hard_reset 'h0;
                }
            }
            register ccf_Probe_T_sip3_main_Probe_Reserved_230 @0x3DC {
                bytes 4;
                field ccf_Probe_T_sip3_main_Probe_Reserved_230 {
                    bits 32;
                    access rw;
                    hard_reset 'h0;
                }
            }
            register ccf_Probe_T_sip3_main_Probe_Reserved_231 @0x3E0 {
                bytes 4;
                field ccf_Probe_T_sip3_main_Probe_Reserved_231 {
                    bits 32;
                    access rw;
                    hard_reset 'h0;
                }
            }
            register ccf_Probe_T_sip3_main_Probe_Reserved_232 @0x3E4 {
                bytes 4;
                field ccf_Probe_T_sip3_main_Probe_Reserved_232 {
                    bits 32;
                    access rw;
                    hard_reset 'h0;
                }
            }
            register ccf_Probe_T_sip3_main_Probe_Reserved_233 @0x3E8 {
                bytes 4;
                field ccf_Probe_T_sip3_main_Probe_Reserved_233 {
                    bits 32;
                    access rw;
                    hard_reset 'h0;
                }
            }
            register ccf_Probe_T_sip3_main_Probe_Reserved_234 @0x3EC {
                bytes 4;
                field ccf_Probe_T_sip3_main_Probe_Reserved_234 {
                    bits 32;
                    access rw;
                    hard_reset 'h0;
                }
            }
            register ccf_Probe_T_sip3_main_Probe_Reserved_235 @0x3F0 {
                bytes 4;
                field ccf_Probe_T_sip3_main_Probe_Reserved_235 {
                    bits 32;
                    access rw;
                    hard_reset 'h0;
                }
            }
            register ccf_Probe_T_sip3_main_Probe_Reserved_236 @0x3F4 {
                bytes 4;
                field ccf_Probe_T_sip3_main_Probe_Reserved_236 {
                    bits 32;
                    access rw;
                    hard_reset 'h0;
                }
            }
            register ccf_Probe_T_sip3_main_Probe_Reserved_237 @0x3F8 {
                bytes 4;
                field ccf_Probe_T_sip3_main_Probe_Reserved_237 {
                    bits 32;
                    access rw;
                    hard_reset 'h0;
                }
            }
            register ccf_Probe_T_sip3_main_Probe_Reserved_238 @0x3FC {
                bytes 4;
                field ccf_Probe_T_sip3_main_Probe_Reserved_238 {
                    bits 32;
                    access rw;
                    hard_reset 'h0;
                }
            }
        }
        block ecf_ccf_axi_ccf_Probe_T_sip4_main_Probe @0xDA000 {
            bytes 4;
            register ccf_Probe_T_sip4_main_Probe_Id_CoreId @0x0 {
                bytes 4;
                field CORETYPEID @'h0 {
                    bits 8;
                    access ro;
                    hard_reset 'h6;
                    doc {
                        Field identifying the type of IP.
                    }
                }
                field CORECHECKSUM @'h8 {
                    bits 24;
                    access ro;
                    hard_reset 'h809513;
                    doc {
                        Field containing a checksum of the parameters of the IP.
                    }
                }
            }
            register ccf_Probe_T_sip4_main_Probe_Id_RevisionId @0x4 {
                bytes 4;
                field USERID @'h0 {
                    bits 8;
                    access ro;
                    hard_reset 'h0;
                    doc {
                        Field containing a user defined value, not used anywhere inside the IP itself.
                    }
                }
                field FLEXNOCID @'h8 {
                    bits 24;
                    access ro;
                    hard_reset 'h84f8c6;
                    doc {
                        Field containing the build revision of the software used to generate the IP HDL code.
                    }
                }
            }
            register ccf_Probe_T_sip4_main_Probe_MainCtl @0x8 {
                bytes 4;
                field ERREN @'h0 {
                    access rw;
                    hard_reset 'h0;
                    doc {
                        Register field ErrEn enables the probe to send on the ObsTx output any packet with Error status, independently of filtering mechanisms, thus constituting a simple supplementary global filter.
                    }
                }
                field TRACEEN @'h1 {
                    access ro;
                    hard_reset 'h0;
                    doc {
                        Register field TraceEn enables the probe to send filtered packets (Trace) on the ObsTx observation output.
                    }
                }
                field PAYLOADEN @'h2 {
                    access rw;
                    hard_reset 'h0;
                    doc {
                        Register field PayloadEn, when set to 1, enables traces to contain headers and payload. When set ot 0, only headers are reported.
                    }
                }
                field STATEN @'h3 {
                    access rw;
                    hard_reset 'h0;
                    doc {
                        When set to 1, register field StatEn enables statistics profiling. The probe sendS statistics results to the output for signal ObsTx. All statistics counters are cleared when the StatEn bit goes from 0 to 1. When set to 0, counters are disabled.
                    }
                }
                field ALARMEN @'h4 {
                    access rw;
                    hard_reset 'h0;
                    doc {
                        When set, register field AlarmEn enables the probe to collect alarm-related information. When the register field bit is null, both TraceAlarm and StatAlarm outputs are driven to 0.
                    }
                }
                field STATCONDDUMP @'h5 {
                    access rw;
                    hard_reset 'h0;
                    doc {
                        When set, register field StatCondDump enables the dump of a statistics frame to the range of counter values set for registers StatAlarmMin, StatAlarmMax, and AlarmMode. This field also renders register StatAlarmStatus inoperative. When parameter statisticsCounterAlarm is set to False, the StatCondDump register bit is reserved.
                    }
                }
                field INTRUSIVEMODE @'h6 {
                    access ro;
                    hard_reset 'h0;
                    doc {
                        When set to 1, register field IntrusiveMode enables trace operation in Intrusive flow-control mode. When set to 0, the register  enables trace operation in Overflow flow-control mode
                    }
                }
                field FILTBYTEALWAYSCHAINABLEEN @'h7 {
                    access rw;
                    hard_reset 'h0;
                    doc {
                        When set to 0, filters are mapped to all statistic counters when counting bytes or enabled bytes. Therefore, only filter events mapped to even counters can be counted using a pair of chained counters.When set to 1, filters are mapped only to even statistic counters when counting bytes or enabled bytes. Thus events from any filter can be counted using a pair of chained counters.
                    }
                }
                doc {
                    Register MainCtl contains probe global control bits. The register has seven bit fields:Register MainCtl contains probe global control bits. The register has seven bit fields:
                }
            }
            register ccf_Probe_T_sip4_main_Probe_CfgCtl @0xC {
                bytes 4;
                field GLOBALEN @'h0 {
                    access rw;
                    hard_reset 'h0;
                }
                field ACTIVE @'h1 {
                    access ro;
                    hard_reset 'h0;
                }
            }
            register ccf_Probe_T_sip4_main_Probe_Reserved_00 @0x10 {
                bytes 4;
                field ccf_Probe_T_sip4_main_Probe_Reserved_00 {
                    bits 32;
                    access rw;
                    hard_reset 'h0;
                }
            }
            register ccf_Probe_T_sip4_main_Probe_Reserved_01 @0x14 {
                bytes 4;
                field ccf_Probe_T_sip4_main_Probe_Reserved_01 {
                    bits 32;
                    access rw;
                    hard_reset 'h0;
                }
            }
            register ccf_Probe_T_sip4_main_Probe_Reserved_02 @0x18 {
                bytes 4;
                field ccf_Probe_T_sip4_main_Probe_Reserved_02 {
                    bits 32;
                    access rw;
                    hard_reset 'h0;
                }
            }
            register ccf_Probe_T_sip4_main_Probe_Reserved_03 @0x1C {
                bytes 4;
                field ccf_Probe_T_sip4_main_Probe_Reserved_03 {
                    bits 32;
                    access rw;
                    hard_reset 'h0;
                }
            }
            register ccf_Probe_T_sip4_main_Probe_Reserved_04 @0x20 {
                bytes 4;
                field ccf_Probe_T_sip4_main_Probe_Reserved_04 {
                    bits 32;
                    access rw;
                    hard_reset 'h0;
                }
            }
            register ccf_Probe_T_sip4_main_Probe_StatPeriod @0x24 {
                bytes 4;
                field STATPERIOD @'h0 {
                    bits 5;
                    access rw;
                    hard_reset 'h0;
                    doc {
                        Register StatPeriod is a 5-bit register that sets a period, within a range of 2 cycles to 2 gigacycles, during which statistics are collected before being dumped automatically. Setting the register implicitly enables automatic mode operation for statistics collection. The period is calculated with the formula: N_Cycle = 2**StatPeriodWhen register StatPeriod is set to its default value 0, automatic dump mode is disabled, and register StatGo is activated for manual mode operation. Note: When parameter statisticsCollection is set to False, StatPeriod is reserved.
                    }
                }
            }
            register ccf_Probe_T_sip4_main_Probe_StatGo @0x28 {
                bytes 4;
                field STATGO @'h0 {
                    access w1c;
                    hard_reset 'h0;
                    doc {
                        Writing a 1 to the 1-bit pulse register StatGo generates a statistics dump.The register is active when statistics collection operates in manual mode, that is, when register StatPeriod is set to 0.NOTE  The written value is not stored in StatGo. A read always returns 0.
                    }
                }
            }
            register ccf_Probe_T_sip4_main_Probe_StatAlarmMin @0x2C {
                bytes 4;
                field STATALARMMIN @'h0 {
                    bits 22;
                    access rw;
                    hard_reset 'h0;
                    doc {
                        Register StatAlarmMin contains the minimum count value used in statistics alarm comparisons. The number of bits is equal to twice the value set forparameter wStatisticsCounter. When parameter statisticsCounterAlarm is set to False, StatAlarmMin is reserved.
                    }
                }
            }
            register ccf_Probe_T_sip4_main_Probe_StatAlarmMax @0x30 {
                bytes 4;
                field STATALARMMAX @'h0 {
                    bits 22;
                    access rw;
                    hard_reset 'h0;
                    doc {
                        Register StatAlarmMax contains the maximum count value used in statistics alarm comparisons.The number of bits is equal to twice the value set for parameter wStatisticsCounter. When parameter statisticsCounterAlarm is set to False, StatAlarmMax is reserved.
                    }
                }
            }
            register ccf_Probe_T_sip4_main_Probe_StatAlarmStatus @0x34 {
                bytes 4;
                field STATALARMSTATUS @'h0 {
                    access ro;
                    hard_reset 'h0;
                    doc {
                        Register StatAlarmStatus is a read-only 1-bit register indicating that at least one statistics counter has exceeded the programmed values for registers StatAlarmMin or StatAlarmMax. Output signal StatAlarm is equal to the values stored in register MainCtl fields StatAlarmStatus and AlarmEn. When parameter statisticsCounterAlarm is set to False, StatAlarmStatus is reserved.
                    }
                }
            }
            register ccf_Probe_T_sip4_main_Probe_StatAlarmClr @0x38 {
                bytes 4;
                field STATALARMCLR @'h0 {
                    access w1c;
                    hard_reset 'h0;
                    doc {
                        Register StatAlarmClr is a 1-bit register. Writing a 1 to this register clears the StatAlarmStatus register bit.When parameter statisticsCounterAlarm is set to False, StatAlarmClr is reserved.NOTE  The written value is not stored in StatAlarmClr. A read always returns 0.
                    }
                }
            }
            register ccf_Probe_T_sip4_main_Probe_StatAlarmEn @0x3C {
                bytes 4;
                field STATALARMEN @'h0 {
                    access rw;
                    hard_reset 'h1;
                    doc {
                        Register StatAlarmEn is a 1-bit register. When set to 0 it masks StatAlarm and CtiTrigOut(1) signal interrupts.
                    }
                }
            }
            register ccf_Probe_T_sip4_main_Probe_Reserved_05 @0x40 {
                bytes 4;
                field ccf_Probe_T_sip4_main_Probe_Reserved_05 {
                    bits 32;
                    access rw;
                    hard_reset 'h0;
                }
            }
            register ccf_Probe_T_sip4_main_Probe_Reserved_06 @0x44 {
                bytes 4;
                field ccf_Probe_T_sip4_main_Probe_Reserved_06 {
                    bits 32;
                    access rw;
                    hard_reset 'h0;
                }
            }
            register ccf_Probe_T_sip4_main_Probe_Reserved_07 @0x48 {
                bytes 4;
                field ccf_Probe_T_sip4_main_Probe_Reserved_07 {
                    bits 32;
                    access rw;
                    hard_reset 'h0;
                }
            }
            register ccf_Probe_T_sip4_main_Probe_Reserved_08 @0x4C {
                bytes 4;
                field ccf_Probe_T_sip4_main_Probe_Reserved_08 {
                    bits 32;
                    access rw;
                    hard_reset 'h0;
                }
            }
            register ccf_Probe_T_sip4_main_Probe_Reserved_09 @0x50 {
                bytes 4;
                field ccf_Probe_T_sip4_main_Probe_Reserved_09 {
                    bits 32;
                    access rw;
                    hard_reset 'h0;
                }
            }
            register ccf_Probe_T_sip4_main_Probe_Reserved_10 @0x54 {
                bytes 4;
                field ccf_Probe_T_sip4_main_Probe_Reserved_10 {
                    bits 32;
                    access rw;
                    hard_reset 'h0;
                }
            }
            register ccf_Probe_T_sip4_main_Probe_Reserved_11 @0x58 {
                bytes 4;
                field ccf_Probe_T_sip4_main_Probe_Reserved_11 {
                    bits 32;
                    access rw;
                    hard_reset 'h0;
                }
            }
            register ccf_Probe_T_sip4_main_Probe_Reserved_12 @0x5C {
                bytes 4;
                field ccf_Probe_T_sip4_main_Probe_Reserved_12 {
                    bits 32;
                    access rw;
                    hard_reset 'h0;
                }
            }
            register ccf_Probe_T_sip4_main_Probe_Reserved_13 @0x60 {
                bytes 4;
                field ccf_Probe_T_sip4_main_Probe_Reserved_13 {
                    bits 32;
                    access rw;
                    hard_reset 'h0;
                }
            }
            register ccf_Probe_T_sip4_main_Probe_Reserved_14 @0x64 {
                bytes 4;
                field ccf_Probe_T_sip4_main_Probe_Reserved_14 {
                    bits 32;
                    access rw;
                    hard_reset 'h0;
                }
            }
            register ccf_Probe_T_sip4_main_Probe_Reserved_15 @0x68 {
                bytes 4;
                field ccf_Probe_T_sip4_main_Probe_Reserved_15 {
                    bits 32;
                    access rw;
                    hard_reset 'h0;
                }
            }
            register ccf_Probe_T_sip4_main_Probe_Reserved_16 @0x6C {
                bytes 4;
                field ccf_Probe_T_sip4_main_Probe_Reserved_16 {
                    bits 32;
                    access rw;
                    hard_reset 'h0;
                }
            }
            register ccf_Probe_T_sip4_main_Probe_Reserved_17 @0x70 {
                bytes 4;
                field ccf_Probe_T_sip4_main_Probe_Reserved_17 {
                    bits 32;
                    access rw;
                    hard_reset 'h0;
                }
            }
            register ccf_Probe_T_sip4_main_Probe_Reserved_18 @0x74 {
                bytes 4;
                field ccf_Probe_T_sip4_main_Probe_Reserved_18 {
                    bits 32;
                    access rw;
                    hard_reset 'h0;
                }
            }
            register ccf_Probe_T_sip4_main_Probe_Reserved_19 @0x78 {
                bytes 4;
                field ccf_Probe_T_sip4_main_Probe_Reserved_19 {
                    bits 32;
                    access rw;
                    hard_reset 'h0;
                }
            }
            register ccf_Probe_T_sip4_main_Probe_Reserved_20 @0x7C {
                bytes 4;
                field ccf_Probe_T_sip4_main_Probe_Reserved_20 {
                    bits 32;
                    access rw;
                    hard_reset 'h0;
                }
            }
            register ccf_Probe_T_sip4_main_Probe_Reserved_21 @0x80 {
                bytes 4;
                field ccf_Probe_T_sip4_main_Probe_Reserved_21 {
                    bits 32;
                    access rw;
                    hard_reset 'h0;
                }
            }
            register ccf_Probe_T_sip4_main_Probe_Reserved_22 @0x84 {
                bytes 4;
                field ccf_Probe_T_sip4_main_Probe_Reserved_22 {
                    bits 32;
                    access rw;
                    hard_reset 'h0;
                }
            }
            register ccf_Probe_T_sip4_main_Probe_Reserved_23 @0x88 {
                bytes 4;
                field ccf_Probe_T_sip4_main_Probe_Reserved_23 {
                    bits 32;
                    access rw;
                    hard_reset 'h0;
                }
            }
            register ccf_Probe_T_sip4_main_Probe_Reserved_24 @0x8C {
                bytes 4;
                field ccf_Probe_T_sip4_main_Probe_Reserved_24 {
                    bits 32;
                    access rw;
                    hard_reset 'h0;
                }
            }
            register ccf_Probe_T_sip4_main_Probe_Reserved_25 @0x90 {
                bytes 4;
                field ccf_Probe_T_sip4_main_Probe_Reserved_25 {
                    bits 32;
                    access rw;
                    hard_reset 'h0;
                }
            }
            register ccf_Probe_T_sip4_main_Probe_Reserved_26 @0x94 {
                bytes 4;
                field ccf_Probe_T_sip4_main_Probe_Reserved_26 {
                    bits 32;
                    access rw;
                    hard_reset 'h0;
                }
            }
            register ccf_Probe_T_sip4_main_Probe_Reserved_27 @0x98 {
                bytes 4;
                field ccf_Probe_T_sip4_main_Probe_Reserved_27 {
                    bits 32;
                    access rw;
                    hard_reset 'h0;
                }
            }
            register ccf_Probe_T_sip4_main_Probe_Reserved_28 @0x9C {
                bytes 4;
                field ccf_Probe_T_sip4_main_Probe_Reserved_28 {
                    bits 32;
                    access rw;
                    hard_reset 'h0;
                }
            }
            register ccf_Probe_T_sip4_main_Probe_Reserved_29 @0xA0 {
                bytes 4;
                field ccf_Probe_T_sip4_main_Probe_Reserved_29 {
                    bits 32;
                    access rw;
                    hard_reset 'h0;
                }
            }
            register ccf_Probe_T_sip4_main_Probe_Reserved_30 @0xA4 {
                bytes 4;
                field ccf_Probe_T_sip4_main_Probe_Reserved_30 {
                    bits 32;
                    access rw;
                    hard_reset 'h0;
                }
            }
            register ccf_Probe_T_sip4_main_Probe_Reserved_31 @0xA8 {
                bytes 4;
                field ccf_Probe_T_sip4_main_Probe_Reserved_31 {
                    bits 32;
                    access rw;
                    hard_reset 'h0;
                }
            }
            register ccf_Probe_T_sip4_main_Probe_Reserved_32 @0xAC {
                bytes 4;
                field ccf_Probe_T_sip4_main_Probe_Reserved_32 {
                    bits 32;
                    access rw;
                    hard_reset 'h0;
                }
            }
            register ccf_Probe_T_sip4_main_Probe_Reserved_33 @0xB0 {
                bytes 4;
                field ccf_Probe_T_sip4_main_Probe_Reserved_33 {
                    bits 32;
                    access rw;
                    hard_reset 'h0;
                }
            }
            register ccf_Probe_T_sip4_main_Probe_Reserved_34 @0xB4 {
                bytes 4;
                field ccf_Probe_T_sip4_main_Probe_Reserved_34 {
                    bits 32;
                    access rw;
                    hard_reset 'h0;
                }
            }
            register ccf_Probe_T_sip4_main_Probe_Reserved_35 @0xB8 {
                bytes 4;
                field ccf_Probe_T_sip4_main_Probe_Reserved_35 {
                    bits 32;
                    access rw;
                    hard_reset 'h0;
                }
            }
            register ccf_Probe_T_sip4_main_Probe_Reserved_36 @0xBC {
                bytes 4;
                field ccf_Probe_T_sip4_main_Probe_Reserved_36 {
                    bits 32;
                    access rw;
                    hard_reset 'h0;
                }
            }
            register ccf_Probe_T_sip4_main_Probe_Reserved_37 @0xC0 {
                bytes 4;
                field ccf_Probe_T_sip4_main_Probe_Reserved_37 {
                    bits 32;
                    access rw;
                    hard_reset 'h0;
                }
            }
            register ccf_Probe_T_sip4_main_Probe_Reserved_38 @0xC4 {
                bytes 4;
                field ccf_Probe_T_sip4_main_Probe_Reserved_38 {
                    bits 32;
                    access rw;
                    hard_reset 'h0;
                }
            }
            register ccf_Probe_T_sip4_main_Probe_Reserved_39 @0xC8 {
                bytes 4;
                field ccf_Probe_T_sip4_main_Probe_Reserved_39 {
                    bits 32;
                    access rw;
                    hard_reset 'h0;
                }
            }
            register ccf_Probe_T_sip4_main_Probe_Reserved_40 @0xCC {
                bytes 4;
                field ccf_Probe_T_sip4_main_Probe_Reserved_40 {
                    bits 32;
                    access rw;
                    hard_reset 'h0;
                }
            }
            register ccf_Probe_T_sip4_main_Probe_Reserved_41 @0xD0 {
                bytes 4;
                field ccf_Probe_T_sip4_main_Probe_Reserved_41 {
                    bits 32;
                    access rw;
                    hard_reset 'h0;
                }
            }
            register ccf_Probe_T_sip4_main_Probe_Reserved_42 @0xD4 {
                bytes 4;
                field ccf_Probe_T_sip4_main_Probe_Reserved_42 {
                    bits 32;
                    access rw;
                    hard_reset 'h0;
                }
            }
            register ccf_Probe_T_sip4_main_Probe_Reserved_43 @0xD8 {
                bytes 4;
                field ccf_Probe_T_sip4_main_Probe_Reserved_43 {
                    bits 32;
                    access rw;
                    hard_reset 'h0;
                }
            }
            register ccf_Probe_T_sip4_main_Probe_Reserved_44 @0xDC {
                bytes 4;
                field ccf_Probe_T_sip4_main_Probe_Reserved_44 {
                    bits 32;
                    access rw;
                    hard_reset 'h0;
                }
            }
            register ccf_Probe_T_sip4_main_Probe_Reserved_45 @0xE0 {
                bytes 4;
                field ccf_Probe_T_sip4_main_Probe_Reserved_45 {
                    bits 32;
                    access rw;
                    hard_reset 'h0;
                }
            }
            register ccf_Probe_T_sip4_main_Probe_Reserved_46 @0xE4 {
                bytes 4;
                field ccf_Probe_T_sip4_main_Probe_Reserved_46 {
                    bits 32;
                    access rw;
                    hard_reset 'h0;
                }
            }
            register ccf_Probe_T_sip4_main_Probe_Reserved_47 @0xE8 {
                bytes 4;
                field ccf_Probe_T_sip4_main_Probe_Reserved_47 {
                    bits 32;
                    access rw;
                    hard_reset 'h0;
                }
            }
            register ccf_Probe_T_sip4_main_Probe_Reserved_48 @0xEC {
                bytes 4;
                field ccf_Probe_T_sip4_main_Probe_Reserved_48 {
                    bits 32;
                    access rw;
                    hard_reset 'h0;
                }
            }
            register ccf_Probe_T_sip4_main_Probe_Reserved_49 @0xF0 {
                bytes 4;
                field ccf_Probe_T_sip4_main_Probe_Reserved_49 {
                    bits 32;
                    access rw;
                    hard_reset 'h0;
                }
            }
            register ccf_Probe_T_sip4_main_Probe_Reserved_50 @0xF4 {
                bytes 4;
                field ccf_Probe_T_sip4_main_Probe_Reserved_50 {
                    bits 32;
                    access rw;
                    hard_reset 'h0;
                }
            }
            register ccf_Probe_T_sip4_main_Probe_Reserved_51 @0xF8 {
                bytes 4;
                field ccf_Probe_T_sip4_main_Probe_Reserved_51 {
                    bits 32;
                    access rw;
                    hard_reset 'h0;
                }
            }
            register ccf_Probe_T_sip4_main_Probe_Reserved_52 @0xFC {
                bytes 4;
                field ccf_Probe_T_sip4_main_Probe_Reserved_52 {
                    bits 32;
                    access rw;
                    hard_reset 'h0;
                }
            }
            register ccf_Probe_T_sip4_main_Probe_Reserved_53 @0x100 {
                bytes 4;
                field ccf_Probe_T_sip4_main_Probe_Reserved_53 {
                    bits 32;
                    access rw;
                    hard_reset 'h0;
                }
            }
            register ccf_Probe_T_sip4_main_Probe_Reserved_54 @0x104 {
                bytes 4;
                field ccf_Probe_T_sip4_main_Probe_Reserved_54 {
                    bits 32;
                    access rw;
                    hard_reset 'h0;
                }
            }
            register ccf_Probe_T_sip4_main_Probe_Reserved_55 @0x108 {
                bytes 4;
                field ccf_Probe_T_sip4_main_Probe_Reserved_55 {
                    bits 32;
                    access rw;
                    hard_reset 'h0;
                }
            }
            register ccf_Probe_T_sip4_main_Probe_Reserved_56 @0x10C {
                bytes 4;
                field ccf_Probe_T_sip4_main_Probe_Reserved_56 {
                    bits 32;
                    access rw;
                    hard_reset 'h0;
                }
            }
            register ccf_Probe_T_sip4_main_Probe_Reserved_57 @0x110 {
                bytes 4;
                field ccf_Probe_T_sip4_main_Probe_Reserved_57 {
                    bits 32;
                    access rw;
                    hard_reset 'h0;
                }
            }
            register ccf_Probe_T_sip4_main_Probe_Reserved_58 @0x114 {
                bytes 4;
                field ccf_Probe_T_sip4_main_Probe_Reserved_58 {
                    bits 32;
                    access rw;
                    hard_reset 'h0;
                }
            }
            register ccf_Probe_T_sip4_main_Probe_Reserved_59 @0x118 {
                bytes 4;
                field ccf_Probe_T_sip4_main_Probe_Reserved_59 {
                    bits 32;
                    access rw;
                    hard_reset 'h0;
                }
            }
            register ccf_Probe_T_sip4_main_Probe_Reserved_60 @0x11C {
                bytes 4;
                field ccf_Probe_T_sip4_main_Probe_Reserved_60 {
                    bits 32;
                    access rw;
                    hard_reset 'h0;
                }
            }
            register ccf_Probe_T_sip4_main_Probe_Reserved_61 @0x120 {
                bytes 4;
                field ccf_Probe_T_sip4_main_Probe_Reserved_61 {
                    bits 32;
                    access rw;
                    hard_reset 'h0;
                }
            }
            register ccf_Probe_T_sip4_main_Probe_Reserved_62 @0x124 {
                bytes 4;
                field ccf_Probe_T_sip4_main_Probe_Reserved_62 {
                    bits 32;
                    access rw;
                    hard_reset 'h0;
                }
            }
            register ccf_Probe_T_sip4_main_Probe_Reserved_63 @0x128 {
                bytes 4;
                field ccf_Probe_T_sip4_main_Probe_Reserved_63 {
                    bits 32;
                    access rw;
                    hard_reset 'h0;
                }
            }
            register ccf_Probe_T_sip4_main_Probe_Reserved_64 @0x12C {
                bytes 4;
                field ccf_Probe_T_sip4_main_Probe_Reserved_64 {
                    bits 32;
                    access rw;
                    hard_reset 'h0;
                }
            }
            register ccf_Probe_T_sip4_main_Probe_Reserved_65 @0x130 {
                bytes 4;
                field ccf_Probe_T_sip4_main_Probe_Reserved_65 {
                    bits 32;
                    access rw;
                    hard_reset 'h0;
                }
            }
            register ccf_Probe_T_sip4_main_Probe_Reserved_66 @0x134 {
                bytes 4;
                field ccf_Probe_T_sip4_main_Probe_Reserved_66 {
                    bits 32;
                    access rw;
                    hard_reset 'h0;
                }
            }
            register ccf_Probe_T_sip4_main_Probe_Counters_0_Src @0x138 {
                bytes 4;
                field INTEVENT @'h0 {
                    bits 5;
                    access rw;
                    hard_reset 'h0;
                    enum { OFF = 0, CYCLE = 1, IDLE = 2, XFER = 3, BUSY = 4, WAIT = 5, PKT = 6, LUT = 7, BYTE = 8, PRESS0 = 9, PRESS1 = 10, PRESS2 = 11, FILT0 = 12, FILT1 = 13, FILT2 = 14, FILT3 = 15, CHAIN = 16, LUT_BYTE_EN = 17, LUT_BYTE = 18, FILT_BYTE_EN = 19, FILT_BYTE = 20, PRESS3 = 21, PRESS4 = 22, PRESS5 = 23, PRESS6 = 24, RSV_0 = 25, RSV_1 = 26, RSV_2 = 27, RSV_3 = 28, RSV_4 = 29, RSV_5 = 30, RSV_6 = 31 };
                    doc {
                        Internal packet event
                    }
                }
                field EXTEVENT @'h5 {
                    access rw;
                    hard_reset 'h0;
                    doc {
                        When greater than 0, the entire register value is used to select an external hardware event source. The index of the external event is equal to {ExtEvent,IntEvent}.
                    }
                }
                doc {
                    Register CntSrc indicates the event source used to increment the counter. Unassigned values (non-existing Press level or ExtEvent index, or unimplemented Filter) are equivalent to OFF.
	Register CntSrc indicates the event source used to increment the counter. Unassigned values (non-existing Press level or ExtEvent index, or unimplemented Filter) are equivalent to OFF.
	
                }
            }
            register ccf_Probe_T_sip4_main_Probe_Counters_0_AlarmMode @0x13C {
                bytes 4;
                field COUNTERS_0_ALARMMODE @'h0 {
                    bits 2;
                    access rw;
                    hard_reset 'h0;
                    enum { OFF = 0, MIN = 1, MAX = 2, MIN_MAX = 3 };
                    doc {
                        Register AlarmMode is a 2-bit register that is present when parameter statisticsCounterAlarm is set to True. The register defines the statistics-alarm behavior of the counter.
                    }
                }
            }
            register ccf_Probe_T_sip4_main_Probe_Counters_0_Val @0x140 {
                bytes 4;
                field COUNTERS_0_VAL @'h0 {
                    bits 11;
                    access ro;
                    hard_reset 'h0;
                    doc {
                        Register Val is a read-only register that is always present. The register containsthe statistics counter value either pending StatAlarm output, or when statisticscollection is suspended subsequent to triggers or signal statSuspend.
                    }
                }
            }
            register ccf_Probe_T_sip4_main_Probe_Reserved_67 @0x144 {
                bytes 4;
                field ccf_Probe_T_sip4_main_Probe_Reserved_67 {
                    bits 32;
                    access rw;
                    hard_reset 'h0;
                }
            }
            register ccf_Probe_T_sip4_main_Probe_Reserved_68 @0x148 {
                bytes 4;
                field ccf_Probe_T_sip4_main_Probe_Reserved_68 {
                    bits 32;
                    access rw;
                    hard_reset 'h0;
                }
            }
            register ccf_Probe_T_sip4_main_Probe_Counters_1_Src @0x14C {
                bytes 4;
                field INTEVENT @'h0 {
                    bits 5;
                    access rw;
                    hard_reset 'h0;
                    enum { OFF = 0, CYCLE = 1, IDLE = 2, XFER = 3, BUSY = 4, WAIT = 5, PKT = 6, LUT = 7, BYTE = 8, PRESS0 = 9, PRESS1 = 10, PRESS2 = 11, FILT0 = 12, FILT1 = 13, FILT2 = 14, FILT3 = 15, CHAIN = 16, LUT_BYTE_EN = 17, LUT_BYTE = 18, FILT_BYTE_EN = 19, FILT_BYTE = 20, PRESS3 = 21, PRESS4 = 22, PRESS5 = 23, PRESS6 = 24, RSV_0 = 25, RSV_1 = 26, RSV_2 = 27, RSV_3 = 28, RSV_4 = 29, RSV_5 = 30, RSV_6 = 31 };
                    doc {
                        Internal packet event
                    }
                }
                field EXTEVENT @'h5 {
                    access rw;
                    hard_reset 'h0;
                    doc {
                        When greater than 0, the entire register value is used to select an external hardware event source. The index of the external event is equal to {ExtEvent,IntEvent}.
                    }
                }
                doc {
                    Register CntSrc indicates the event source used to increment the counter. Unassigned values (non-existing Press level or ExtEvent index, or unimplemented Filter) are equivalent to OFF.
	Register CntSrc indicates the event source used to increment the counter. Unassigned values (non-existing Press level or ExtEvent index, or unimplemented Filter) are equivalent to OFF.
	
                }
            }
            register ccf_Probe_T_sip4_main_Probe_Counters_1_AlarmMode @0x150 {
                bytes 4;
                field COUNTERS_1_ALARMMODE @'h0 {
                    bits 2;
                    access rw;
                    hard_reset 'h0;
                    enum { OFF = 0, MIN = 1, MAX = 2, MIN_MAX = 3 };
                    doc {
                        Register AlarmMode is a 2-bit register that is present when parameter statisticsCounterAlarm is set to True. The register defines the statistics-alarm behavior of the counter.
                    }
                }
            }
            register ccf_Probe_T_sip4_main_Probe_Counters_1_Val @0x154 {
                bytes 4;
                field COUNTERS_1_VAL @'h0 {
                    bits 11;
                    access ro;
                    hard_reset 'h0;
                    doc {
                        Register Val is a read-only register that is always present. The register containsthe statistics counter value either pending StatAlarm output, or when statisticscollection is suspended subsequent to triggers or signal statSuspend.
                    }
                }
            }
            register ccf_Probe_T_sip4_main_Probe_Reserved_69 @0x158 {
                bytes 4;
                field ccf_Probe_T_sip4_main_Probe_Reserved_69 {
                    bits 32;
                    access rw;
                    hard_reset 'h0;
                }
            }
            register ccf_Probe_T_sip4_main_Probe_Reserved_70 @0x15C {
                bytes 4;
                field ccf_Probe_T_sip4_main_Probe_Reserved_70 {
                    bits 32;
                    access rw;
                    hard_reset 'h0;
                }
            }
            register ccf_Probe_T_sip4_main_Probe_Reserved_71 @0x160 {
                bytes 4;
                field ccf_Probe_T_sip4_main_Probe_Reserved_71 {
                    bits 32;
                    access rw;
                    hard_reset 'h0;
                }
            }
            register ccf_Probe_T_sip4_main_Probe_Reserved_72 @0x164 {
                bytes 4;
                field ccf_Probe_T_sip4_main_Probe_Reserved_72 {
                    bits 32;
                    access rw;
                    hard_reset 'h0;
                }
            }
            register ccf_Probe_T_sip4_main_Probe_Reserved_73 @0x168 {
                bytes 4;
                field ccf_Probe_T_sip4_main_Probe_Reserved_73 {
                    bits 32;
                    access rw;
                    hard_reset 'h0;
                }
            }
            register ccf_Probe_T_sip4_main_Probe_Reserved_74 @0x16C {
                bytes 4;
                field ccf_Probe_T_sip4_main_Probe_Reserved_74 {
                    bits 32;
                    access rw;
                    hard_reset 'h0;
                }
            }
            register ccf_Probe_T_sip4_main_Probe_Reserved_75 @0x170 {
                bytes 4;
                field ccf_Probe_T_sip4_main_Probe_Reserved_75 {
                    bits 32;
                    access rw;
                    hard_reset 'h0;
                }
            }
            register ccf_Probe_T_sip4_main_Probe_Reserved_76 @0x174 {
                bytes 4;
                field ccf_Probe_T_sip4_main_Probe_Reserved_76 {
                    bits 32;
                    access rw;
                    hard_reset 'h0;
                }
            }
            register ccf_Probe_T_sip4_main_Probe_Reserved_77 @0x178 {
                bytes 4;
                field ccf_Probe_T_sip4_main_Probe_Reserved_77 {
                    bits 32;
                    access rw;
                    hard_reset 'h0;
                }
            }
            register ccf_Probe_T_sip4_main_Probe_Reserved_78 @0x17C {
                bytes 4;
                field ccf_Probe_T_sip4_main_Probe_Reserved_78 {
                    bits 32;
                    access rw;
                    hard_reset 'h0;
                }
            }
            register ccf_Probe_T_sip4_main_Probe_Reserved_79 @0x180 {
                bytes 4;
                field ccf_Probe_T_sip4_main_Probe_Reserved_79 {
                    bits 32;
                    access rw;
                    hard_reset 'h0;
                }
            }
            register ccf_Probe_T_sip4_main_Probe_Reserved_80 @0x184 {
                bytes 4;
                field ccf_Probe_T_sip4_main_Probe_Reserved_80 {
                    bits 32;
                    access rw;
                    hard_reset 'h0;
                }
            }
            register ccf_Probe_T_sip4_main_Probe_Reserved_81 @0x188 {
                bytes 4;
                field ccf_Probe_T_sip4_main_Probe_Reserved_81 {
                    bits 32;
                    access rw;
                    hard_reset 'h0;
                }
            }
            register ccf_Probe_T_sip4_main_Probe_Reserved_82 @0x18C {
                bytes 4;
                field ccf_Probe_T_sip4_main_Probe_Reserved_82 {
                    bits 32;
                    access rw;
                    hard_reset 'h0;
                }
            }
            register ccf_Probe_T_sip4_main_Probe_Reserved_83 @0x190 {
                bytes 4;
                field ccf_Probe_T_sip4_main_Probe_Reserved_83 {
                    bits 32;
                    access rw;
                    hard_reset 'h0;
                }
            }
            register ccf_Probe_T_sip4_main_Probe_Reserved_84 @0x194 {
                bytes 4;
                field ccf_Probe_T_sip4_main_Probe_Reserved_84 {
                    bits 32;
                    access rw;
                    hard_reset 'h0;
                }
            }
            register ccf_Probe_T_sip4_main_Probe_Reserved_85 @0x198 {
                bytes 4;
                field ccf_Probe_T_sip4_main_Probe_Reserved_85 {
                    bits 32;
                    access rw;
                    hard_reset 'h0;
                }
            }
            register ccf_Probe_T_sip4_main_Probe_Reserved_86 @0x19C {
                bytes 4;
                field ccf_Probe_T_sip4_main_Probe_Reserved_86 {
                    bits 32;
                    access rw;
                    hard_reset 'h0;
                }
            }
            register ccf_Probe_T_sip4_main_Probe_Reserved_87 @0x1A0 {
                bytes 4;
                field ccf_Probe_T_sip4_main_Probe_Reserved_87 {
                    bits 32;
                    access rw;
                    hard_reset 'h0;
                }
            }
            register ccf_Probe_T_sip4_main_Probe_Reserved_88 @0x1A4 {
                bytes 4;
                field ccf_Probe_T_sip4_main_Probe_Reserved_88 {
                    bits 32;
                    access rw;
                    hard_reset 'h0;
                }
            }
            register ccf_Probe_T_sip4_main_Probe_Reserved_89 @0x1A8 {
                bytes 4;
                field ccf_Probe_T_sip4_main_Probe_Reserved_89 {
                    bits 32;
                    access rw;
                    hard_reset 'h0;
                }
            }
            register ccf_Probe_T_sip4_main_Probe_Reserved_90 @0x1AC {
                bytes 4;
                field ccf_Probe_T_sip4_main_Probe_Reserved_90 {
                    bits 32;
                    access rw;
                    hard_reset 'h0;
                }
            }
            register ccf_Probe_T_sip4_main_Probe_Reserved_91 @0x1B0 {
                bytes 4;
                field ccf_Probe_T_sip4_main_Probe_Reserved_91 {
                    bits 32;
                    access rw;
                    hard_reset 'h0;
                }
            }
            register ccf_Probe_T_sip4_main_Probe_Reserved_92 @0x1B4 {
                bytes 4;
                field ccf_Probe_T_sip4_main_Probe_Reserved_92 {
                    bits 32;
                    access rw;
                    hard_reset 'h0;
                }
            }
            register ccf_Probe_T_sip4_main_Probe_Reserved_93 @0x1B8 {
                bytes 4;
                field ccf_Probe_T_sip4_main_Probe_Reserved_93 {
                    bits 32;
                    access rw;
                    hard_reset 'h0;
                }
            }
            register ccf_Probe_T_sip4_main_Probe_Reserved_94 @0x1BC {
                bytes 4;
                field ccf_Probe_T_sip4_main_Probe_Reserved_94 {
                    bits 32;
                    access rw;
                    hard_reset 'h0;
                }
            }
            register ccf_Probe_T_sip4_main_Probe_Reserved_95 @0x1C0 {
                bytes 4;
                field ccf_Probe_T_sip4_main_Probe_Reserved_95 {
                    bits 32;
                    access rw;
                    hard_reset 'h0;
                }
            }
            register ccf_Probe_T_sip4_main_Probe_Reserved_96 @0x1C4 {
                bytes 4;
                field ccf_Probe_T_sip4_main_Probe_Reserved_96 {
                    bits 32;
                    access rw;
                    hard_reset 'h0;
                }
            }
            register ccf_Probe_T_sip4_main_Probe_Reserved_97 @0x1C8 {
                bytes 4;
                field ccf_Probe_T_sip4_main_Probe_Reserved_97 {
                    bits 32;
                    access rw;
                    hard_reset 'h0;
                }
            }
            register ccf_Probe_T_sip4_main_Probe_Reserved_98 @0x1CC {
                bytes 4;
                field ccf_Probe_T_sip4_main_Probe_Reserved_98 {
                    bits 32;
                    access rw;
                    hard_reset 'h0;
                }
            }
            register ccf_Probe_T_sip4_main_Probe_Reserved_99 @0x1D0 {
                bytes 4;
                field ccf_Probe_T_sip4_main_Probe_Reserved_99 {
                    bits 32;
                    access rw;
                    hard_reset 'h0;
                }
            }
            register ccf_Probe_T_sip4_main_Probe_Reserved_100 @0x1D4 {
                bytes 4;
                field ccf_Probe_T_sip4_main_Probe_Reserved_100 {
                    bits 32;
                    access rw;
                    hard_reset 'h0;
                }
            }
            register ccf_Probe_T_sip4_main_Probe_Reserved_101 @0x1D8 {
                bytes 4;
                field ccf_Probe_T_sip4_main_Probe_Reserved_101 {
                    bits 32;
                    access rw;
                    hard_reset 'h0;
                }
            }
            register ccf_Probe_T_sip4_main_Probe_Reserved_102 @0x1DC {
                bytes 4;
                field ccf_Probe_T_sip4_main_Probe_Reserved_102 {
                    bits 32;
                    access rw;
                    hard_reset 'h0;
                }
            }
            register ccf_Probe_T_sip4_main_Probe_Reserved_103 @0x1E0 {
                bytes 4;
                field ccf_Probe_T_sip4_main_Probe_Reserved_103 {
                    bits 32;
                    access rw;
                    hard_reset 'h0;
                }
            }
            register ccf_Probe_T_sip4_main_Probe_Reserved_104 @0x1E4 {
                bytes 4;
                field ccf_Probe_T_sip4_main_Probe_Reserved_104 {
                    bits 32;
                    access rw;
                    hard_reset 'h0;
                }
            }
            register ccf_Probe_T_sip4_main_Probe_Reserved_105 @0x1E8 {
                bytes 4;
                field ccf_Probe_T_sip4_main_Probe_Reserved_105 {
                    bits 32;
                    access rw;
                    hard_reset 'h0;
                }
            }
            register ccf_Probe_T_sip4_main_Probe_Reserved_106 @0x1EC {
                bytes 4;
                field ccf_Probe_T_sip4_main_Probe_Reserved_106 {
                    bits 32;
                    access rw;
                    hard_reset 'h0;
                }
            }
            register ccf_Probe_T_sip4_main_Probe_Reserved_107 @0x1F0 {
                bytes 4;
                field ccf_Probe_T_sip4_main_Probe_Reserved_107 {
                    bits 32;
                    access rw;
                    hard_reset 'h0;
                }
            }
            register ccf_Probe_T_sip4_main_Probe_Reserved_108 @0x1F4 {
                bytes 4;
                field ccf_Probe_T_sip4_main_Probe_Reserved_108 {
                    bits 32;
                    access rw;
                    hard_reset 'h0;
                }
            }
            register ccf_Probe_T_sip4_main_Probe_Reserved_109 @0x1F8 {
                bytes 4;
                field ccf_Probe_T_sip4_main_Probe_Reserved_109 {
                    bits 32;
                    access rw;
                    hard_reset 'h0;
                }
            }
            register ccf_Probe_T_sip4_main_Probe_Reserved_110 @0x1FC {
                bytes 4;
                field ccf_Probe_T_sip4_main_Probe_Reserved_110 {
                    bits 32;
                    access rw;
                    hard_reset 'h0;
                }
            }
            register ccf_Probe_T_sip4_main_Probe_Reserved_111 @0x200 {
                bytes 4;
                field ccf_Probe_T_sip4_main_Probe_Reserved_111 {
                    bits 32;
                    access rw;
                    hard_reset 'h0;
                }
            }
            register ccf_Probe_T_sip4_main_Probe_Reserved_112 @0x204 {
                bytes 4;
                field ccf_Probe_T_sip4_main_Probe_Reserved_112 {
                    bits 32;
                    access rw;
                    hard_reset 'h0;
                }
            }
            register ccf_Probe_T_sip4_main_Probe_Reserved_113 @0x208 {
                bytes 4;
                field ccf_Probe_T_sip4_main_Probe_Reserved_113 {
                    bits 32;
                    access rw;
                    hard_reset 'h0;
                }
            }
            register ccf_Probe_T_sip4_main_Probe_Reserved_114 @0x20C {
                bytes 4;
                field ccf_Probe_T_sip4_main_Probe_Reserved_114 {
                    bits 32;
                    access rw;
                    hard_reset 'h0;
                }
            }
            register ccf_Probe_T_sip4_main_Probe_Reserved_115 @0x210 {
                bytes 4;
                field ccf_Probe_T_sip4_main_Probe_Reserved_115 {
                    bits 32;
                    access rw;
                    hard_reset 'h0;
                }
            }
            register ccf_Probe_T_sip4_main_Probe_Reserved_116 @0x214 {
                bytes 4;
                field ccf_Probe_T_sip4_main_Probe_Reserved_116 {
                    bits 32;
                    access rw;
                    hard_reset 'h0;
                }
            }
            register ccf_Probe_T_sip4_main_Probe_Reserved_117 @0x218 {
                bytes 4;
                field ccf_Probe_T_sip4_main_Probe_Reserved_117 {
                    bits 32;
                    access rw;
                    hard_reset 'h0;
                }
            }
            register ccf_Probe_T_sip4_main_Probe_Reserved_118 @0x21C {
                bytes 4;
                field ccf_Probe_T_sip4_main_Probe_Reserved_118 {
                    bits 32;
                    access rw;
                    hard_reset 'h0;
                }
            }
            register ccf_Probe_T_sip4_main_Probe_Reserved_119 @0x220 {
                bytes 4;
                field ccf_Probe_T_sip4_main_Probe_Reserved_119 {
                    bits 32;
                    access rw;
                    hard_reset 'h0;
                }
            }
            register ccf_Probe_T_sip4_main_Probe_Reserved_120 @0x224 {
                bytes 4;
                field ccf_Probe_T_sip4_main_Probe_Reserved_120 {
                    bits 32;
                    access rw;
                    hard_reset 'h0;
                }
            }
            register ccf_Probe_T_sip4_main_Probe_Reserved_121 @0x228 {
                bytes 4;
                field ccf_Probe_T_sip4_main_Probe_Reserved_121 {
                    bits 32;
                    access rw;
                    hard_reset 'h0;
                }
            }
            register ccf_Probe_T_sip4_main_Probe_Reserved_122 @0x22C {
                bytes 4;
                field ccf_Probe_T_sip4_main_Probe_Reserved_122 {
                    bits 32;
                    access rw;
                    hard_reset 'h0;
                }
            }
            register ccf_Probe_T_sip4_main_Probe_Reserved_123 @0x230 {
                bytes 4;
                field ccf_Probe_T_sip4_main_Probe_Reserved_123 {
                    bits 32;
                    access rw;
                    hard_reset 'h0;
                }
            }
            register ccf_Probe_T_sip4_main_Probe_Reserved_124 @0x234 {
                bytes 4;
                field ccf_Probe_T_sip4_main_Probe_Reserved_124 {
                    bits 32;
                    access rw;
                    hard_reset 'h0;
                }
            }
            register ccf_Probe_T_sip4_main_Probe_Reserved_125 @0x238 {
                bytes 4;
                field ccf_Probe_T_sip4_main_Probe_Reserved_125 {
                    bits 32;
                    access rw;
                    hard_reset 'h0;
                }
            }
            register ccf_Probe_T_sip4_main_Probe_Reserved_126 @0x23C {
                bytes 4;
                field ccf_Probe_T_sip4_main_Probe_Reserved_126 {
                    bits 32;
                    access rw;
                    hard_reset 'h0;
                }
            }
            register ccf_Probe_T_sip4_main_Probe_Reserved_127 @0x240 {
                bytes 4;
                field ccf_Probe_T_sip4_main_Probe_Reserved_127 {
                    bits 32;
                    access rw;
                    hard_reset 'h0;
                }
            }
            register ccf_Probe_T_sip4_main_Probe_Reserved_128 @0x244 {
                bytes 4;
                field ccf_Probe_T_sip4_main_Probe_Reserved_128 {
                    bits 32;
                    access rw;
                    hard_reset 'h0;
                }
            }
            register ccf_Probe_T_sip4_main_Probe_Reserved_129 @0x248 {
                bytes 4;
                field ccf_Probe_T_sip4_main_Probe_Reserved_129 {
                    bits 32;
                    access rw;
                    hard_reset 'h0;
                }
            }
            register ccf_Probe_T_sip4_main_Probe_Reserved_130 @0x24C {
                bytes 4;
                field ccf_Probe_T_sip4_main_Probe_Reserved_130 {
                    bits 32;
                    access rw;
                    hard_reset 'h0;
                }
            }
            register ccf_Probe_T_sip4_main_Probe_Reserved_131 @0x250 {
                bytes 4;
                field ccf_Probe_T_sip4_main_Probe_Reserved_131 {
                    bits 32;
                    access rw;
                    hard_reset 'h0;
                }
            }
            register ccf_Probe_T_sip4_main_Probe_Reserved_132 @0x254 {
                bytes 4;
                field ccf_Probe_T_sip4_main_Probe_Reserved_132 {
                    bits 32;
                    access rw;
                    hard_reset 'h0;
                }
            }
            register ccf_Probe_T_sip4_main_Probe_Reserved_133 @0x258 {
                bytes 4;
                field ccf_Probe_T_sip4_main_Probe_Reserved_133 {
                    bits 32;
                    access rw;
                    hard_reset 'h0;
                }
            }
            register ccf_Probe_T_sip4_main_Probe_Reserved_134 @0x25C {
                bytes 4;
                field ccf_Probe_T_sip4_main_Probe_Reserved_134 {
                    bits 32;
                    access rw;
                    hard_reset 'h0;
                }
            }
            register ccf_Probe_T_sip4_main_Probe_Reserved_135 @0x260 {
                bytes 4;
                field ccf_Probe_T_sip4_main_Probe_Reserved_135 {
                    bits 32;
                    access rw;
                    hard_reset 'h0;
                }
            }
            register ccf_Probe_T_sip4_main_Probe_Reserved_136 @0x264 {
                bytes 4;
                field ccf_Probe_T_sip4_main_Probe_Reserved_136 {
                    bits 32;
                    access rw;
                    hard_reset 'h0;
                }
            }
            register ccf_Probe_T_sip4_main_Probe_Reserved_137 @0x268 {
                bytes 4;
                field ccf_Probe_T_sip4_main_Probe_Reserved_137 {
                    bits 32;
                    access rw;
                    hard_reset 'h0;
                }
            }
            register ccf_Probe_T_sip4_main_Probe_Reserved_138 @0x26C {
                bytes 4;
                field ccf_Probe_T_sip4_main_Probe_Reserved_138 {
                    bits 32;
                    access rw;
                    hard_reset 'h0;
                }
            }
            register ccf_Probe_T_sip4_main_Probe_Reserved_139 @0x270 {
                bytes 4;
                field ccf_Probe_T_sip4_main_Probe_Reserved_139 {
                    bits 32;
                    access rw;
                    hard_reset 'h0;
                }
            }
            register ccf_Probe_T_sip4_main_Probe_Reserved_140 @0x274 {
                bytes 4;
                field ccf_Probe_T_sip4_main_Probe_Reserved_140 {
                    bits 32;
                    access rw;
                    hard_reset 'h0;
                }
            }
            register ccf_Probe_T_sip4_main_Probe_Reserved_141 @0x278 {
                bytes 4;
                field ccf_Probe_T_sip4_main_Probe_Reserved_141 {
                    bits 32;
                    access rw;
                    hard_reset 'h0;
                }
            }
            register ccf_Probe_T_sip4_main_Probe_Reserved_142 @0x27C {
                bytes 4;
                field ccf_Probe_T_sip4_main_Probe_Reserved_142 {
                    bits 32;
                    access rw;
                    hard_reset 'h0;
                }
            }
            register ccf_Probe_T_sip4_main_Probe_Reserved_143 @0x280 {
                bytes 4;
                field ccf_Probe_T_sip4_main_Probe_Reserved_143 {
                    bits 32;
                    access rw;
                    hard_reset 'h0;
                }
            }
            register ccf_Probe_T_sip4_main_Probe_Reserved_144 @0x284 {
                bytes 4;
                field ccf_Probe_T_sip4_main_Probe_Reserved_144 {
                    bits 32;
                    access rw;
                    hard_reset 'h0;
                }
            }
            register ccf_Probe_T_sip4_main_Probe_Reserved_145 @0x288 {
                bytes 4;
                field ccf_Probe_T_sip4_main_Probe_Reserved_145 {
                    bits 32;
                    access rw;
                    hard_reset 'h0;
                }
            }
            register ccf_Probe_T_sip4_main_Probe_Reserved_146 @0x28C {
                bytes 4;
                field ccf_Probe_T_sip4_main_Probe_Reserved_146 {
                    bits 32;
                    access rw;
                    hard_reset 'h0;
                }
            }
            register ccf_Probe_T_sip4_main_Probe_Reserved_147 @0x290 {
                bytes 4;
                field ccf_Probe_T_sip4_main_Probe_Reserved_147 {
                    bits 32;
                    access rw;
                    hard_reset 'h0;
                }
            }
            register ccf_Probe_T_sip4_main_Probe_Reserved_148 @0x294 {
                bytes 4;
                field ccf_Probe_T_sip4_main_Probe_Reserved_148 {
                    bits 32;
                    access rw;
                    hard_reset 'h0;
                }
            }
            register ccf_Probe_T_sip4_main_Probe_Reserved_149 @0x298 {
                bytes 4;
                field ccf_Probe_T_sip4_main_Probe_Reserved_149 {
                    bits 32;
                    access rw;
                    hard_reset 'h0;
                }
            }
            register ccf_Probe_T_sip4_main_Probe_Reserved_150 @0x29C {
                bytes 4;
                field ccf_Probe_T_sip4_main_Probe_Reserved_150 {
                    bits 32;
                    access rw;
                    hard_reset 'h0;
                }
            }
            register ccf_Probe_T_sip4_main_Probe_Reserved_151 @0x2A0 {
                bytes 4;
                field ccf_Probe_T_sip4_main_Probe_Reserved_151 {
                    bits 32;
                    access rw;
                    hard_reset 'h0;
                }
            }
            register ccf_Probe_T_sip4_main_Probe_Reserved_152 @0x2A4 {
                bytes 4;
                field ccf_Probe_T_sip4_main_Probe_Reserved_152 {
                    bits 32;
                    access rw;
                    hard_reset 'h0;
                }
            }
            register ccf_Probe_T_sip4_main_Probe_Reserved_153 @0x2A8 {
                bytes 4;
                field ccf_Probe_T_sip4_main_Probe_Reserved_153 {
                    bits 32;
                    access rw;
                    hard_reset 'h0;
                }
            }
            register ccf_Probe_T_sip4_main_Probe_Reserved_154 @0x2AC {
                bytes 4;
                field ccf_Probe_T_sip4_main_Probe_Reserved_154 {
                    bits 32;
                    access rw;
                    hard_reset 'h0;
                }
            }
            register ccf_Probe_T_sip4_main_Probe_Reserved_155 @0x2B0 {
                bytes 4;
                field ccf_Probe_T_sip4_main_Probe_Reserved_155 {
                    bits 32;
                    access rw;
                    hard_reset 'h0;
                }
            }
            register ccf_Probe_T_sip4_main_Probe_Reserved_156 @0x2B4 {
                bytes 4;
                field ccf_Probe_T_sip4_main_Probe_Reserved_156 {
                    bits 32;
                    access rw;
                    hard_reset 'h0;
                }
            }
            register ccf_Probe_T_sip4_main_Probe_Reserved_157 @0x2B8 {
                bytes 4;
                field ccf_Probe_T_sip4_main_Probe_Reserved_157 {
                    bits 32;
                    access rw;
                    hard_reset 'h0;
                }
            }
            register ccf_Probe_T_sip4_main_Probe_Reserved_158 @0x2BC {
                bytes 4;
                field ccf_Probe_T_sip4_main_Probe_Reserved_158 {
                    bits 32;
                    access rw;
                    hard_reset 'h0;
                }
            }
            register ccf_Probe_T_sip4_main_Probe_Reserved_159 @0x2C0 {
                bytes 4;
                field ccf_Probe_T_sip4_main_Probe_Reserved_159 {
                    bits 32;
                    access rw;
                    hard_reset 'h0;
                }
            }
            register ccf_Probe_T_sip4_main_Probe_Reserved_160 @0x2C4 {
                bytes 4;
                field ccf_Probe_T_sip4_main_Probe_Reserved_160 {
                    bits 32;
                    access rw;
                    hard_reset 'h0;
                }
            }
            register ccf_Probe_T_sip4_main_Probe_Reserved_161 @0x2C8 {
                bytes 4;
                field ccf_Probe_T_sip4_main_Probe_Reserved_161 {
                    bits 32;
                    access rw;
                    hard_reset 'h0;
                }
            }
            register ccf_Probe_T_sip4_main_Probe_Reserved_162 @0x2CC {
                bytes 4;
                field ccf_Probe_T_sip4_main_Probe_Reserved_162 {
                    bits 32;
                    access rw;
                    hard_reset 'h0;
                }
            }
            register ccf_Probe_T_sip4_main_Probe_Reserved_163 @0x2D0 {
                bytes 4;
                field ccf_Probe_T_sip4_main_Probe_Reserved_163 {
                    bits 32;
                    access rw;
                    hard_reset 'h0;
                }
            }
            register ccf_Probe_T_sip4_main_Probe_Reserved_164 @0x2D4 {
                bytes 4;
                field ccf_Probe_T_sip4_main_Probe_Reserved_164 {
                    bits 32;
                    access rw;
                    hard_reset 'h0;
                }
            }
            register ccf_Probe_T_sip4_main_Probe_Reserved_165 @0x2D8 {
                bytes 4;
                field ccf_Probe_T_sip4_main_Probe_Reserved_165 {
                    bits 32;
                    access rw;
                    hard_reset 'h0;
                }
            }
            register ccf_Probe_T_sip4_main_Probe_Reserved_166 @0x2DC {
                bytes 4;
                field ccf_Probe_T_sip4_main_Probe_Reserved_166 {
                    bits 32;
                    access rw;
                    hard_reset 'h0;
                }
            }
            register ccf_Probe_T_sip4_main_Probe_Reserved_167 @0x2E0 {
                bytes 4;
                field ccf_Probe_T_sip4_main_Probe_Reserved_167 {
                    bits 32;
                    access rw;
                    hard_reset 'h0;
                }
            }
            register ccf_Probe_T_sip4_main_Probe_Reserved_168 @0x2E4 {
                bytes 4;
                field ccf_Probe_T_sip4_main_Probe_Reserved_168 {
                    bits 32;
                    access rw;
                    hard_reset 'h0;
                }
            }
            register ccf_Probe_T_sip4_main_Probe_Reserved_169 @0x2E8 {
                bytes 4;
                field ccf_Probe_T_sip4_main_Probe_Reserved_169 {
                    bits 32;
                    access rw;
                    hard_reset 'h0;
                }
            }
            register ccf_Probe_T_sip4_main_Probe_Reserved_170 @0x2EC {
                bytes 4;
                field ccf_Probe_T_sip4_main_Probe_Reserved_170 {
                    bits 32;
                    access rw;
                    hard_reset 'h0;
                }
            }
            register ccf_Probe_T_sip4_main_Probe_Reserved_171 @0x2F0 {
                bytes 4;
                field ccf_Probe_T_sip4_main_Probe_Reserved_171 {
                    bits 32;
                    access rw;
                    hard_reset 'h0;
                }
            }
            register ccf_Probe_T_sip4_main_Probe_Reserved_172 @0x2F4 {
                bytes 4;
                field ccf_Probe_T_sip4_main_Probe_Reserved_172 {
                    bits 32;
                    access rw;
                    hard_reset 'h0;
                }
            }
            register ccf_Probe_T_sip4_main_Probe_Reserved_173 @0x2F8 {
                bytes 4;
                field ccf_Probe_T_sip4_main_Probe_Reserved_173 {
                    bits 32;
                    access rw;
                    hard_reset 'h0;
                }
            }
            register ccf_Probe_T_sip4_main_Probe_Reserved_174 @0x2FC {
                bytes 4;
                field ccf_Probe_T_sip4_main_Probe_Reserved_174 {
                    bits 32;
                    access rw;
                    hard_reset 'h0;
                }
            }
            register ccf_Probe_T_sip4_main_Probe_Reserved_175 @0x300 {
                bytes 4;
                field ccf_Probe_T_sip4_main_Probe_Reserved_175 {
                    bits 32;
                    access rw;
                    hard_reset 'h0;
                }
            }
            register ccf_Probe_T_sip4_main_Probe_Reserved_176 @0x304 {
                bytes 4;
                field ccf_Probe_T_sip4_main_Probe_Reserved_176 {
                    bits 32;
                    access rw;
                    hard_reset 'h0;
                }
            }
            register ccf_Probe_T_sip4_main_Probe_Reserved_177 @0x308 {
                bytes 4;
                field ccf_Probe_T_sip4_main_Probe_Reserved_177 {
                    bits 32;
                    access rw;
                    hard_reset 'h0;
                }
            }
            register ccf_Probe_T_sip4_main_Probe_Reserved_178 @0x30C {
                bytes 4;
                field ccf_Probe_T_sip4_main_Probe_Reserved_178 {
                    bits 32;
                    access rw;
                    hard_reset 'h0;
                }
            }
            register ccf_Probe_T_sip4_main_Probe_Reserved_179 @0x310 {
                bytes 4;
                field ccf_Probe_T_sip4_main_Probe_Reserved_179 {
                    bits 32;
                    access rw;
                    hard_reset 'h0;
                }
            }
            register ccf_Probe_T_sip4_main_Probe_Reserved_180 @0x314 {
                bytes 4;
                field ccf_Probe_T_sip4_main_Probe_Reserved_180 {
                    bits 32;
                    access rw;
                    hard_reset 'h0;
                }
            }
            register ccf_Probe_T_sip4_main_Probe_Reserved_181 @0x318 {
                bytes 4;
                field ccf_Probe_T_sip4_main_Probe_Reserved_181 {
                    bits 32;
                    access rw;
                    hard_reset 'h0;
                }
            }
            register ccf_Probe_T_sip4_main_Probe_Reserved_182 @0x31C {
                bytes 4;
                field ccf_Probe_T_sip4_main_Probe_Reserved_182 {
                    bits 32;
                    access rw;
                    hard_reset 'h0;
                }
            }
            register ccf_Probe_T_sip4_main_Probe_Reserved_183 @0x320 {
                bytes 4;
                field ccf_Probe_T_sip4_main_Probe_Reserved_183 {
                    bits 32;
                    access rw;
                    hard_reset 'h0;
                }
            }
            register ccf_Probe_T_sip4_main_Probe_Reserved_184 @0x324 {
                bytes 4;
                field ccf_Probe_T_sip4_main_Probe_Reserved_184 {
                    bits 32;
                    access rw;
                    hard_reset 'h0;
                }
            }
            register ccf_Probe_T_sip4_main_Probe_Reserved_185 @0x328 {
                bytes 4;
                field ccf_Probe_T_sip4_main_Probe_Reserved_185 {
                    bits 32;
                    access rw;
                    hard_reset 'h0;
                }
            }
            register ccf_Probe_T_sip4_main_Probe_Reserved_186 @0x32C {
                bytes 4;
                field ccf_Probe_T_sip4_main_Probe_Reserved_186 {
                    bits 32;
                    access rw;
                    hard_reset 'h0;
                }
            }
            register ccf_Probe_T_sip4_main_Probe_Reserved_187 @0x330 {
                bytes 4;
                field ccf_Probe_T_sip4_main_Probe_Reserved_187 {
                    bits 32;
                    access rw;
                    hard_reset 'h0;
                }
            }
            register ccf_Probe_T_sip4_main_Probe_Reserved_188 @0x334 {
                bytes 4;
                field ccf_Probe_T_sip4_main_Probe_Reserved_188 {
                    bits 32;
                    access rw;
                    hard_reset 'h0;
                }
            }
            register ccf_Probe_T_sip4_main_Probe_Reserved_189 @0x338 {
                bytes 4;
                field ccf_Probe_T_sip4_main_Probe_Reserved_189 {
                    bits 32;
                    access rw;
                    hard_reset 'h0;
                }
            }
            register ccf_Probe_T_sip4_main_Probe_Reserved_190 @0x33C {
                bytes 4;
                field ccf_Probe_T_sip4_main_Probe_Reserved_190 {
                    bits 32;
                    access rw;
                    hard_reset 'h0;
                }
            }
            register ccf_Probe_T_sip4_main_Probe_Reserved_191 @0x340 {
                bytes 4;
                field ccf_Probe_T_sip4_main_Probe_Reserved_191 {
                    bits 32;
                    access rw;
                    hard_reset 'h0;
                }
            }
            register ccf_Probe_T_sip4_main_Probe_Reserved_192 @0x344 {
                bytes 4;
                field ccf_Probe_T_sip4_main_Probe_Reserved_192 {
                    bits 32;
                    access rw;
                    hard_reset 'h0;
                }
            }
            register ccf_Probe_T_sip4_main_Probe_Reserved_193 @0x348 {
                bytes 4;
                field ccf_Probe_T_sip4_main_Probe_Reserved_193 {
                    bits 32;
                    access rw;
                    hard_reset 'h0;
                }
            }
            register ccf_Probe_T_sip4_main_Probe_Reserved_194 @0x34C {
                bytes 4;
                field ccf_Probe_T_sip4_main_Probe_Reserved_194 {
                    bits 32;
                    access rw;
                    hard_reset 'h0;
                }
            }
            register ccf_Probe_T_sip4_main_Probe_Reserved_195 @0x350 {
                bytes 4;
                field ccf_Probe_T_sip4_main_Probe_Reserved_195 {
                    bits 32;
                    access rw;
                    hard_reset 'h0;
                }
            }
            register ccf_Probe_T_sip4_main_Probe_Reserved_196 @0x354 {
                bytes 4;
                field ccf_Probe_T_sip4_main_Probe_Reserved_196 {
                    bits 32;
                    access rw;
                    hard_reset 'h0;
                }
            }
            register ccf_Probe_T_sip4_main_Probe_Reserved_197 @0x358 {
                bytes 4;
                field ccf_Probe_T_sip4_main_Probe_Reserved_197 {
                    bits 32;
                    access rw;
                    hard_reset 'h0;
                }
            }
            register ccf_Probe_T_sip4_main_Probe_Reserved_198 @0x35C {
                bytes 4;
                field ccf_Probe_T_sip4_main_Probe_Reserved_198 {
                    bits 32;
                    access rw;
                    hard_reset 'h0;
                }
            }
            register ccf_Probe_T_sip4_main_Probe_Reserved_199 @0x360 {
                bytes 4;
                field ccf_Probe_T_sip4_main_Probe_Reserved_199 {
                    bits 32;
                    access rw;
                    hard_reset 'h0;
                }
            }
            register ccf_Probe_T_sip4_main_Probe_Reserved_200 @0x364 {
                bytes 4;
                field ccf_Probe_T_sip4_main_Probe_Reserved_200 {
                    bits 32;
                    access rw;
                    hard_reset 'h0;
                }
            }
            register ccf_Probe_T_sip4_main_Probe_Reserved_201 @0x368 {
                bytes 4;
                field ccf_Probe_T_sip4_main_Probe_Reserved_201 {
                    bits 32;
                    access rw;
                    hard_reset 'h0;
                }
            }
            register ccf_Probe_T_sip4_main_Probe_Reserved_202 @0x36C {
                bytes 4;
                field ccf_Probe_T_sip4_main_Probe_Reserved_202 {
                    bits 32;
                    access rw;
                    hard_reset 'h0;
                }
            }
            register ccf_Probe_T_sip4_main_Probe_Reserved_203 @0x370 {
                bytes 4;
                field ccf_Probe_T_sip4_main_Probe_Reserved_203 {
                    bits 32;
                    access rw;
                    hard_reset 'h0;
                }
            }
            register ccf_Probe_T_sip4_main_Probe_Reserved_204 @0x374 {
                bytes 4;
                field ccf_Probe_T_sip4_main_Probe_Reserved_204 {
                    bits 32;
                    access rw;
                    hard_reset 'h0;
                }
            }
            register ccf_Probe_T_sip4_main_Probe_Reserved_205 @0x378 {
                bytes 4;
                field ccf_Probe_T_sip4_main_Probe_Reserved_205 {
                    bits 32;
                    access rw;
                    hard_reset 'h0;
                }
            }
            register ccf_Probe_T_sip4_main_Probe_Reserved_206 @0x37C {
                bytes 4;
                field ccf_Probe_T_sip4_main_Probe_Reserved_206 {
                    bits 32;
                    access rw;
                    hard_reset 'h0;
                }
            }
            register ccf_Probe_T_sip4_main_Probe_Reserved_207 @0x380 {
                bytes 4;
                field ccf_Probe_T_sip4_main_Probe_Reserved_207 {
                    bits 32;
                    access rw;
                    hard_reset 'h0;
                }
            }
            register ccf_Probe_T_sip4_main_Probe_Reserved_208 @0x384 {
                bytes 4;
                field ccf_Probe_T_sip4_main_Probe_Reserved_208 {
                    bits 32;
                    access rw;
                    hard_reset 'h0;
                }
            }
            register ccf_Probe_T_sip4_main_Probe_Reserved_209 @0x388 {
                bytes 4;
                field ccf_Probe_T_sip4_main_Probe_Reserved_209 {
                    bits 32;
                    access rw;
                    hard_reset 'h0;
                }
            }
            register ccf_Probe_T_sip4_main_Probe_Reserved_210 @0x38C {
                bytes 4;
                field ccf_Probe_T_sip4_main_Probe_Reserved_210 {
                    bits 32;
                    access rw;
                    hard_reset 'h0;
                }
            }
            register ccf_Probe_T_sip4_main_Probe_Reserved_211 @0x390 {
                bytes 4;
                field ccf_Probe_T_sip4_main_Probe_Reserved_211 {
                    bits 32;
                    access rw;
                    hard_reset 'h0;
                }
            }
            register ccf_Probe_T_sip4_main_Probe_Reserved_212 @0x394 {
                bytes 4;
                field ccf_Probe_T_sip4_main_Probe_Reserved_212 {
                    bits 32;
                    access rw;
                    hard_reset 'h0;
                }
            }
            register ccf_Probe_T_sip4_main_Probe_Reserved_213 @0x398 {
                bytes 4;
                field ccf_Probe_T_sip4_main_Probe_Reserved_213 {
                    bits 32;
                    access rw;
                    hard_reset 'h0;
                }
            }
            register ccf_Probe_T_sip4_main_Probe_Reserved_214 @0x39C {
                bytes 4;
                field ccf_Probe_T_sip4_main_Probe_Reserved_214 {
                    bits 32;
                    access rw;
                    hard_reset 'h0;
                }
            }
            register ccf_Probe_T_sip4_main_Probe_Reserved_215 @0x3A0 {
                bytes 4;
                field ccf_Probe_T_sip4_main_Probe_Reserved_215 {
                    bits 32;
                    access rw;
                    hard_reset 'h0;
                }
            }
            register ccf_Probe_T_sip4_main_Probe_Reserved_216 @0x3A4 {
                bytes 4;
                field ccf_Probe_T_sip4_main_Probe_Reserved_216 {
                    bits 32;
                    access rw;
                    hard_reset 'h0;
                }
            }
            register ccf_Probe_T_sip4_main_Probe_Reserved_217 @0x3A8 {
                bytes 4;
                field ccf_Probe_T_sip4_main_Probe_Reserved_217 {
                    bits 32;
                    access rw;
                    hard_reset 'h0;
                }
            }
            register ccf_Probe_T_sip4_main_Probe_Reserved_218 @0x3AC {
                bytes 4;
                field ccf_Probe_T_sip4_main_Probe_Reserved_218 {
                    bits 32;
                    access rw;
                    hard_reset 'h0;
                }
            }
            register ccf_Probe_T_sip4_main_Probe_Reserved_219 @0x3B0 {
                bytes 4;
                field ccf_Probe_T_sip4_main_Probe_Reserved_219 {
                    bits 32;
                    access rw;
                    hard_reset 'h0;
                }
            }
            register ccf_Probe_T_sip4_main_Probe_Reserved_220 @0x3B4 {
                bytes 4;
                field ccf_Probe_T_sip4_main_Probe_Reserved_220 {
                    bits 32;
                    access rw;
                    hard_reset 'h0;
                }
            }
            register ccf_Probe_T_sip4_main_Probe_Reserved_221 @0x3B8 {
                bytes 4;
                field ccf_Probe_T_sip4_main_Probe_Reserved_221 {
                    bits 32;
                    access rw;
                    hard_reset 'h0;
                }
            }
            register ccf_Probe_T_sip4_main_Probe_Reserved_222 @0x3BC {
                bytes 4;
                field ccf_Probe_T_sip4_main_Probe_Reserved_222 {
                    bits 32;
                    access rw;
                    hard_reset 'h0;
                }
            }
            register ccf_Probe_T_sip4_main_Probe_Reserved_223 @0x3C0 {
                bytes 4;
                field ccf_Probe_T_sip4_main_Probe_Reserved_223 {
                    bits 32;
                    access rw;
                    hard_reset 'h0;
                }
            }
            register ccf_Probe_T_sip4_main_Probe_Reserved_224 @0x3C4 {
                bytes 4;
                field ccf_Probe_T_sip4_main_Probe_Reserved_224 {
                    bits 32;
                    access rw;
                    hard_reset 'h0;
                }
            }
            register ccf_Probe_T_sip4_main_Probe_Reserved_225 @0x3C8 {
                bytes 4;
                field ccf_Probe_T_sip4_main_Probe_Reserved_225 {
                    bits 32;
                    access rw;
                    hard_reset 'h0;
                }
            }
            register ccf_Probe_T_sip4_main_Probe_Reserved_226 @0x3CC {
                bytes 4;
                field ccf_Probe_T_sip4_main_Probe_Reserved_226 {
                    bits 32;
                    access rw;
                    hard_reset 'h0;
                }
            }
            register ccf_Probe_T_sip4_main_Probe_Reserved_227 @0x3D0 {
                bytes 4;
                field ccf_Probe_T_sip4_main_Probe_Reserved_227 {
                    bits 32;
                    access rw;
                    hard_reset 'h0;
                }
            }
            register ccf_Probe_T_sip4_main_Probe_Reserved_228 @0x3D4 {
                bytes 4;
                field ccf_Probe_T_sip4_main_Probe_Reserved_228 {
                    bits 32;
                    access rw;
                    hard_reset 'h0;
                }
            }
            register ccf_Probe_T_sip4_main_Probe_Reserved_229 @0x3D8 {
                bytes 4;
                field ccf_Probe_T_sip4_main_Probe_Reserved_229 {
                    bits 32;
                    access rw;
                    hard_reset 'h0;
                }
            }
            register ccf_Probe_T_sip4_main_Probe_Reserved_230 @0x3DC {
                bytes 4;
                field ccf_Probe_T_sip4_main_Probe_Reserved_230 {
                    bits 32;
                    access rw;
                    hard_reset 'h0;
                }
            }
            register ccf_Probe_T_sip4_main_Probe_Reserved_231 @0x3E0 {
                bytes 4;
                field ccf_Probe_T_sip4_main_Probe_Reserved_231 {
                    bits 32;
                    access rw;
                    hard_reset 'h0;
                }
            }
            register ccf_Probe_T_sip4_main_Probe_Reserved_232 @0x3E4 {
                bytes 4;
                field ccf_Probe_T_sip4_main_Probe_Reserved_232 {
                    bits 32;
                    access rw;
                    hard_reset 'h0;
                }
            }
            register ccf_Probe_T_sip4_main_Probe_Reserved_233 @0x3E8 {
                bytes 4;
                field ccf_Probe_T_sip4_main_Probe_Reserved_233 {
                    bits 32;
                    access rw;
                    hard_reset 'h0;
                }
            }
            register ccf_Probe_T_sip4_main_Probe_Reserved_234 @0x3EC {
                bytes 4;
                field ccf_Probe_T_sip4_main_Probe_Reserved_234 {
                    bits 32;
                    access rw;
                    hard_reset 'h0;
                }
            }
            register ccf_Probe_T_sip4_main_Probe_Reserved_235 @0x3F0 {
                bytes 4;
                field ccf_Probe_T_sip4_main_Probe_Reserved_235 {
                    bits 32;
                    access rw;
                    hard_reset 'h0;
                }
            }
            register ccf_Probe_T_sip4_main_Probe_Reserved_236 @0x3F4 {
                bytes 4;
                field ccf_Probe_T_sip4_main_Probe_Reserved_236 {
                    bits 32;
                    access rw;
                    hard_reset 'h0;
                }
            }
            register ccf_Probe_T_sip4_main_Probe_Reserved_237 @0x3F8 {
                bytes 4;
                field ccf_Probe_T_sip4_main_Probe_Reserved_237 {
                    bits 32;
                    access rw;
                    hard_reset 'h0;
                }
            }
            register ccf_Probe_T_sip4_main_Probe_Reserved_238 @0x3FC {
                bytes 4;
                field ccf_Probe_T_sip4_main_Probe_Reserved_238 {
                    bits 32;
                    access rw;
                    hard_reset 'h0;
                }
            }
        }
        block ecf_ccf_axi_ccf_Probe_T_sip5_main_Probe @0xDA400 {
            bytes 4;
            register ccf_Probe_T_sip5_main_Probe_Id_CoreId @0x0 {
                bytes 4;
                field CORETYPEID @'h0 {
                    bits 8;
                    access ro;
                    hard_reset 'h6;
                    doc {
                        Field identifying the type of IP.
                    }
                }
                field CORECHECKSUM @'h8 {
                    bits 24;
                    access ro;
                    hard_reset 'h16169e;
                    doc {
                        Field containing a checksum of the parameters of the IP.
                    }
                }
            }
            register ccf_Probe_T_sip5_main_Probe_Id_RevisionId @0x4 {
                bytes 4;
                field USERID @'h0 {
                    bits 8;
                    access ro;
                    hard_reset 'h0;
                    doc {
                        Field containing a user defined value, not used anywhere inside the IP itself.
                    }
                }
                field FLEXNOCID @'h8 {
                    bits 24;
                    access ro;
                    hard_reset 'h84f8c6;
                    doc {
                        Field containing the build revision of the software used to generate the IP HDL code.
                    }
                }
            }
            register ccf_Probe_T_sip5_main_Probe_MainCtl @0x8 {
                bytes 4;
                field ERREN @'h0 {
                    access rw;
                    hard_reset 'h0;
                    doc {
                        Register field ErrEn enables the probe to send on the ObsTx output any packet with Error status, independently of filtering mechanisms, thus constituting a simple supplementary global filter.
                    }
                }
                field TRACEEN @'h1 {
                    access ro;
                    hard_reset 'h0;
                    doc {
                        Register field TraceEn enables the probe to send filtered packets (Trace) on the ObsTx observation output.
                    }
                }
                field PAYLOADEN @'h2 {
                    access rw;
                    hard_reset 'h0;
                    doc {
                        Register field PayloadEn, when set to 1, enables traces to contain headers and payload. When set ot 0, only headers are reported.
                    }
                }
                field STATEN @'h3 {
                    access rw;
                    hard_reset 'h0;
                    doc {
                        When set to 1, register field StatEn enables statistics profiling. The probe sendS statistics results to the output for signal ObsTx. All statistics counters are cleared when the StatEn bit goes from 0 to 1. When set to 0, counters are disabled.
                    }
                }
                field ALARMEN @'h4 {
                    access rw;
                    hard_reset 'h0;
                    doc {
                        When set, register field AlarmEn enables the probe to collect alarm-related information. When the register field bit is null, both TraceAlarm and StatAlarm outputs are driven to 0.
                    }
                }
                field STATCONDDUMP @'h5 {
                    access rw;
                    hard_reset 'h0;
                    doc {
                        When set, register field StatCondDump enables the dump of a statistics frame to the range of counter values set for registers StatAlarmMin, StatAlarmMax, and AlarmMode. This field also renders register StatAlarmStatus inoperative. When parameter statisticsCounterAlarm is set to False, the StatCondDump register bit is reserved.
                    }
                }
                field INTRUSIVEMODE @'h6 {
                    access ro;
                    hard_reset 'h0;
                    doc {
                        When set to 1, register field IntrusiveMode enables trace operation in Intrusive flow-control mode. When set to 0, the register  enables trace operation in Overflow flow-control mode
                    }
                }
                field FILTBYTEALWAYSCHAINABLEEN @'h7 {
                    access rw;
                    hard_reset 'h0;
                    doc {
                        When set to 0, filters are mapped to all statistic counters when counting bytes or enabled bytes. Therefore, only filter events mapped to even counters can be counted using a pair of chained counters.When set to 1, filters are mapped only to even statistic counters when counting bytes or enabled bytes. Thus events from any filter can be counted using a pair of chained counters.
                    }
                }
                doc {
                    Register MainCtl contains probe global control bits. The register has seven bit fields:Register MainCtl contains probe global control bits. The register has seven bit fields:
                }
            }
            register ccf_Probe_T_sip5_main_Probe_CfgCtl @0xC {
                bytes 4;
                field GLOBALEN @'h0 {
                    access rw;
                    hard_reset 'h0;
                }
                field ACTIVE @'h1 {
                    access ro;
                    hard_reset 'h0;
                }
            }
            register ccf_Probe_T_sip5_main_Probe_Reserved_00 @0x10 {
                bytes 4;
                field ccf_Probe_T_sip5_main_Probe_Reserved_00 {
                    bits 32;
                    access rw;
                    hard_reset 'h0;
                }
            }
            register ccf_Probe_T_sip5_main_Probe_Reserved_01 @0x14 {
                bytes 4;
                field ccf_Probe_T_sip5_main_Probe_Reserved_01 {
                    bits 32;
                    access rw;
                    hard_reset 'h0;
                }
            }
            register ccf_Probe_T_sip5_main_Probe_Reserved_02 @0x18 {
                bytes 4;
                field ccf_Probe_T_sip5_main_Probe_Reserved_02 {
                    bits 32;
                    access rw;
                    hard_reset 'h0;
                }
            }
            register ccf_Probe_T_sip5_main_Probe_Reserved_03 @0x1C {
                bytes 4;
                field ccf_Probe_T_sip5_main_Probe_Reserved_03 {
                    bits 32;
                    access rw;
                    hard_reset 'h0;
                }
            }
            register ccf_Probe_T_sip5_main_Probe_Reserved_04 @0x20 {
                bytes 4;
                field ccf_Probe_T_sip5_main_Probe_Reserved_04 {
                    bits 32;
                    access rw;
                    hard_reset 'h0;
                }
            }
            register ccf_Probe_T_sip5_main_Probe_StatPeriod @0x24 {
                bytes 4;
                field STATPERIOD @'h0 {
                    bits 5;
                    access rw;
                    hard_reset 'h0;
                    doc {
                        Register StatPeriod is a 5-bit register that sets a period, within a range of 2 cycles to 2 gigacycles, during which statistics are collected before being dumped automatically. Setting the register implicitly enables automatic mode operation for statistics collection. The period is calculated with the formula: N_Cycle = 2**StatPeriodWhen register StatPeriod is set to its default value 0, automatic dump mode is disabled, and register StatGo is activated for manual mode operation. Note: When parameter statisticsCollection is set to False, StatPeriod is reserved.
                    }
                }
            }
            register ccf_Probe_T_sip5_main_Probe_StatGo @0x28 {
                bytes 4;
                field STATGO @'h0 {
                    access w1c;
                    hard_reset 'h0;
                    doc {
                        Writing a 1 to the 1-bit pulse register StatGo generates a statistics dump.The register is active when statistics collection operates in manual mode, that is, when register StatPeriod is set to 0.NOTE  The written value is not stored in StatGo. A read always returns 0.
                    }
                }
            }
            register ccf_Probe_T_sip5_main_Probe_StatAlarmMin @0x2C {
                bytes 4;
                field STATALARMMIN @'h0 {
                    bits 22;
                    access rw;
                    hard_reset 'h0;
                    doc {
                        Register StatAlarmMin contains the minimum count value used in statistics alarm comparisons. The number of bits is equal to twice the value set forparameter wStatisticsCounter. When parameter statisticsCounterAlarm is set to False, StatAlarmMin is reserved.
                    }
                }
            }
            register ccf_Probe_T_sip5_main_Probe_StatAlarmMax @0x30 {
                bytes 4;
                field STATALARMMAX @'h0 {
                    bits 22;
                    access rw;
                    hard_reset 'h0;
                    doc {
                        Register StatAlarmMax contains the maximum count value used in statistics alarm comparisons.The number of bits is equal to twice the value set for parameter wStatisticsCounter. When parameter statisticsCounterAlarm is set to False, StatAlarmMax is reserved.
                    }
                }
            }
            register ccf_Probe_T_sip5_main_Probe_StatAlarmStatus @0x34 {
                bytes 4;
                field STATALARMSTATUS @'h0 {
                    access ro;
                    hard_reset 'h0;
                    doc {
                        Register StatAlarmStatus is a read-only 1-bit register indicating that at least one statistics counter has exceeded the programmed values for registers StatAlarmMin or StatAlarmMax. Output signal StatAlarm is equal to the values stored in register MainCtl fields StatAlarmStatus and AlarmEn. When parameter statisticsCounterAlarm is set to False, StatAlarmStatus is reserved.
                    }
                }
            }
            register ccf_Probe_T_sip5_main_Probe_StatAlarmClr @0x38 {
                bytes 4;
                field STATALARMCLR @'h0 {
                    access w1c;
                    hard_reset 'h0;
                    doc {
                        Register StatAlarmClr is a 1-bit register. Writing a 1 to this register clears the StatAlarmStatus register bit.When parameter statisticsCounterAlarm is set to False, StatAlarmClr is reserved.NOTE  The written value is not stored in StatAlarmClr. A read always returns 0.
                    }
                }
            }
            register ccf_Probe_T_sip5_main_Probe_StatAlarmEn @0x3C {
                bytes 4;
                field STATALARMEN @'h0 {
                    access rw;
                    hard_reset 'h1;
                    doc {
                        Register StatAlarmEn is a 1-bit register. When set to 0 it masks StatAlarm and CtiTrigOut(1) signal interrupts.
                    }
                }
            }
            register ccf_Probe_T_sip5_main_Probe_Reserved_05 @0x40 {
                bytes 4;
                field ccf_Probe_T_sip5_main_Probe_Reserved_05 {
                    bits 32;
                    access rw;
                    hard_reset 'h0;
                }
            }
            register ccf_Probe_T_sip5_main_Probe_Reserved_06 @0x44 {
                bytes 4;
                field ccf_Probe_T_sip5_main_Probe_Reserved_06 {
                    bits 32;
                    access rw;
                    hard_reset 'h0;
                }
            }
            register ccf_Probe_T_sip5_main_Probe_Reserved_07 @0x48 {
                bytes 4;
                field ccf_Probe_T_sip5_main_Probe_Reserved_07 {
                    bits 32;
                    access rw;
                    hard_reset 'h0;
                }
            }
            register ccf_Probe_T_sip5_main_Probe_Reserved_08 @0x4C {
                bytes 4;
                field ccf_Probe_T_sip5_main_Probe_Reserved_08 {
                    bits 32;
                    access rw;
                    hard_reset 'h0;
                }
            }
            register ccf_Probe_T_sip5_main_Probe_Reserved_09 @0x50 {
                bytes 4;
                field ccf_Probe_T_sip5_main_Probe_Reserved_09 {
                    bits 32;
                    access rw;
                    hard_reset 'h0;
                }
            }
            register ccf_Probe_T_sip5_main_Probe_Reserved_10 @0x54 {
                bytes 4;
                field ccf_Probe_T_sip5_main_Probe_Reserved_10 {
                    bits 32;
                    access rw;
                    hard_reset 'h0;
                }
            }
            register ccf_Probe_T_sip5_main_Probe_Reserved_11 @0x58 {
                bytes 4;
                field ccf_Probe_T_sip5_main_Probe_Reserved_11 {
                    bits 32;
                    access rw;
                    hard_reset 'h0;
                }
            }
            register ccf_Probe_T_sip5_main_Probe_Reserved_12 @0x5C {
                bytes 4;
                field ccf_Probe_T_sip5_main_Probe_Reserved_12 {
                    bits 32;
                    access rw;
                    hard_reset 'h0;
                }
            }
            register ccf_Probe_T_sip5_main_Probe_Reserved_13 @0x60 {
                bytes 4;
                field ccf_Probe_T_sip5_main_Probe_Reserved_13 {
                    bits 32;
                    access rw;
                    hard_reset 'h0;
                }
            }
            register ccf_Probe_T_sip5_main_Probe_Reserved_14 @0x64 {
                bytes 4;
                field ccf_Probe_T_sip5_main_Probe_Reserved_14 {
                    bits 32;
                    access rw;
                    hard_reset 'h0;
                }
            }
            register ccf_Probe_T_sip5_main_Probe_Reserved_15 @0x68 {
                bytes 4;
                field ccf_Probe_T_sip5_main_Probe_Reserved_15 {
                    bits 32;
                    access rw;
                    hard_reset 'h0;
                }
            }
            register ccf_Probe_T_sip5_main_Probe_Reserved_16 @0x6C {
                bytes 4;
                field ccf_Probe_T_sip5_main_Probe_Reserved_16 {
                    bits 32;
                    access rw;
                    hard_reset 'h0;
                }
            }
            register ccf_Probe_T_sip5_main_Probe_Reserved_17 @0x70 {
                bytes 4;
                field ccf_Probe_T_sip5_main_Probe_Reserved_17 {
                    bits 32;
                    access rw;
                    hard_reset 'h0;
                }
            }
            register ccf_Probe_T_sip5_main_Probe_Reserved_18 @0x74 {
                bytes 4;
                field ccf_Probe_T_sip5_main_Probe_Reserved_18 {
                    bits 32;
                    access rw;
                    hard_reset 'h0;
                }
            }
            register ccf_Probe_T_sip5_main_Probe_Reserved_19 @0x78 {
                bytes 4;
                field ccf_Probe_T_sip5_main_Probe_Reserved_19 {
                    bits 32;
                    access rw;
                    hard_reset 'h0;
                }
            }
            register ccf_Probe_T_sip5_main_Probe_Reserved_20 @0x7C {
                bytes 4;
                field ccf_Probe_T_sip5_main_Probe_Reserved_20 {
                    bits 32;
                    access rw;
                    hard_reset 'h0;
                }
            }
            register ccf_Probe_T_sip5_main_Probe_Reserved_21 @0x80 {
                bytes 4;
                field ccf_Probe_T_sip5_main_Probe_Reserved_21 {
                    bits 32;
                    access rw;
                    hard_reset 'h0;
                }
            }
            register ccf_Probe_T_sip5_main_Probe_Reserved_22 @0x84 {
                bytes 4;
                field ccf_Probe_T_sip5_main_Probe_Reserved_22 {
                    bits 32;
                    access rw;
                    hard_reset 'h0;
                }
            }
            register ccf_Probe_T_sip5_main_Probe_Reserved_23 @0x88 {
                bytes 4;
                field ccf_Probe_T_sip5_main_Probe_Reserved_23 {
                    bits 32;
                    access rw;
                    hard_reset 'h0;
                }
            }
            register ccf_Probe_T_sip5_main_Probe_Reserved_24 @0x8C {
                bytes 4;
                field ccf_Probe_T_sip5_main_Probe_Reserved_24 {
                    bits 32;
                    access rw;
                    hard_reset 'h0;
                }
            }
            register ccf_Probe_T_sip5_main_Probe_Reserved_25 @0x90 {
                bytes 4;
                field ccf_Probe_T_sip5_main_Probe_Reserved_25 {
                    bits 32;
                    access rw;
                    hard_reset 'h0;
                }
            }
            register ccf_Probe_T_sip5_main_Probe_Reserved_26 @0x94 {
                bytes 4;
                field ccf_Probe_T_sip5_main_Probe_Reserved_26 {
                    bits 32;
                    access rw;
                    hard_reset 'h0;
                }
            }
            register ccf_Probe_T_sip5_main_Probe_Reserved_27 @0x98 {
                bytes 4;
                field ccf_Probe_T_sip5_main_Probe_Reserved_27 {
                    bits 32;
                    access rw;
                    hard_reset 'h0;
                }
            }
            register ccf_Probe_T_sip5_main_Probe_Reserved_28 @0x9C {
                bytes 4;
                field ccf_Probe_T_sip5_main_Probe_Reserved_28 {
                    bits 32;
                    access rw;
                    hard_reset 'h0;
                }
            }
            register ccf_Probe_T_sip5_main_Probe_Reserved_29 @0xA0 {
                bytes 4;
                field ccf_Probe_T_sip5_main_Probe_Reserved_29 {
                    bits 32;
                    access rw;
                    hard_reset 'h0;
                }
            }
            register ccf_Probe_T_sip5_main_Probe_Reserved_30 @0xA4 {
                bytes 4;
                field ccf_Probe_T_sip5_main_Probe_Reserved_30 {
                    bits 32;
                    access rw;
                    hard_reset 'h0;
                }
            }
            register ccf_Probe_T_sip5_main_Probe_Reserved_31 @0xA8 {
                bytes 4;
                field ccf_Probe_T_sip5_main_Probe_Reserved_31 {
                    bits 32;
                    access rw;
                    hard_reset 'h0;
                }
            }
            register ccf_Probe_T_sip5_main_Probe_Reserved_32 @0xAC {
                bytes 4;
                field ccf_Probe_T_sip5_main_Probe_Reserved_32 {
                    bits 32;
                    access rw;
                    hard_reset 'h0;
                }
            }
            register ccf_Probe_T_sip5_main_Probe_Reserved_33 @0xB0 {
                bytes 4;
                field ccf_Probe_T_sip5_main_Probe_Reserved_33 {
                    bits 32;
                    access rw;
                    hard_reset 'h0;
                }
            }
            register ccf_Probe_T_sip5_main_Probe_Reserved_34 @0xB4 {
                bytes 4;
                field ccf_Probe_T_sip5_main_Probe_Reserved_34 {
                    bits 32;
                    access rw;
                    hard_reset 'h0;
                }
            }
            register ccf_Probe_T_sip5_main_Probe_Reserved_35 @0xB8 {
                bytes 4;
                field ccf_Probe_T_sip5_main_Probe_Reserved_35 {
                    bits 32;
                    access rw;
                    hard_reset 'h0;
                }
            }
            register ccf_Probe_T_sip5_main_Probe_Reserved_36 @0xBC {
                bytes 4;
                field ccf_Probe_T_sip5_main_Probe_Reserved_36 {
                    bits 32;
                    access rw;
                    hard_reset 'h0;
                }
            }
            register ccf_Probe_T_sip5_main_Probe_Reserved_37 @0xC0 {
                bytes 4;
                field ccf_Probe_T_sip5_main_Probe_Reserved_37 {
                    bits 32;
                    access rw;
                    hard_reset 'h0;
                }
            }
            register ccf_Probe_T_sip5_main_Probe_Reserved_38 @0xC4 {
                bytes 4;
                field ccf_Probe_T_sip5_main_Probe_Reserved_38 {
                    bits 32;
                    access rw;
                    hard_reset 'h0;
                }
            }
            register ccf_Probe_T_sip5_main_Probe_Reserved_39 @0xC8 {
                bytes 4;
                field ccf_Probe_T_sip5_main_Probe_Reserved_39 {
                    bits 32;
                    access rw;
                    hard_reset 'h0;
                }
            }
            register ccf_Probe_T_sip5_main_Probe_Reserved_40 @0xCC {
                bytes 4;
                field ccf_Probe_T_sip5_main_Probe_Reserved_40 {
                    bits 32;
                    access rw;
                    hard_reset 'h0;
                }
            }
            register ccf_Probe_T_sip5_main_Probe_Reserved_41 @0xD0 {
                bytes 4;
                field ccf_Probe_T_sip5_main_Probe_Reserved_41 {
                    bits 32;
                    access rw;
                    hard_reset 'h0;
                }
            }
            register ccf_Probe_T_sip5_main_Probe_Reserved_42 @0xD4 {
                bytes 4;
                field ccf_Probe_T_sip5_main_Probe_Reserved_42 {
                    bits 32;
                    access rw;
                    hard_reset 'h0;
                }
            }
            register ccf_Probe_T_sip5_main_Probe_Reserved_43 @0xD8 {
                bytes 4;
                field ccf_Probe_T_sip5_main_Probe_Reserved_43 {
                    bits 32;
                    access rw;
                    hard_reset 'h0;
                }
            }
            register ccf_Probe_T_sip5_main_Probe_Reserved_44 @0xDC {
                bytes 4;
                field ccf_Probe_T_sip5_main_Probe_Reserved_44 {
                    bits 32;
                    access rw;
                    hard_reset 'h0;
                }
            }
            register ccf_Probe_T_sip5_main_Probe_Reserved_45 @0xE0 {
                bytes 4;
                field ccf_Probe_T_sip5_main_Probe_Reserved_45 {
                    bits 32;
                    access rw;
                    hard_reset 'h0;
                }
            }
            register ccf_Probe_T_sip5_main_Probe_Reserved_46 @0xE4 {
                bytes 4;
                field ccf_Probe_T_sip5_main_Probe_Reserved_46 {
                    bits 32;
                    access rw;
                    hard_reset 'h0;
                }
            }
            register ccf_Probe_T_sip5_main_Probe_Reserved_47 @0xE8 {
                bytes 4;
                field ccf_Probe_T_sip5_main_Probe_Reserved_47 {
                    bits 32;
                    access rw;
                    hard_reset 'h0;
                }
            }
            register ccf_Probe_T_sip5_main_Probe_Reserved_48 @0xEC {
                bytes 4;
                field ccf_Probe_T_sip5_main_Probe_Reserved_48 {
                    bits 32;
                    access rw;
                    hard_reset 'h0;
                }
            }
            register ccf_Probe_T_sip5_main_Probe_Reserved_49 @0xF0 {
                bytes 4;
                field ccf_Probe_T_sip5_main_Probe_Reserved_49 {
                    bits 32;
                    access rw;
                    hard_reset 'h0;
                }
            }
            register ccf_Probe_T_sip5_main_Probe_Reserved_50 @0xF4 {
                bytes 4;
                field ccf_Probe_T_sip5_main_Probe_Reserved_50 {
                    bits 32;
                    access rw;
                    hard_reset 'h0;
                }
            }
            register ccf_Probe_T_sip5_main_Probe_Reserved_51 @0xF8 {
                bytes 4;
                field ccf_Probe_T_sip5_main_Probe_Reserved_51 {
                    bits 32;
                    access rw;
                    hard_reset 'h0;
                }
            }
            register ccf_Probe_T_sip5_main_Probe_Reserved_52 @0xFC {
                bytes 4;
                field ccf_Probe_T_sip5_main_Probe_Reserved_52 {
                    bits 32;
                    access rw;
                    hard_reset 'h0;
                }
            }
            register ccf_Probe_T_sip5_main_Probe_Reserved_53 @0x100 {
                bytes 4;
                field ccf_Probe_T_sip5_main_Probe_Reserved_53 {
                    bits 32;
                    access rw;
                    hard_reset 'h0;
                }
            }
            register ccf_Probe_T_sip5_main_Probe_Reserved_54 @0x104 {
                bytes 4;
                field ccf_Probe_T_sip5_main_Probe_Reserved_54 {
                    bits 32;
                    access rw;
                    hard_reset 'h0;
                }
            }
            register ccf_Probe_T_sip5_main_Probe_Reserved_55 @0x108 {
                bytes 4;
                field ccf_Probe_T_sip5_main_Probe_Reserved_55 {
                    bits 32;
                    access rw;
                    hard_reset 'h0;
                }
            }
            register ccf_Probe_T_sip5_main_Probe_Reserved_56 @0x10C {
                bytes 4;
                field ccf_Probe_T_sip5_main_Probe_Reserved_56 {
                    bits 32;
                    access rw;
                    hard_reset 'h0;
                }
            }
            register ccf_Probe_T_sip5_main_Probe_Reserved_57 @0x110 {
                bytes 4;
                field ccf_Probe_T_sip5_main_Probe_Reserved_57 {
                    bits 32;
                    access rw;
                    hard_reset 'h0;
                }
            }
            register ccf_Probe_T_sip5_main_Probe_Reserved_58 @0x114 {
                bytes 4;
                field ccf_Probe_T_sip5_main_Probe_Reserved_58 {
                    bits 32;
                    access rw;
                    hard_reset 'h0;
                }
            }
            register ccf_Probe_T_sip5_main_Probe_Reserved_59 @0x118 {
                bytes 4;
                field ccf_Probe_T_sip5_main_Probe_Reserved_59 {
                    bits 32;
                    access rw;
                    hard_reset 'h0;
                }
            }
            register ccf_Probe_T_sip5_main_Probe_Reserved_60 @0x11C {
                bytes 4;
                field ccf_Probe_T_sip5_main_Probe_Reserved_60 {
                    bits 32;
                    access rw;
                    hard_reset 'h0;
                }
            }
            register ccf_Probe_T_sip5_main_Probe_Reserved_61 @0x120 {
                bytes 4;
                field ccf_Probe_T_sip5_main_Probe_Reserved_61 {
                    bits 32;
                    access rw;
                    hard_reset 'h0;
                }
            }
            register ccf_Probe_T_sip5_main_Probe_Reserved_62 @0x124 {
                bytes 4;
                field ccf_Probe_T_sip5_main_Probe_Reserved_62 {
                    bits 32;
                    access rw;
                    hard_reset 'h0;
                }
            }
            register ccf_Probe_T_sip5_main_Probe_Reserved_63 @0x128 {
                bytes 4;
                field ccf_Probe_T_sip5_main_Probe_Reserved_63 {
                    bits 32;
                    access rw;
                    hard_reset 'h0;
                }
            }
            register ccf_Probe_T_sip5_main_Probe_Reserved_64 @0x12C {
                bytes 4;
                field ccf_Probe_T_sip5_main_Probe_Reserved_64 {
                    bits 32;
                    access rw;
                    hard_reset 'h0;
                }
            }
            register ccf_Probe_T_sip5_main_Probe_Reserved_65 @0x130 {
                bytes 4;
                field ccf_Probe_T_sip5_main_Probe_Reserved_65 {
                    bits 32;
                    access rw;
                    hard_reset 'h0;
                }
            }
            register ccf_Probe_T_sip5_main_Probe_Reserved_66 @0x134 {
                bytes 4;
                field ccf_Probe_T_sip5_main_Probe_Reserved_66 {
                    bits 32;
                    access rw;
                    hard_reset 'h0;
                }
            }
            register ccf_Probe_T_sip5_main_Probe_Counters_0_Src @0x138 {
                bytes 4;
                field INTEVENT @'h0 {
                    bits 5;
                    access rw;
                    hard_reset 'h0;
                    enum { OFF = 0, CYCLE = 1, IDLE = 2, XFER = 3, BUSY = 4, WAIT = 5, PKT = 6, LUT = 7, BYTE = 8, PRESS0 = 9, PRESS1 = 10, PRESS2 = 11, FILT0 = 12, FILT1 = 13, FILT2 = 14, FILT3 = 15, CHAIN = 16, LUT_BYTE_EN = 17, LUT_BYTE = 18, FILT_BYTE_EN = 19, FILT_BYTE = 20, PRESS3 = 21, PRESS4 = 22, PRESS5 = 23, PRESS6 = 24, RSV_0 = 25, RSV_1 = 26, RSV_2 = 27, RSV_3 = 28, RSV_4 = 29, RSV_5 = 30, RSV_6 = 31 };
                    doc {
                        Internal packet event
                    }
                }
                field EXTEVENT @'h5 {
                    access rw;
                    hard_reset 'h0;
                    doc {
                        When greater than 0, the entire register value is used to select an external hardware event source. The index of the external event is equal to {ExtEvent,IntEvent}.
                    }
                }
                doc {
                    Register CntSrc indicates the event source used to increment the counter. Unassigned values (non-existing Press level or ExtEvent index, or unimplemented Filter) are equivalent to OFF.
	Register CntSrc indicates the event source used to increment the counter. Unassigned values (non-existing Press level or ExtEvent index, or unimplemented Filter) are equivalent to OFF.
	
                }
            }
            register ccf_Probe_T_sip5_main_Probe_Counters_0_AlarmMode @0x13C {
                bytes 4;
                field COUNTERS_0_ALARMMODE @'h0 {
                    bits 2;
                    access rw;
                    hard_reset 'h0;
                    enum { OFF = 0, MIN = 1, MAX = 2, MIN_MAX = 3 };
                    doc {
                        Register AlarmMode is a 2-bit register that is present when parameter statisticsCounterAlarm is set to True. The register defines the statistics-alarm behavior of the counter.
                    }
                }
            }
            register ccf_Probe_T_sip5_main_Probe_Counters_0_Val @0x140 {
                bytes 4;
                field COUNTERS_0_VAL @'h0 {
                    bits 11;
                    access ro;
                    hard_reset 'h0;
                    doc {
                        Register Val is a read-only register that is always present. The register containsthe statistics counter value either pending StatAlarm output, or when statisticscollection is suspended subsequent to triggers or signal statSuspend.
                    }
                }
            }
            register ccf_Probe_T_sip5_main_Probe_Reserved_67 @0x144 {
                bytes 4;
                field ccf_Probe_T_sip5_main_Probe_Reserved_67 {
                    bits 32;
                    access rw;
                    hard_reset 'h0;
                }
            }
            register ccf_Probe_T_sip5_main_Probe_Reserved_68 @0x148 {
                bytes 4;
                field ccf_Probe_T_sip5_main_Probe_Reserved_68 {
                    bits 32;
                    access rw;
                    hard_reset 'h0;
                }
            }
            register ccf_Probe_T_sip5_main_Probe_Counters_1_Src @0x14C {
                bytes 4;
                field INTEVENT @'h0 {
                    bits 5;
                    access rw;
                    hard_reset 'h0;
                    enum { OFF = 0, CYCLE = 1, IDLE = 2, XFER = 3, BUSY = 4, WAIT = 5, PKT = 6, LUT = 7, BYTE = 8, PRESS0 = 9, PRESS1 = 10, PRESS2 = 11, FILT0 = 12, FILT1 = 13, FILT2 = 14, FILT3 = 15, CHAIN = 16, LUT_BYTE_EN = 17, LUT_BYTE = 18, FILT_BYTE_EN = 19, FILT_BYTE = 20, PRESS3 = 21, PRESS4 = 22, PRESS5 = 23, PRESS6 = 24, RSV_0 = 25, RSV_1 = 26, RSV_2 = 27, RSV_3 = 28, RSV_4 = 29, RSV_5 = 30, RSV_6 = 31 };
                    doc {
                        Internal packet event
                    }
                }
                field EXTEVENT @'h5 {
                    access rw;
                    hard_reset 'h0;
                    doc {
                        When greater than 0, the entire register value is used to select an external hardware event source. The index of the external event is equal to {ExtEvent,IntEvent}.
                    }
                }
                doc {
                    Register CntSrc indicates the event source used to increment the counter. Unassigned values (non-existing Press level or ExtEvent index, or unimplemented Filter) are equivalent to OFF.
	Register CntSrc indicates the event source used to increment the counter. Unassigned values (non-existing Press level or ExtEvent index, or unimplemented Filter) are equivalent to OFF.
	
                }
            }
            register ccf_Probe_T_sip5_main_Probe_Counters_1_AlarmMode @0x150 {
                bytes 4;
                field COUNTERS_1_ALARMMODE @'h0 {
                    bits 2;
                    access rw;
                    hard_reset 'h0;
                    enum { OFF = 0, MIN = 1, MAX = 2, MIN_MAX = 3 };
                    doc {
                        Register AlarmMode is a 2-bit register that is present when parameter statisticsCounterAlarm is set to True. The register defines the statistics-alarm behavior of the counter.
                    }
                }
            }
            register ccf_Probe_T_sip5_main_Probe_Counters_1_Val @0x154 {
                bytes 4;
                field COUNTERS_1_VAL @'h0 {
                    bits 11;
                    access ro;
                    hard_reset 'h0;
                    doc {
                        Register Val is a read-only register that is always present. The register containsthe statistics counter value either pending StatAlarm output, or when statisticscollection is suspended subsequent to triggers or signal statSuspend.
                    }
                }
            }
            register ccf_Probe_T_sip5_main_Probe_Reserved_69 @0x158 {
                bytes 4;
                field ccf_Probe_T_sip5_main_Probe_Reserved_69 {
                    bits 32;
                    access rw;
                    hard_reset 'h0;
                }
            }
            register ccf_Probe_T_sip5_main_Probe_Reserved_70 @0x15C {
                bytes 4;
                field ccf_Probe_T_sip5_main_Probe_Reserved_70 {
                    bits 32;
                    access rw;
                    hard_reset 'h0;
                }
            }
            register ccf_Probe_T_sip5_main_Probe_Reserved_71 @0x160 {
                bytes 4;
                field ccf_Probe_T_sip5_main_Probe_Reserved_71 {
                    bits 32;
                    access rw;
                    hard_reset 'h0;
                }
            }
            register ccf_Probe_T_sip5_main_Probe_Reserved_72 @0x164 {
                bytes 4;
                field ccf_Probe_T_sip5_main_Probe_Reserved_72 {
                    bits 32;
                    access rw;
                    hard_reset 'h0;
                }
            }
            register ccf_Probe_T_sip5_main_Probe_Reserved_73 @0x168 {
                bytes 4;
                field ccf_Probe_T_sip5_main_Probe_Reserved_73 {
                    bits 32;
                    access rw;
                    hard_reset 'h0;
                }
            }
            register ccf_Probe_T_sip5_main_Probe_Reserved_74 @0x16C {
                bytes 4;
                field ccf_Probe_T_sip5_main_Probe_Reserved_74 {
                    bits 32;
                    access rw;
                    hard_reset 'h0;
                }
            }
            register ccf_Probe_T_sip5_main_Probe_Reserved_75 @0x170 {
                bytes 4;
                field ccf_Probe_T_sip5_main_Probe_Reserved_75 {
                    bits 32;
                    access rw;
                    hard_reset 'h0;
                }
            }
            register ccf_Probe_T_sip5_main_Probe_Reserved_76 @0x174 {
                bytes 4;
                field ccf_Probe_T_sip5_main_Probe_Reserved_76 {
                    bits 32;
                    access rw;
                    hard_reset 'h0;
                }
            }
            register ccf_Probe_T_sip5_main_Probe_Reserved_77 @0x178 {
                bytes 4;
                field ccf_Probe_T_sip5_main_Probe_Reserved_77 {
                    bits 32;
                    access rw;
                    hard_reset 'h0;
                }
            }
            register ccf_Probe_T_sip5_main_Probe_Reserved_78 @0x17C {
                bytes 4;
                field ccf_Probe_T_sip5_main_Probe_Reserved_78 {
                    bits 32;
                    access rw;
                    hard_reset 'h0;
                }
            }
            register ccf_Probe_T_sip5_main_Probe_Reserved_79 @0x180 {
                bytes 4;
                field ccf_Probe_T_sip5_main_Probe_Reserved_79 {
                    bits 32;
                    access rw;
                    hard_reset 'h0;
                }
            }
            register ccf_Probe_T_sip5_main_Probe_Reserved_80 @0x184 {
                bytes 4;
                field ccf_Probe_T_sip5_main_Probe_Reserved_80 {
                    bits 32;
                    access rw;
                    hard_reset 'h0;
                }
            }
            register ccf_Probe_T_sip5_main_Probe_Reserved_81 @0x188 {
                bytes 4;
                field ccf_Probe_T_sip5_main_Probe_Reserved_81 {
                    bits 32;
                    access rw;
                    hard_reset 'h0;
                }
            }
            register ccf_Probe_T_sip5_main_Probe_Reserved_82 @0x18C {
                bytes 4;
                field ccf_Probe_T_sip5_main_Probe_Reserved_82 {
                    bits 32;
                    access rw;
                    hard_reset 'h0;
                }
            }
            register ccf_Probe_T_sip5_main_Probe_Reserved_83 @0x190 {
                bytes 4;
                field ccf_Probe_T_sip5_main_Probe_Reserved_83 {
                    bits 32;
                    access rw;
                    hard_reset 'h0;
                }
            }
            register ccf_Probe_T_sip5_main_Probe_Reserved_84 @0x194 {
                bytes 4;
                field ccf_Probe_T_sip5_main_Probe_Reserved_84 {
                    bits 32;
                    access rw;
                    hard_reset 'h0;
                }
            }
            register ccf_Probe_T_sip5_main_Probe_Reserved_85 @0x198 {
                bytes 4;
                field ccf_Probe_T_sip5_main_Probe_Reserved_85 {
                    bits 32;
                    access rw;
                    hard_reset 'h0;
                }
            }
            register ccf_Probe_T_sip5_main_Probe_Reserved_86 @0x19C {
                bytes 4;
                field ccf_Probe_T_sip5_main_Probe_Reserved_86 {
                    bits 32;
                    access rw;
                    hard_reset 'h0;
                }
            }
            register ccf_Probe_T_sip5_main_Probe_Reserved_87 @0x1A0 {
                bytes 4;
                field ccf_Probe_T_sip5_main_Probe_Reserved_87 {
                    bits 32;
                    access rw;
                    hard_reset 'h0;
                }
            }
            register ccf_Probe_T_sip5_main_Probe_Reserved_88 @0x1A4 {
                bytes 4;
                field ccf_Probe_T_sip5_main_Probe_Reserved_88 {
                    bits 32;
                    access rw;
                    hard_reset 'h0;
                }
            }
            register ccf_Probe_T_sip5_main_Probe_Reserved_89 @0x1A8 {
                bytes 4;
                field ccf_Probe_T_sip5_main_Probe_Reserved_89 {
                    bits 32;
                    access rw;
                    hard_reset 'h0;
                }
            }
            register ccf_Probe_T_sip5_main_Probe_Reserved_90 @0x1AC {
                bytes 4;
                field ccf_Probe_T_sip5_main_Probe_Reserved_90 {
                    bits 32;
                    access rw;
                    hard_reset 'h0;
                }
            }
            register ccf_Probe_T_sip5_main_Probe_Reserved_91 @0x1B0 {
                bytes 4;
                field ccf_Probe_T_sip5_main_Probe_Reserved_91 {
                    bits 32;
                    access rw;
                    hard_reset 'h0;
                }
            }
            register ccf_Probe_T_sip5_main_Probe_Reserved_92 @0x1B4 {
                bytes 4;
                field ccf_Probe_T_sip5_main_Probe_Reserved_92 {
                    bits 32;
                    access rw;
                    hard_reset 'h0;
                }
            }
            register ccf_Probe_T_sip5_main_Probe_Reserved_93 @0x1B8 {
                bytes 4;
                field ccf_Probe_T_sip5_main_Probe_Reserved_93 {
                    bits 32;
                    access rw;
                    hard_reset 'h0;
                }
            }
            register ccf_Probe_T_sip5_main_Probe_Reserved_94 @0x1BC {
                bytes 4;
                field ccf_Probe_T_sip5_main_Probe_Reserved_94 {
                    bits 32;
                    access rw;
                    hard_reset 'h0;
                }
            }
            register ccf_Probe_T_sip5_main_Probe_Reserved_95 @0x1C0 {
                bytes 4;
                field ccf_Probe_T_sip5_main_Probe_Reserved_95 {
                    bits 32;
                    access rw;
                    hard_reset 'h0;
                }
            }
            register ccf_Probe_T_sip5_main_Probe_Reserved_96 @0x1C4 {
                bytes 4;
                field ccf_Probe_T_sip5_main_Probe_Reserved_96 {
                    bits 32;
                    access rw;
                    hard_reset 'h0;
                }
            }
            register ccf_Probe_T_sip5_main_Probe_Reserved_97 @0x1C8 {
                bytes 4;
                field ccf_Probe_T_sip5_main_Probe_Reserved_97 {
                    bits 32;
                    access rw;
                    hard_reset 'h0;
                }
            }
            register ccf_Probe_T_sip5_main_Probe_Reserved_98 @0x1CC {
                bytes 4;
                field ccf_Probe_T_sip5_main_Probe_Reserved_98 {
                    bits 32;
                    access rw;
                    hard_reset 'h0;
                }
            }
            register ccf_Probe_T_sip5_main_Probe_Reserved_99 @0x1D0 {
                bytes 4;
                field ccf_Probe_T_sip5_main_Probe_Reserved_99 {
                    bits 32;
                    access rw;
                    hard_reset 'h0;
                }
            }
            register ccf_Probe_T_sip5_main_Probe_Reserved_100 @0x1D4 {
                bytes 4;
                field ccf_Probe_T_sip5_main_Probe_Reserved_100 {
                    bits 32;
                    access rw;
                    hard_reset 'h0;
                }
            }
            register ccf_Probe_T_sip5_main_Probe_Reserved_101 @0x1D8 {
                bytes 4;
                field ccf_Probe_T_sip5_main_Probe_Reserved_101 {
                    bits 32;
                    access rw;
                    hard_reset 'h0;
                }
            }
            register ccf_Probe_T_sip5_main_Probe_Reserved_102 @0x1DC {
                bytes 4;
                field ccf_Probe_T_sip5_main_Probe_Reserved_102 {
                    bits 32;
                    access rw;
                    hard_reset 'h0;
                }
            }
            register ccf_Probe_T_sip5_main_Probe_Reserved_103 @0x1E0 {
                bytes 4;
                field ccf_Probe_T_sip5_main_Probe_Reserved_103 {
                    bits 32;
                    access rw;
                    hard_reset 'h0;
                }
            }
            register ccf_Probe_T_sip5_main_Probe_Reserved_104 @0x1E4 {
                bytes 4;
                field ccf_Probe_T_sip5_main_Probe_Reserved_104 {
                    bits 32;
                    access rw;
                    hard_reset 'h0;
                }
            }
            register ccf_Probe_T_sip5_main_Probe_Reserved_105 @0x1E8 {
                bytes 4;
                field ccf_Probe_T_sip5_main_Probe_Reserved_105 {
                    bits 32;
                    access rw;
                    hard_reset 'h0;
                }
            }
            register ccf_Probe_T_sip5_main_Probe_Reserved_106 @0x1EC {
                bytes 4;
                field ccf_Probe_T_sip5_main_Probe_Reserved_106 {
                    bits 32;
                    access rw;
                    hard_reset 'h0;
                }
            }
            register ccf_Probe_T_sip5_main_Probe_Reserved_107 @0x1F0 {
                bytes 4;
                field ccf_Probe_T_sip5_main_Probe_Reserved_107 {
                    bits 32;
                    access rw;
                    hard_reset 'h0;
                }
            }
            register ccf_Probe_T_sip5_main_Probe_Reserved_108 @0x1F4 {
                bytes 4;
                field ccf_Probe_T_sip5_main_Probe_Reserved_108 {
                    bits 32;
                    access rw;
                    hard_reset 'h0;
                }
            }
            register ccf_Probe_T_sip5_main_Probe_Reserved_109 @0x1F8 {
                bytes 4;
                field ccf_Probe_T_sip5_main_Probe_Reserved_109 {
                    bits 32;
                    access rw;
                    hard_reset 'h0;
                }
            }
            register ccf_Probe_T_sip5_main_Probe_Reserved_110 @0x1FC {
                bytes 4;
                field ccf_Probe_T_sip5_main_Probe_Reserved_110 {
                    bits 32;
                    access rw;
                    hard_reset 'h0;
                }
            }
            register ccf_Probe_T_sip5_main_Probe_Reserved_111 @0x200 {
                bytes 4;
                field ccf_Probe_T_sip5_main_Probe_Reserved_111 {
                    bits 32;
                    access rw;
                    hard_reset 'h0;
                }
            }
            register ccf_Probe_T_sip5_main_Probe_Reserved_112 @0x204 {
                bytes 4;
                field ccf_Probe_T_sip5_main_Probe_Reserved_112 {
                    bits 32;
                    access rw;
                    hard_reset 'h0;
                }
            }
            register ccf_Probe_T_sip5_main_Probe_Reserved_113 @0x208 {
                bytes 4;
                field ccf_Probe_T_sip5_main_Probe_Reserved_113 {
                    bits 32;
                    access rw;
                    hard_reset 'h0;
                }
            }
            register ccf_Probe_T_sip5_main_Probe_Reserved_114 @0x20C {
                bytes 4;
                field ccf_Probe_T_sip5_main_Probe_Reserved_114 {
                    bits 32;
                    access rw;
                    hard_reset 'h0;
                }
            }
            register ccf_Probe_T_sip5_main_Probe_Reserved_115 @0x210 {
                bytes 4;
                field ccf_Probe_T_sip5_main_Probe_Reserved_115 {
                    bits 32;
                    access rw;
                    hard_reset 'h0;
                }
            }
            register ccf_Probe_T_sip5_main_Probe_Reserved_116 @0x214 {
                bytes 4;
                field ccf_Probe_T_sip5_main_Probe_Reserved_116 {
                    bits 32;
                    access rw;
                    hard_reset 'h0;
                }
            }
            register ccf_Probe_T_sip5_main_Probe_Reserved_117 @0x218 {
                bytes 4;
                field ccf_Probe_T_sip5_main_Probe_Reserved_117 {
                    bits 32;
                    access rw;
                    hard_reset 'h0;
                }
            }
            register ccf_Probe_T_sip5_main_Probe_Reserved_118 @0x21C {
                bytes 4;
                field ccf_Probe_T_sip5_main_Probe_Reserved_118 {
                    bits 32;
                    access rw;
                    hard_reset 'h0;
                }
            }
            register ccf_Probe_T_sip5_main_Probe_Reserved_119 @0x220 {
                bytes 4;
                field ccf_Probe_T_sip5_main_Probe_Reserved_119 {
                    bits 32;
                    access rw;
                    hard_reset 'h0;
                }
            }
            register ccf_Probe_T_sip5_main_Probe_Reserved_120 @0x224 {
                bytes 4;
                field ccf_Probe_T_sip5_main_Probe_Reserved_120 {
                    bits 32;
                    access rw;
                    hard_reset 'h0;
                }
            }
            register ccf_Probe_T_sip5_main_Probe_Reserved_121 @0x228 {
                bytes 4;
                field ccf_Probe_T_sip5_main_Probe_Reserved_121 {
                    bits 32;
                    access rw;
                    hard_reset 'h0;
                }
            }
            register ccf_Probe_T_sip5_main_Probe_Reserved_122 @0x22C {
                bytes 4;
                field ccf_Probe_T_sip5_main_Probe_Reserved_122 {
                    bits 32;
                    access rw;
                    hard_reset 'h0;
                }
            }
            register ccf_Probe_T_sip5_main_Probe_Reserved_123 @0x230 {
                bytes 4;
                field ccf_Probe_T_sip5_main_Probe_Reserved_123 {
                    bits 32;
                    access rw;
                    hard_reset 'h0;
                }
            }
            register ccf_Probe_T_sip5_main_Probe_Reserved_124 @0x234 {
                bytes 4;
                field ccf_Probe_T_sip5_main_Probe_Reserved_124 {
                    bits 32;
                    access rw;
                    hard_reset 'h0;
                }
            }
            register ccf_Probe_T_sip5_main_Probe_Reserved_125 @0x238 {
                bytes 4;
                field ccf_Probe_T_sip5_main_Probe_Reserved_125 {
                    bits 32;
                    access rw;
                    hard_reset 'h0;
                }
            }
            register ccf_Probe_T_sip5_main_Probe_Reserved_126 @0x23C {
                bytes 4;
                field ccf_Probe_T_sip5_main_Probe_Reserved_126 {
                    bits 32;
                    access rw;
                    hard_reset 'h0;
                }
            }
            register ccf_Probe_T_sip5_main_Probe_Reserved_127 @0x240 {
                bytes 4;
                field ccf_Probe_T_sip5_main_Probe_Reserved_127 {
                    bits 32;
                    access rw;
                    hard_reset 'h0;
                }
            }
            register ccf_Probe_T_sip5_main_Probe_Reserved_128 @0x244 {
                bytes 4;
                field ccf_Probe_T_sip5_main_Probe_Reserved_128 {
                    bits 32;
                    access rw;
                    hard_reset 'h0;
                }
            }
            register ccf_Probe_T_sip5_main_Probe_Reserved_129 @0x248 {
                bytes 4;
                field ccf_Probe_T_sip5_main_Probe_Reserved_129 {
                    bits 32;
                    access rw;
                    hard_reset 'h0;
                }
            }
            register ccf_Probe_T_sip5_main_Probe_Reserved_130 @0x24C {
                bytes 4;
                field ccf_Probe_T_sip5_main_Probe_Reserved_130 {
                    bits 32;
                    access rw;
                    hard_reset 'h0;
                }
            }
            register ccf_Probe_T_sip5_main_Probe_Reserved_131 @0x250 {
                bytes 4;
                field ccf_Probe_T_sip5_main_Probe_Reserved_131 {
                    bits 32;
                    access rw;
                    hard_reset 'h0;
                }
            }
            register ccf_Probe_T_sip5_main_Probe_Reserved_132 @0x254 {
                bytes 4;
                field ccf_Probe_T_sip5_main_Probe_Reserved_132 {
                    bits 32;
                    access rw;
                    hard_reset 'h0;
                }
            }
            register ccf_Probe_T_sip5_main_Probe_Reserved_133 @0x258 {
                bytes 4;
                field ccf_Probe_T_sip5_main_Probe_Reserved_133 {
                    bits 32;
                    access rw;
                    hard_reset 'h0;
                }
            }
            register ccf_Probe_T_sip5_main_Probe_Reserved_134 @0x25C {
                bytes 4;
                field ccf_Probe_T_sip5_main_Probe_Reserved_134 {
                    bits 32;
                    access rw;
                    hard_reset 'h0;
                }
            }
            register ccf_Probe_T_sip5_main_Probe_Reserved_135 @0x260 {
                bytes 4;
                field ccf_Probe_T_sip5_main_Probe_Reserved_135 {
                    bits 32;
                    access rw;
                    hard_reset 'h0;
                }
            }
            register ccf_Probe_T_sip5_main_Probe_Reserved_136 @0x264 {
                bytes 4;
                field ccf_Probe_T_sip5_main_Probe_Reserved_136 {
                    bits 32;
                    access rw;
                    hard_reset 'h0;
                }
            }
            register ccf_Probe_T_sip5_main_Probe_Reserved_137 @0x268 {
                bytes 4;
                field ccf_Probe_T_sip5_main_Probe_Reserved_137 {
                    bits 32;
                    access rw;
                    hard_reset 'h0;
                }
            }
            register ccf_Probe_T_sip5_main_Probe_Reserved_138 @0x26C {
                bytes 4;
                field ccf_Probe_T_sip5_main_Probe_Reserved_138 {
                    bits 32;
                    access rw;
                    hard_reset 'h0;
                }
            }
            register ccf_Probe_T_sip5_main_Probe_Reserved_139 @0x270 {
                bytes 4;
                field ccf_Probe_T_sip5_main_Probe_Reserved_139 {
                    bits 32;
                    access rw;
                    hard_reset 'h0;
                }
            }
            register ccf_Probe_T_sip5_main_Probe_Reserved_140 @0x274 {
                bytes 4;
                field ccf_Probe_T_sip5_main_Probe_Reserved_140 {
                    bits 32;
                    access rw;
                    hard_reset 'h0;
                }
            }
            register ccf_Probe_T_sip5_main_Probe_Reserved_141 @0x278 {
                bytes 4;
                field ccf_Probe_T_sip5_main_Probe_Reserved_141 {
                    bits 32;
                    access rw;
                    hard_reset 'h0;
                }
            }
            register ccf_Probe_T_sip5_main_Probe_Reserved_142 @0x27C {
                bytes 4;
                field ccf_Probe_T_sip5_main_Probe_Reserved_142 {
                    bits 32;
                    access rw;
                    hard_reset 'h0;
                }
            }
            register ccf_Probe_T_sip5_main_Probe_Reserved_143 @0x280 {
                bytes 4;
                field ccf_Probe_T_sip5_main_Probe_Reserved_143 {
                    bits 32;
                    access rw;
                    hard_reset 'h0;
                }
            }
            register ccf_Probe_T_sip5_main_Probe_Reserved_144 @0x284 {
                bytes 4;
                field ccf_Probe_T_sip5_main_Probe_Reserved_144 {
                    bits 32;
                    access rw;
                    hard_reset 'h0;
                }
            }
            register ccf_Probe_T_sip5_main_Probe_Reserved_145 @0x288 {
                bytes 4;
                field ccf_Probe_T_sip5_main_Probe_Reserved_145 {
                    bits 32;
                    access rw;
                    hard_reset 'h0;
                }
            }
            register ccf_Probe_T_sip5_main_Probe_Reserved_146 @0x28C {
                bytes 4;
                field ccf_Probe_T_sip5_main_Probe_Reserved_146 {
                    bits 32;
                    access rw;
                    hard_reset 'h0;
                }
            }
            register ccf_Probe_T_sip5_main_Probe_Reserved_147 @0x290 {
                bytes 4;
                field ccf_Probe_T_sip5_main_Probe_Reserved_147 {
                    bits 32;
                    access rw;
                    hard_reset 'h0;
                }
            }
            register ccf_Probe_T_sip5_main_Probe_Reserved_148 @0x294 {
                bytes 4;
                field ccf_Probe_T_sip5_main_Probe_Reserved_148 {
                    bits 32;
                    access rw;
                    hard_reset 'h0;
                }
            }
            register ccf_Probe_T_sip5_main_Probe_Reserved_149 @0x298 {
                bytes 4;
                field ccf_Probe_T_sip5_main_Probe_Reserved_149 {
                    bits 32;
                    access rw;
                    hard_reset 'h0;
                }
            }
            register ccf_Probe_T_sip5_main_Probe_Reserved_150 @0x29C {
                bytes 4;
                field ccf_Probe_T_sip5_main_Probe_Reserved_150 {
                    bits 32;
                    access rw;
                    hard_reset 'h0;
                }
            }
            register ccf_Probe_T_sip5_main_Probe_Reserved_151 @0x2A0 {
                bytes 4;
                field ccf_Probe_T_sip5_main_Probe_Reserved_151 {
                    bits 32;
                    access rw;
                    hard_reset 'h0;
                }
            }
            register ccf_Probe_T_sip5_main_Probe_Reserved_152 @0x2A4 {
                bytes 4;
                field ccf_Probe_T_sip5_main_Probe_Reserved_152 {
                    bits 32;
                    access rw;
                    hard_reset 'h0;
                }
            }
            register ccf_Probe_T_sip5_main_Probe_Reserved_153 @0x2A8 {
                bytes 4;
                field ccf_Probe_T_sip5_main_Probe_Reserved_153 {
                    bits 32;
                    access rw;
                    hard_reset 'h0;
                }
            }
            register ccf_Probe_T_sip5_main_Probe_Reserved_154 @0x2AC {
                bytes 4;
                field ccf_Probe_T_sip5_main_Probe_Reserved_154 {
                    bits 32;
                    access rw;
                    hard_reset 'h0;
                }
            }
            register ccf_Probe_T_sip5_main_Probe_Reserved_155 @0x2B0 {
                bytes 4;
                field ccf_Probe_T_sip5_main_Probe_Reserved_155 {
                    bits 32;
                    access rw;
                    hard_reset 'h0;
                }
            }
            register ccf_Probe_T_sip5_main_Probe_Reserved_156 @0x2B4 {
                bytes 4;
                field ccf_Probe_T_sip5_main_Probe_Reserved_156 {
                    bits 32;
                    access rw;
                    hard_reset 'h0;
                }
            }
            register ccf_Probe_T_sip5_main_Probe_Reserved_157 @0x2B8 {
                bytes 4;
                field ccf_Probe_T_sip5_main_Probe_Reserved_157 {
                    bits 32;
                    access rw;
                    hard_reset 'h0;
                }
            }
            register ccf_Probe_T_sip5_main_Probe_Reserved_158 @0x2BC {
                bytes 4;
                field ccf_Probe_T_sip5_main_Probe_Reserved_158 {
                    bits 32;
                    access rw;
                    hard_reset 'h0;
                }
            }
            register ccf_Probe_T_sip5_main_Probe_Reserved_159 @0x2C0 {
                bytes 4;
                field ccf_Probe_T_sip5_main_Probe_Reserved_159 {
                    bits 32;
                    access rw;
                    hard_reset 'h0;
                }
            }
            register ccf_Probe_T_sip5_main_Probe_Reserved_160 @0x2C4 {
                bytes 4;
                field ccf_Probe_T_sip5_main_Probe_Reserved_160 {
                    bits 32;
                    access rw;
                    hard_reset 'h0;
                }
            }
            register ccf_Probe_T_sip5_main_Probe_Reserved_161 @0x2C8 {
                bytes 4;
                field ccf_Probe_T_sip5_main_Probe_Reserved_161 {
                    bits 32;
                    access rw;
                    hard_reset 'h0;
                }
            }
            register ccf_Probe_T_sip5_main_Probe_Reserved_162 @0x2CC {
                bytes 4;
                field ccf_Probe_T_sip5_main_Probe_Reserved_162 {
                    bits 32;
                    access rw;
                    hard_reset 'h0;
                }
            }
            register ccf_Probe_T_sip5_main_Probe_Reserved_163 @0x2D0 {
                bytes 4;
                field ccf_Probe_T_sip5_main_Probe_Reserved_163 {
                    bits 32;
                    access rw;
                    hard_reset 'h0;
                }
            }
            register ccf_Probe_T_sip5_main_Probe_Reserved_164 @0x2D4 {
                bytes 4;
                field ccf_Probe_T_sip5_main_Probe_Reserved_164 {
                    bits 32;
                    access rw;
                    hard_reset 'h0;
                }
            }
            register ccf_Probe_T_sip5_main_Probe_Reserved_165 @0x2D8 {
                bytes 4;
                field ccf_Probe_T_sip5_main_Probe_Reserved_165 {
                    bits 32;
                    access rw;
                    hard_reset 'h0;
                }
            }
            register ccf_Probe_T_sip5_main_Probe_Reserved_166 @0x2DC {
                bytes 4;
                field ccf_Probe_T_sip5_main_Probe_Reserved_166 {
                    bits 32;
                    access rw;
                    hard_reset 'h0;
                }
            }
            register ccf_Probe_T_sip5_main_Probe_Reserved_167 @0x2E0 {
                bytes 4;
                field ccf_Probe_T_sip5_main_Probe_Reserved_167 {
                    bits 32;
                    access rw;
                    hard_reset 'h0;
                }
            }
            register ccf_Probe_T_sip5_main_Probe_Reserved_168 @0x2E4 {
                bytes 4;
                field ccf_Probe_T_sip5_main_Probe_Reserved_168 {
                    bits 32;
                    access rw;
                    hard_reset 'h0;
                }
            }
            register ccf_Probe_T_sip5_main_Probe_Reserved_169 @0x2E8 {
                bytes 4;
                field ccf_Probe_T_sip5_main_Probe_Reserved_169 {
                    bits 32;
                    access rw;
                    hard_reset 'h0;
                }
            }
            register ccf_Probe_T_sip5_main_Probe_Reserved_170 @0x2EC {
                bytes 4;
                field ccf_Probe_T_sip5_main_Probe_Reserved_170 {
                    bits 32;
                    access rw;
                    hard_reset 'h0;
                }
            }
            register ccf_Probe_T_sip5_main_Probe_Reserved_171 @0x2F0 {
                bytes 4;
                field ccf_Probe_T_sip5_main_Probe_Reserved_171 {
                    bits 32;
                    access rw;
                    hard_reset 'h0;
                }
            }
            register ccf_Probe_T_sip5_main_Probe_Reserved_172 @0x2F4 {
                bytes 4;
                field ccf_Probe_T_sip5_main_Probe_Reserved_172 {
                    bits 32;
                    access rw;
                    hard_reset 'h0;
                }
            }
            register ccf_Probe_T_sip5_main_Probe_Reserved_173 @0x2F8 {
                bytes 4;
                field ccf_Probe_T_sip5_main_Probe_Reserved_173 {
                    bits 32;
                    access rw;
                    hard_reset 'h0;
                }
            }
            register ccf_Probe_T_sip5_main_Probe_Reserved_174 @0x2FC {
                bytes 4;
                field ccf_Probe_T_sip5_main_Probe_Reserved_174 {
                    bits 32;
                    access rw;
                    hard_reset 'h0;
                }
            }
            register ccf_Probe_T_sip5_main_Probe_Reserved_175 @0x300 {
                bytes 4;
                field ccf_Probe_T_sip5_main_Probe_Reserved_175 {
                    bits 32;
                    access rw;
                    hard_reset 'h0;
                }
            }
            register ccf_Probe_T_sip5_main_Probe_Reserved_176 @0x304 {
                bytes 4;
                field ccf_Probe_T_sip5_main_Probe_Reserved_176 {
                    bits 32;
                    access rw;
                    hard_reset 'h0;
                }
            }
            register ccf_Probe_T_sip5_main_Probe_Reserved_177 @0x308 {
                bytes 4;
                field ccf_Probe_T_sip5_main_Probe_Reserved_177 {
                    bits 32;
                    access rw;
                    hard_reset 'h0;
                }
            }
            register ccf_Probe_T_sip5_main_Probe_Reserved_178 @0x30C {
                bytes 4;
                field ccf_Probe_T_sip5_main_Probe_Reserved_178 {
                    bits 32;
                    access rw;
                    hard_reset 'h0;
                }
            }
            register ccf_Probe_T_sip5_main_Probe_Reserved_179 @0x310 {
                bytes 4;
                field ccf_Probe_T_sip5_main_Probe_Reserved_179 {
                    bits 32;
                    access rw;
                    hard_reset 'h0;
                }
            }
            register ccf_Probe_T_sip5_main_Probe_Reserved_180 @0x314 {
                bytes 4;
                field ccf_Probe_T_sip5_main_Probe_Reserved_180 {
                    bits 32;
                    access rw;
                    hard_reset 'h0;
                }
            }
            register ccf_Probe_T_sip5_main_Probe_Reserved_181 @0x318 {
                bytes 4;
                field ccf_Probe_T_sip5_main_Probe_Reserved_181 {
                    bits 32;
                    access rw;
                    hard_reset 'h0;
                }
            }
            register ccf_Probe_T_sip5_main_Probe_Reserved_182 @0x31C {
                bytes 4;
                field ccf_Probe_T_sip5_main_Probe_Reserved_182 {
                    bits 32;
                    access rw;
                    hard_reset 'h0;
                }
            }
            register ccf_Probe_T_sip5_main_Probe_Reserved_183 @0x320 {
                bytes 4;
                field ccf_Probe_T_sip5_main_Probe_Reserved_183 {
                    bits 32;
                    access rw;
                    hard_reset 'h0;
                }
            }
            register ccf_Probe_T_sip5_main_Probe_Reserved_184 @0x324 {
                bytes 4;
                field ccf_Probe_T_sip5_main_Probe_Reserved_184 {
                    bits 32;
                    access rw;
                    hard_reset 'h0;
                }
            }
            register ccf_Probe_T_sip5_main_Probe_Reserved_185 @0x328 {
                bytes 4;
                field ccf_Probe_T_sip5_main_Probe_Reserved_185 {
                    bits 32;
                    access rw;
                    hard_reset 'h0;
                }
            }
            register ccf_Probe_T_sip5_main_Probe_Reserved_186 @0x32C {
                bytes 4;
                field ccf_Probe_T_sip5_main_Probe_Reserved_186 {
                    bits 32;
                    access rw;
                    hard_reset 'h0;
                }
            }
            register ccf_Probe_T_sip5_main_Probe_Reserved_187 @0x330 {
                bytes 4;
                field ccf_Probe_T_sip5_main_Probe_Reserved_187 {
                    bits 32;
                    access rw;
                    hard_reset 'h0;
                }
            }
            register ccf_Probe_T_sip5_main_Probe_Reserved_188 @0x334 {
                bytes 4;
                field ccf_Probe_T_sip5_main_Probe_Reserved_188 {
                    bits 32;
                    access rw;
                    hard_reset 'h0;
                }
            }
            register ccf_Probe_T_sip5_main_Probe_Reserved_189 @0x338 {
                bytes 4;
                field ccf_Probe_T_sip5_main_Probe_Reserved_189 {
                    bits 32;
                    access rw;
                    hard_reset 'h0;
                }
            }
            register ccf_Probe_T_sip5_main_Probe_Reserved_190 @0x33C {
                bytes 4;
                field ccf_Probe_T_sip5_main_Probe_Reserved_190 {
                    bits 32;
                    access rw;
                    hard_reset 'h0;
                }
            }
            register ccf_Probe_T_sip5_main_Probe_Reserved_191 @0x340 {
                bytes 4;
                field ccf_Probe_T_sip5_main_Probe_Reserved_191 {
                    bits 32;
                    access rw;
                    hard_reset 'h0;
                }
            }
            register ccf_Probe_T_sip5_main_Probe_Reserved_192 @0x344 {
                bytes 4;
                field ccf_Probe_T_sip5_main_Probe_Reserved_192 {
                    bits 32;
                    access rw;
                    hard_reset 'h0;
                }
            }
            register ccf_Probe_T_sip5_main_Probe_Reserved_193 @0x348 {
                bytes 4;
                field ccf_Probe_T_sip5_main_Probe_Reserved_193 {
                    bits 32;
                    access rw;
                    hard_reset 'h0;
                }
            }
            register ccf_Probe_T_sip5_main_Probe_Reserved_194 @0x34C {
                bytes 4;
                field ccf_Probe_T_sip5_main_Probe_Reserved_194 {
                    bits 32;
                    access rw;
                    hard_reset 'h0;
                }
            }
            register ccf_Probe_T_sip5_main_Probe_Reserved_195 @0x350 {
                bytes 4;
                field ccf_Probe_T_sip5_main_Probe_Reserved_195 {
                    bits 32;
                    access rw;
                    hard_reset 'h0;
                }
            }
            register ccf_Probe_T_sip5_main_Probe_Reserved_196 @0x354 {
                bytes 4;
                field ccf_Probe_T_sip5_main_Probe_Reserved_196 {
                    bits 32;
                    access rw;
                    hard_reset 'h0;
                }
            }
            register ccf_Probe_T_sip5_main_Probe_Reserved_197 @0x358 {
                bytes 4;
                field ccf_Probe_T_sip5_main_Probe_Reserved_197 {
                    bits 32;
                    access rw;
                    hard_reset 'h0;
                }
            }
            register ccf_Probe_T_sip5_main_Probe_Reserved_198 @0x35C {
                bytes 4;
                field ccf_Probe_T_sip5_main_Probe_Reserved_198 {
                    bits 32;
                    access rw;
                    hard_reset 'h0;
                }
            }
            register ccf_Probe_T_sip5_main_Probe_Reserved_199 @0x360 {
                bytes 4;
                field ccf_Probe_T_sip5_main_Probe_Reserved_199 {
                    bits 32;
                    access rw;
                    hard_reset 'h0;
                }
            }
            register ccf_Probe_T_sip5_main_Probe_Reserved_200 @0x364 {
                bytes 4;
                field ccf_Probe_T_sip5_main_Probe_Reserved_200 {
                    bits 32;
                    access rw;
                    hard_reset 'h0;
                }
            }
            register ccf_Probe_T_sip5_main_Probe_Reserved_201 @0x368 {
                bytes 4;
                field ccf_Probe_T_sip5_main_Probe_Reserved_201 {
                    bits 32;
                    access rw;
                    hard_reset 'h0;
                }
            }
            register ccf_Probe_T_sip5_main_Probe_Reserved_202 @0x36C {
                bytes 4;
                field ccf_Probe_T_sip5_main_Probe_Reserved_202 {
                    bits 32;
                    access rw;
                    hard_reset 'h0;
                }
            }
            register ccf_Probe_T_sip5_main_Probe_Reserved_203 @0x370 {
                bytes 4;
                field ccf_Probe_T_sip5_main_Probe_Reserved_203 {
                    bits 32;
                    access rw;
                    hard_reset 'h0;
                }
            }
            register ccf_Probe_T_sip5_main_Probe_Reserved_204 @0x374 {
                bytes 4;
                field ccf_Probe_T_sip5_main_Probe_Reserved_204 {
                    bits 32;
                    access rw;
                    hard_reset 'h0;
                }
            }
            register ccf_Probe_T_sip5_main_Probe_Reserved_205 @0x378 {
                bytes 4;
                field ccf_Probe_T_sip5_main_Probe_Reserved_205 {
                    bits 32;
                    access rw;
                    hard_reset 'h0;
                }
            }
            register ccf_Probe_T_sip5_main_Probe_Reserved_206 @0x37C {
                bytes 4;
                field ccf_Probe_T_sip5_main_Probe_Reserved_206 {
                    bits 32;
                    access rw;
                    hard_reset 'h0;
                }
            }
            register ccf_Probe_T_sip5_main_Probe_Reserved_207 @0x380 {
                bytes 4;
                field ccf_Probe_T_sip5_main_Probe_Reserved_207 {
                    bits 32;
                    access rw;
                    hard_reset 'h0;
                }
            }
            register ccf_Probe_T_sip5_main_Probe_Reserved_208 @0x384 {
                bytes 4;
                field ccf_Probe_T_sip5_main_Probe_Reserved_208 {
                    bits 32;
                    access rw;
                    hard_reset 'h0;
                }
            }
            register ccf_Probe_T_sip5_main_Probe_Reserved_209 @0x388 {
                bytes 4;
                field ccf_Probe_T_sip5_main_Probe_Reserved_209 {
                    bits 32;
                    access rw;
                    hard_reset 'h0;
                }
            }
            register ccf_Probe_T_sip5_main_Probe_Reserved_210 @0x38C {
                bytes 4;
                field ccf_Probe_T_sip5_main_Probe_Reserved_210 {
                    bits 32;
                    access rw;
                    hard_reset 'h0;
                }
            }
            register ccf_Probe_T_sip5_main_Probe_Reserved_211 @0x390 {
                bytes 4;
                field ccf_Probe_T_sip5_main_Probe_Reserved_211 {
                    bits 32;
                    access rw;
                    hard_reset 'h0;
                }
            }
            register ccf_Probe_T_sip5_main_Probe_Reserved_212 @0x394 {
                bytes 4;
                field ccf_Probe_T_sip5_main_Probe_Reserved_212 {
                    bits 32;
                    access rw;
                    hard_reset 'h0;
                }
            }
            register ccf_Probe_T_sip5_main_Probe_Reserved_213 @0x398 {
                bytes 4;
                field ccf_Probe_T_sip5_main_Probe_Reserved_213 {
                    bits 32;
                    access rw;
                    hard_reset 'h0;
                }
            }
            register ccf_Probe_T_sip5_main_Probe_Reserved_214 @0x39C {
                bytes 4;
                field ccf_Probe_T_sip5_main_Probe_Reserved_214 {
                    bits 32;
                    access rw;
                    hard_reset 'h0;
                }
            }
            register ccf_Probe_T_sip5_main_Probe_Reserved_215 @0x3A0 {
                bytes 4;
                field ccf_Probe_T_sip5_main_Probe_Reserved_215 {
                    bits 32;
                    access rw;
                    hard_reset 'h0;
                }
            }
            register ccf_Probe_T_sip5_main_Probe_Reserved_216 @0x3A4 {
                bytes 4;
                field ccf_Probe_T_sip5_main_Probe_Reserved_216 {
                    bits 32;
                    access rw;
                    hard_reset 'h0;
                }
            }
            register ccf_Probe_T_sip5_main_Probe_Reserved_217 @0x3A8 {
                bytes 4;
                field ccf_Probe_T_sip5_main_Probe_Reserved_217 {
                    bits 32;
                    access rw;
                    hard_reset 'h0;
                }
            }
            register ccf_Probe_T_sip5_main_Probe_Reserved_218 @0x3AC {
                bytes 4;
                field ccf_Probe_T_sip5_main_Probe_Reserved_218 {
                    bits 32;
                    access rw;
                    hard_reset 'h0;
                }
            }
            register ccf_Probe_T_sip5_main_Probe_Reserved_219 @0x3B0 {
                bytes 4;
                field ccf_Probe_T_sip5_main_Probe_Reserved_219 {
                    bits 32;
                    access rw;
                    hard_reset 'h0;
                }
            }
            register ccf_Probe_T_sip5_main_Probe_Reserved_220 @0x3B4 {
                bytes 4;
                field ccf_Probe_T_sip5_main_Probe_Reserved_220 {
                    bits 32;
                    access rw;
                    hard_reset 'h0;
                }
            }
            register ccf_Probe_T_sip5_main_Probe_Reserved_221 @0x3B8 {
                bytes 4;
                field ccf_Probe_T_sip5_main_Probe_Reserved_221 {
                    bits 32;
                    access rw;
                    hard_reset 'h0;
                }
            }
            register ccf_Probe_T_sip5_main_Probe_Reserved_222 @0x3BC {
                bytes 4;
                field ccf_Probe_T_sip5_main_Probe_Reserved_222 {
                    bits 32;
                    access rw;
                    hard_reset 'h0;
                }
            }
            register ccf_Probe_T_sip5_main_Probe_Reserved_223 @0x3C0 {
                bytes 4;
                field ccf_Probe_T_sip5_main_Probe_Reserved_223 {
                    bits 32;
                    access rw;
                    hard_reset 'h0;
                }
            }
            register ccf_Probe_T_sip5_main_Probe_Reserved_224 @0x3C4 {
                bytes 4;
                field ccf_Probe_T_sip5_main_Probe_Reserved_224 {
                    bits 32;
                    access rw;
                    hard_reset 'h0;
                }
            }
            register ccf_Probe_T_sip5_main_Probe_Reserved_225 @0x3C8 {
                bytes 4;
                field ccf_Probe_T_sip5_main_Probe_Reserved_225 {
                    bits 32;
                    access rw;
                    hard_reset 'h0;
                }
            }
            register ccf_Probe_T_sip5_main_Probe_Reserved_226 @0x3CC {
                bytes 4;
                field ccf_Probe_T_sip5_main_Probe_Reserved_226 {
                    bits 32;
                    access rw;
                    hard_reset 'h0;
                }
            }
            register ccf_Probe_T_sip5_main_Probe_Reserved_227 @0x3D0 {
                bytes 4;
                field ccf_Probe_T_sip5_main_Probe_Reserved_227 {
                    bits 32;
                    access rw;
                    hard_reset 'h0;
                }
            }
            register ccf_Probe_T_sip5_main_Probe_Reserved_228 @0x3D4 {
                bytes 4;
                field ccf_Probe_T_sip5_main_Probe_Reserved_228 {
                    bits 32;
                    access rw;
                    hard_reset 'h0;
                }
            }
            register ccf_Probe_T_sip5_main_Probe_Reserved_229 @0x3D8 {
                bytes 4;
                field ccf_Probe_T_sip5_main_Probe_Reserved_229 {
                    bits 32;
                    access rw;
                    hard_reset 'h0;
                }
            }
            register ccf_Probe_T_sip5_main_Probe_Reserved_230 @0x3DC {
                bytes 4;
                field ccf_Probe_T_sip5_main_Probe_Reserved_230 {
                    bits 32;
                    access rw;
                    hard_reset 'h0;
                }
            }
            register ccf_Probe_T_sip5_main_Probe_Reserved_231 @0x3E0 {
                bytes 4;
                field ccf_Probe_T_sip5_main_Probe_Reserved_231 {
                    bits 32;
                    access rw;
                    hard_reset 'h0;
                }
            }
            register ccf_Probe_T_sip5_main_Probe_Reserved_232 @0x3E4 {
                bytes 4;
                field ccf_Probe_T_sip5_main_Probe_Reserved_232 {
                    bits 32;
                    access rw;
                    hard_reset 'h0;
                }
            }
            register ccf_Probe_T_sip5_main_Probe_Reserved_233 @0x3E8 {
                bytes 4;
                field ccf_Probe_T_sip5_main_Probe_Reserved_233 {
                    bits 32;
                    access rw;
                    hard_reset 'h0;
                }
            }
            register ccf_Probe_T_sip5_main_Probe_Reserved_234 @0x3EC {
                bytes 4;
                field ccf_Probe_T_sip5_main_Probe_Reserved_234 {
                    bits 32;
                    access rw;
                    hard_reset 'h0;
                }
            }
            register ccf_Probe_T_sip5_main_Probe_Reserved_235 @0x3F0 {
                bytes 4;
                field ccf_Probe_T_sip5_main_Probe_Reserved_235 {
                    bits 32;
                    access rw;
                    hard_reset 'h0;
                }
            }
            register ccf_Probe_T_sip5_main_Probe_Reserved_236 @0x3F4 {
                bytes 4;
                field ccf_Probe_T_sip5_main_Probe_Reserved_236 {
                    bits 32;
                    access rw;
                    hard_reset 'h0;
                }
            }
            register ccf_Probe_T_sip5_main_Probe_Reserved_237 @0x3F8 {
                bytes 4;
                field ccf_Probe_T_sip5_main_Probe_Reserved_237 {
                    bits 32;
                    access rw;
                    hard_reset 'h0;
                }
            }
            register ccf_Probe_T_sip5_main_Probe_Reserved_238 @0x3FC {
                bytes 4;
                field ccf_Probe_T_sip5_main_Probe_Reserved_238 {
                    bits 32;
                    access rw;
                    hard_reset 'h0;
                }
            }
        }
        block ecf_ccf_axi_ccf_Probe_T_sip6_main_Probe @0xDA800 {
            bytes 4;
            register ccf_Probe_T_sip6_main_Probe_Id_CoreId @0x0 {
                bytes 4;
                field CORETYPEID @'h0 {
                    bits 8;
                    access ro;
                    hard_reset 'h6;
                    doc {
                        Field identifying the type of IP.
                    }
                }
                field CORECHECKSUM @'h8 {
                    bits 24;
                    access ro;
                    hard_reset 'h5a0d06;
                    doc {
                        Field containing a checksum of the parameters of the IP.
                    }
                }
            }
            register ccf_Probe_T_sip6_main_Probe_Id_RevisionId @0x4 {
                bytes 4;
                field USERID @'h0 {
                    bits 8;
                    access ro;
                    hard_reset 'h0;
                    doc {
                        Field containing a user defined value, not used anywhere inside the IP itself.
                    }
                }
                field FLEXNOCID @'h8 {
                    bits 24;
                    access ro;
                    hard_reset 'h84f8c6;
                    doc {
                        Field containing the build revision of the software used to generate the IP HDL code.
                    }
                }
            }
            register ccf_Probe_T_sip6_main_Probe_MainCtl @0x8 {
                bytes 4;
                field ERREN @'h0 {
                    access rw;
                    hard_reset 'h0;
                    doc {
                        Register field ErrEn enables the probe to send on the ObsTx output any packet with Error status, independently of filtering mechanisms, thus constituting a simple supplementary global filter.
                    }
                }
                field TRACEEN @'h1 {
                    access ro;
                    hard_reset 'h0;
                    doc {
                        Register field TraceEn enables the probe to send filtered packets (Trace) on the ObsTx observation output.
                    }
                }
                field PAYLOADEN @'h2 {
                    access rw;
                    hard_reset 'h0;
                    doc {
                        Register field PayloadEn, when set to 1, enables traces to contain headers and payload. When set ot 0, only headers are reported.
                    }
                }
                field STATEN @'h3 {
                    access rw;
                    hard_reset 'h0;
                    doc {
                        When set to 1, register field StatEn enables statistics profiling. The probe sendS statistics results to the output for signal ObsTx. All statistics counters are cleared when the StatEn bit goes from 0 to 1. When set to 0, counters are disabled.
                    }
                }
                field ALARMEN @'h4 {
                    access rw;
                    hard_reset 'h0;
                    doc {
                        When set, register field AlarmEn enables the probe to collect alarm-related information. When the register field bit is null, both TraceAlarm and StatAlarm outputs are driven to 0.
                    }
                }
                field STATCONDDUMP @'h5 {
                    access rw;
                    hard_reset 'h0;
                    doc {
                        When set, register field StatCondDump enables the dump of a statistics frame to the range of counter values set for registers StatAlarmMin, StatAlarmMax, and AlarmMode. This field also renders register StatAlarmStatus inoperative. When parameter statisticsCounterAlarm is set to False, the StatCondDump register bit is reserved.
                    }
                }
                field INTRUSIVEMODE @'h6 {
                    access ro;
                    hard_reset 'h0;
                    doc {
                        When set to 1, register field IntrusiveMode enables trace operation in Intrusive flow-control mode. When set to 0, the register  enables trace operation in Overflow flow-control mode
                    }
                }
                field FILTBYTEALWAYSCHAINABLEEN @'h7 {
                    access rw;
                    hard_reset 'h0;
                    doc {
                        When set to 0, filters are mapped to all statistic counters when counting bytes or enabled bytes. Therefore, only filter events mapped to even counters can be counted using a pair of chained counters.When set to 1, filters are mapped only to even statistic counters when counting bytes or enabled bytes. Thus events from any filter can be counted using a pair of chained counters.
                    }
                }
                doc {
                    Register MainCtl contains probe global control bits. The register has seven bit fields:Register MainCtl contains probe global control bits. The register has seven bit fields:
                }
            }
            register ccf_Probe_T_sip6_main_Probe_CfgCtl @0xC {
                bytes 4;
                field GLOBALEN @'h0 {
                    access rw;
                    hard_reset 'h0;
                }
                field ACTIVE @'h1 {
                    access ro;
                    hard_reset 'h0;
                }
            }
            register ccf_Probe_T_sip6_main_Probe_Reserved_00 @0x10 {
                bytes 4;
                field ccf_Probe_T_sip6_main_Probe_Reserved_00 {
                    bits 32;
                    access rw;
                    hard_reset 'h0;
                }
            }
            register ccf_Probe_T_sip6_main_Probe_Reserved_01 @0x14 {
                bytes 4;
                field ccf_Probe_T_sip6_main_Probe_Reserved_01 {
                    bits 32;
                    access rw;
                    hard_reset 'h0;
                }
            }
            register ccf_Probe_T_sip6_main_Probe_Reserved_02 @0x18 {
                bytes 4;
                field ccf_Probe_T_sip6_main_Probe_Reserved_02 {
                    bits 32;
                    access rw;
                    hard_reset 'h0;
                }
            }
            register ccf_Probe_T_sip6_main_Probe_Reserved_03 @0x1C {
                bytes 4;
                field ccf_Probe_T_sip6_main_Probe_Reserved_03 {
                    bits 32;
                    access rw;
                    hard_reset 'h0;
                }
            }
            register ccf_Probe_T_sip6_main_Probe_Reserved_04 @0x20 {
                bytes 4;
                field ccf_Probe_T_sip6_main_Probe_Reserved_04 {
                    bits 32;
                    access rw;
                    hard_reset 'h0;
                }
            }
            register ccf_Probe_T_sip6_main_Probe_StatPeriod @0x24 {
                bytes 4;
                field STATPERIOD @'h0 {
                    bits 5;
                    access rw;
                    hard_reset 'h0;
                    doc {
                        Register StatPeriod is a 5-bit register that sets a period, within a range of 2 cycles to 2 gigacycles, during which statistics are collected before being dumped automatically. Setting the register implicitly enables automatic mode operation for statistics collection. The period is calculated with the formula: N_Cycle = 2**StatPeriodWhen register StatPeriod is set to its default value 0, automatic dump mode is disabled, and register StatGo is activated for manual mode operation. Note: When parameter statisticsCollection is set to False, StatPeriod is reserved.
                    }
                }
            }
            register ccf_Probe_T_sip6_main_Probe_StatGo @0x28 {
                bytes 4;
                field STATGO @'h0 {
                    access w1c;
                    hard_reset 'h0;
                    doc {
                        Writing a 1 to the 1-bit pulse register StatGo generates a statistics dump.The register is active when statistics collection operates in manual mode, that is, when register StatPeriod is set to 0.NOTE  The written value is not stored in StatGo. A read always returns 0.
                    }
                }
            }
            register ccf_Probe_T_sip6_main_Probe_StatAlarmMin @0x2C {
                bytes 4;
                field STATALARMMIN @'h0 {
                    bits 22;
                    access rw;
                    hard_reset 'h0;
                    doc {
                        Register StatAlarmMin contains the minimum count value used in statistics alarm comparisons. The number of bits is equal to twice the value set forparameter wStatisticsCounter. When parameter statisticsCounterAlarm is set to False, StatAlarmMin is reserved.
                    }
                }
            }
            register ccf_Probe_T_sip6_main_Probe_StatAlarmMax @0x30 {
                bytes 4;
                field STATALARMMAX @'h0 {
                    bits 22;
                    access rw;
                    hard_reset 'h0;
                    doc {
                        Register StatAlarmMax contains the maximum count value used in statistics alarm comparisons.The number of bits is equal to twice the value set for parameter wStatisticsCounter. When parameter statisticsCounterAlarm is set to False, StatAlarmMax is reserved.
                    }
                }
            }
            register ccf_Probe_T_sip6_main_Probe_StatAlarmStatus @0x34 {
                bytes 4;
                field STATALARMSTATUS @'h0 {
                    access ro;
                    hard_reset 'h0;
                    doc {
                        Register StatAlarmStatus is a read-only 1-bit register indicating that at least one statistics counter has exceeded the programmed values for registers StatAlarmMin or StatAlarmMax. Output signal StatAlarm is equal to the values stored in register MainCtl fields StatAlarmStatus and AlarmEn. When parameter statisticsCounterAlarm is set to False, StatAlarmStatus is reserved.
                    }
                }
            }
            register ccf_Probe_T_sip6_main_Probe_StatAlarmClr @0x38 {
                bytes 4;
                field STATALARMCLR @'h0 {
                    access w1c;
                    hard_reset 'h0;
                    doc {
                        Register StatAlarmClr is a 1-bit register. Writing a 1 to this register clears the StatAlarmStatus register bit.When parameter statisticsCounterAlarm is set to False, StatAlarmClr is reserved.NOTE  The written value is not stored in StatAlarmClr. A read always returns 0.
                    }
                }
            }
            register ccf_Probe_T_sip6_main_Probe_StatAlarmEn @0x3C {
                bytes 4;
                field STATALARMEN @'h0 {
                    access rw;
                    hard_reset 'h1;
                    doc {
                        Register StatAlarmEn is a 1-bit register. When set to 0 it masks StatAlarm and CtiTrigOut(1) signal interrupts.
                    }
                }
            }
            register ccf_Probe_T_sip6_main_Probe_Reserved_05 @0x40 {
                bytes 4;
                field ccf_Probe_T_sip6_main_Probe_Reserved_05 {
                    bits 32;
                    access rw;
                    hard_reset 'h0;
                }
            }
            register ccf_Probe_T_sip6_main_Probe_Reserved_06 @0x44 {
                bytes 4;
                field ccf_Probe_T_sip6_main_Probe_Reserved_06 {
                    bits 32;
                    access rw;
                    hard_reset 'h0;
                }
            }
            register ccf_Probe_T_sip6_main_Probe_Reserved_07 @0x48 {
                bytes 4;
                field ccf_Probe_T_sip6_main_Probe_Reserved_07 {
                    bits 32;
                    access rw;
                    hard_reset 'h0;
                }
            }
            register ccf_Probe_T_sip6_main_Probe_Reserved_08 @0x4C {
                bytes 4;
                field ccf_Probe_T_sip6_main_Probe_Reserved_08 {
                    bits 32;
                    access rw;
                    hard_reset 'h0;
                }
            }
            register ccf_Probe_T_sip6_main_Probe_Reserved_09 @0x50 {
                bytes 4;
                field ccf_Probe_T_sip6_main_Probe_Reserved_09 {
                    bits 32;
                    access rw;
                    hard_reset 'h0;
                }
            }
            register ccf_Probe_T_sip6_main_Probe_Reserved_10 @0x54 {
                bytes 4;
                field ccf_Probe_T_sip6_main_Probe_Reserved_10 {
                    bits 32;
                    access rw;
                    hard_reset 'h0;
                }
            }
            register ccf_Probe_T_sip6_main_Probe_Reserved_11 @0x58 {
                bytes 4;
                field ccf_Probe_T_sip6_main_Probe_Reserved_11 {
                    bits 32;
                    access rw;
                    hard_reset 'h0;
                }
            }
            register ccf_Probe_T_sip6_main_Probe_Reserved_12 @0x5C {
                bytes 4;
                field ccf_Probe_T_sip6_main_Probe_Reserved_12 {
                    bits 32;
                    access rw;
                    hard_reset 'h0;
                }
            }
            register ccf_Probe_T_sip6_main_Probe_Reserved_13 @0x60 {
                bytes 4;
                field ccf_Probe_T_sip6_main_Probe_Reserved_13 {
                    bits 32;
                    access rw;
                    hard_reset 'h0;
                }
            }
            register ccf_Probe_T_sip6_main_Probe_Reserved_14 @0x64 {
                bytes 4;
                field ccf_Probe_T_sip6_main_Probe_Reserved_14 {
                    bits 32;
                    access rw;
                    hard_reset 'h0;
                }
            }
            register ccf_Probe_T_sip6_main_Probe_Reserved_15 @0x68 {
                bytes 4;
                field ccf_Probe_T_sip6_main_Probe_Reserved_15 {
                    bits 32;
                    access rw;
                    hard_reset 'h0;
                }
            }
            register ccf_Probe_T_sip6_main_Probe_Reserved_16 @0x6C {
                bytes 4;
                field ccf_Probe_T_sip6_main_Probe_Reserved_16 {
                    bits 32;
                    access rw;
                    hard_reset 'h0;
                }
            }
            register ccf_Probe_T_sip6_main_Probe_Reserved_17 @0x70 {
                bytes 4;
                field ccf_Probe_T_sip6_main_Probe_Reserved_17 {
                    bits 32;
                    access rw;
                    hard_reset 'h0;
                }
            }
            register ccf_Probe_T_sip6_main_Probe_Reserved_18 @0x74 {
                bytes 4;
                field ccf_Probe_T_sip6_main_Probe_Reserved_18 {
                    bits 32;
                    access rw;
                    hard_reset 'h0;
                }
            }
            register ccf_Probe_T_sip6_main_Probe_Reserved_19 @0x78 {
                bytes 4;
                field ccf_Probe_T_sip6_main_Probe_Reserved_19 {
                    bits 32;
                    access rw;
                    hard_reset 'h0;
                }
            }
            register ccf_Probe_T_sip6_main_Probe_Reserved_20 @0x7C {
                bytes 4;
                field ccf_Probe_T_sip6_main_Probe_Reserved_20 {
                    bits 32;
                    access rw;
                    hard_reset 'h0;
                }
            }
            register ccf_Probe_T_sip6_main_Probe_Reserved_21 @0x80 {
                bytes 4;
                field ccf_Probe_T_sip6_main_Probe_Reserved_21 {
                    bits 32;
                    access rw;
                    hard_reset 'h0;
                }
            }
            register ccf_Probe_T_sip6_main_Probe_Reserved_22 @0x84 {
                bytes 4;
                field ccf_Probe_T_sip6_main_Probe_Reserved_22 {
                    bits 32;
                    access rw;
                    hard_reset 'h0;
                }
            }
            register ccf_Probe_T_sip6_main_Probe_Reserved_23 @0x88 {
                bytes 4;
                field ccf_Probe_T_sip6_main_Probe_Reserved_23 {
                    bits 32;
                    access rw;
                    hard_reset 'h0;
                }
            }
            register ccf_Probe_T_sip6_main_Probe_Reserved_24 @0x8C {
                bytes 4;
                field ccf_Probe_T_sip6_main_Probe_Reserved_24 {
                    bits 32;
                    access rw;
                    hard_reset 'h0;
                }
            }
            register ccf_Probe_T_sip6_main_Probe_Reserved_25 @0x90 {
                bytes 4;
                field ccf_Probe_T_sip6_main_Probe_Reserved_25 {
                    bits 32;
                    access rw;
                    hard_reset 'h0;
                }
            }
            register ccf_Probe_T_sip6_main_Probe_Reserved_26 @0x94 {
                bytes 4;
                field ccf_Probe_T_sip6_main_Probe_Reserved_26 {
                    bits 32;
                    access rw;
                    hard_reset 'h0;
                }
            }
            register ccf_Probe_T_sip6_main_Probe_Reserved_27 @0x98 {
                bytes 4;
                field ccf_Probe_T_sip6_main_Probe_Reserved_27 {
                    bits 32;
                    access rw;
                    hard_reset 'h0;
                }
            }
            register ccf_Probe_T_sip6_main_Probe_Reserved_28 @0x9C {
                bytes 4;
                field ccf_Probe_T_sip6_main_Probe_Reserved_28 {
                    bits 32;
                    access rw;
                    hard_reset 'h0;
                }
            }
            register ccf_Probe_T_sip6_main_Probe_Reserved_29 @0xA0 {
                bytes 4;
                field ccf_Probe_T_sip6_main_Probe_Reserved_29 {
                    bits 32;
                    access rw;
                    hard_reset 'h0;
                }
            }
            register ccf_Probe_T_sip6_main_Probe_Reserved_30 @0xA4 {
                bytes 4;
                field ccf_Probe_T_sip6_main_Probe_Reserved_30 {
                    bits 32;
                    access rw;
                    hard_reset 'h0;
                }
            }
            register ccf_Probe_T_sip6_main_Probe_Reserved_31 @0xA8 {
                bytes 4;
                field ccf_Probe_T_sip6_main_Probe_Reserved_31 {
                    bits 32;
                    access rw;
                    hard_reset 'h0;
                }
            }
            register ccf_Probe_T_sip6_main_Probe_Reserved_32 @0xAC {
                bytes 4;
                field ccf_Probe_T_sip6_main_Probe_Reserved_32 {
                    bits 32;
                    access rw;
                    hard_reset 'h0;
                }
            }
            register ccf_Probe_T_sip6_main_Probe_Reserved_33 @0xB0 {
                bytes 4;
                field ccf_Probe_T_sip6_main_Probe_Reserved_33 {
                    bits 32;
                    access rw;
                    hard_reset 'h0;
                }
            }
            register ccf_Probe_T_sip6_main_Probe_Reserved_34 @0xB4 {
                bytes 4;
                field ccf_Probe_T_sip6_main_Probe_Reserved_34 {
                    bits 32;
                    access rw;
                    hard_reset 'h0;
                }
            }
            register ccf_Probe_T_sip6_main_Probe_Reserved_35 @0xB8 {
                bytes 4;
                field ccf_Probe_T_sip6_main_Probe_Reserved_35 {
                    bits 32;
                    access rw;
                    hard_reset 'h0;
                }
            }
            register ccf_Probe_T_sip6_main_Probe_Reserved_36 @0xBC {
                bytes 4;
                field ccf_Probe_T_sip6_main_Probe_Reserved_36 {
                    bits 32;
                    access rw;
                    hard_reset 'h0;
                }
            }
            register ccf_Probe_T_sip6_main_Probe_Reserved_37 @0xC0 {
                bytes 4;
                field ccf_Probe_T_sip6_main_Probe_Reserved_37 {
                    bits 32;
                    access rw;
                    hard_reset 'h0;
                }
            }
            register ccf_Probe_T_sip6_main_Probe_Reserved_38 @0xC4 {
                bytes 4;
                field ccf_Probe_T_sip6_main_Probe_Reserved_38 {
                    bits 32;
                    access rw;
                    hard_reset 'h0;
                }
            }
            register ccf_Probe_T_sip6_main_Probe_Reserved_39 @0xC8 {
                bytes 4;
                field ccf_Probe_T_sip6_main_Probe_Reserved_39 {
                    bits 32;
                    access rw;
                    hard_reset 'h0;
                }
            }
            register ccf_Probe_T_sip6_main_Probe_Reserved_40 @0xCC {
                bytes 4;
                field ccf_Probe_T_sip6_main_Probe_Reserved_40 {
                    bits 32;
                    access rw;
                    hard_reset 'h0;
                }
            }
            register ccf_Probe_T_sip6_main_Probe_Reserved_41 @0xD0 {
                bytes 4;
                field ccf_Probe_T_sip6_main_Probe_Reserved_41 {
                    bits 32;
                    access rw;
                    hard_reset 'h0;
                }
            }
            register ccf_Probe_T_sip6_main_Probe_Reserved_42 @0xD4 {
                bytes 4;
                field ccf_Probe_T_sip6_main_Probe_Reserved_42 {
                    bits 32;
                    access rw;
                    hard_reset 'h0;
                }
            }
            register ccf_Probe_T_sip6_main_Probe_Reserved_43 @0xD8 {
                bytes 4;
                field ccf_Probe_T_sip6_main_Probe_Reserved_43 {
                    bits 32;
                    access rw;
                    hard_reset 'h0;
                }
            }
            register ccf_Probe_T_sip6_main_Probe_Reserved_44 @0xDC {
                bytes 4;
                field ccf_Probe_T_sip6_main_Probe_Reserved_44 {
                    bits 32;
                    access rw;
                    hard_reset 'h0;
                }
            }
            register ccf_Probe_T_sip6_main_Probe_Reserved_45 @0xE0 {
                bytes 4;
                field ccf_Probe_T_sip6_main_Probe_Reserved_45 {
                    bits 32;
                    access rw;
                    hard_reset 'h0;
                }
            }
            register ccf_Probe_T_sip6_main_Probe_Reserved_46 @0xE4 {
                bytes 4;
                field ccf_Probe_T_sip6_main_Probe_Reserved_46 {
                    bits 32;
                    access rw;
                    hard_reset 'h0;
                }
            }
            register ccf_Probe_T_sip6_main_Probe_Reserved_47 @0xE8 {
                bytes 4;
                field ccf_Probe_T_sip6_main_Probe_Reserved_47 {
                    bits 32;
                    access rw;
                    hard_reset 'h0;
                }
            }
            register ccf_Probe_T_sip6_main_Probe_Reserved_48 @0xEC {
                bytes 4;
                field ccf_Probe_T_sip6_main_Probe_Reserved_48 {
                    bits 32;
                    access rw;
                    hard_reset 'h0;
                }
            }
            register ccf_Probe_T_sip6_main_Probe_Reserved_49 @0xF0 {
                bytes 4;
                field ccf_Probe_T_sip6_main_Probe_Reserved_49 {
                    bits 32;
                    access rw;
                    hard_reset 'h0;
                }
            }
            register ccf_Probe_T_sip6_main_Probe_Reserved_50 @0xF4 {
                bytes 4;
                field ccf_Probe_T_sip6_main_Probe_Reserved_50 {
                    bits 32;
                    access rw;
                    hard_reset 'h0;
                }
            }
            register ccf_Probe_T_sip6_main_Probe_Reserved_51 @0xF8 {
                bytes 4;
                field ccf_Probe_T_sip6_main_Probe_Reserved_51 {
                    bits 32;
                    access rw;
                    hard_reset 'h0;
                }
            }
            register ccf_Probe_T_sip6_main_Probe_Reserved_52 @0xFC {
                bytes 4;
                field ccf_Probe_T_sip6_main_Probe_Reserved_52 {
                    bits 32;
                    access rw;
                    hard_reset 'h0;
                }
            }
            register ccf_Probe_T_sip6_main_Probe_Reserved_53 @0x100 {
                bytes 4;
                field ccf_Probe_T_sip6_main_Probe_Reserved_53 {
                    bits 32;
                    access rw;
                    hard_reset 'h0;
                }
            }
            register ccf_Probe_T_sip6_main_Probe_Reserved_54 @0x104 {
                bytes 4;
                field ccf_Probe_T_sip6_main_Probe_Reserved_54 {
                    bits 32;
                    access rw;
                    hard_reset 'h0;
                }
            }
            register ccf_Probe_T_sip6_main_Probe_Reserved_55 @0x108 {
                bytes 4;
                field ccf_Probe_T_sip6_main_Probe_Reserved_55 {
                    bits 32;
                    access rw;
                    hard_reset 'h0;
                }
            }
            register ccf_Probe_T_sip6_main_Probe_Reserved_56 @0x10C {
                bytes 4;
                field ccf_Probe_T_sip6_main_Probe_Reserved_56 {
                    bits 32;
                    access rw;
                    hard_reset 'h0;
                }
            }
            register ccf_Probe_T_sip6_main_Probe_Reserved_57 @0x110 {
                bytes 4;
                field ccf_Probe_T_sip6_main_Probe_Reserved_57 {
                    bits 32;
                    access rw;
                    hard_reset 'h0;
                }
            }
            register ccf_Probe_T_sip6_main_Probe_Reserved_58 @0x114 {
                bytes 4;
                field ccf_Probe_T_sip6_main_Probe_Reserved_58 {
                    bits 32;
                    access rw;
                    hard_reset 'h0;
                }
            }
            register ccf_Probe_T_sip6_main_Probe_Reserved_59 @0x118 {
                bytes 4;
                field ccf_Probe_T_sip6_main_Probe_Reserved_59 {
                    bits 32;
                    access rw;
                    hard_reset 'h0;
                }
            }
            register ccf_Probe_T_sip6_main_Probe_Reserved_60 @0x11C {
                bytes 4;
                field ccf_Probe_T_sip6_main_Probe_Reserved_60 {
                    bits 32;
                    access rw;
                    hard_reset 'h0;
                }
            }
            register ccf_Probe_T_sip6_main_Probe_Reserved_61 @0x120 {
                bytes 4;
                field ccf_Probe_T_sip6_main_Probe_Reserved_61 {
                    bits 32;
                    access rw;
                    hard_reset 'h0;
                }
            }
            register ccf_Probe_T_sip6_main_Probe_Reserved_62 @0x124 {
                bytes 4;
                field ccf_Probe_T_sip6_main_Probe_Reserved_62 {
                    bits 32;
                    access rw;
                    hard_reset 'h0;
                }
            }
            register ccf_Probe_T_sip6_main_Probe_Reserved_63 @0x128 {
                bytes 4;
                field ccf_Probe_T_sip6_main_Probe_Reserved_63 {
                    bits 32;
                    access rw;
                    hard_reset 'h0;
                }
            }
            register ccf_Probe_T_sip6_main_Probe_Reserved_64 @0x12C {
                bytes 4;
                field ccf_Probe_T_sip6_main_Probe_Reserved_64 {
                    bits 32;
                    access rw;
                    hard_reset 'h0;
                }
            }
            register ccf_Probe_T_sip6_main_Probe_Reserved_65 @0x130 {
                bytes 4;
                field ccf_Probe_T_sip6_main_Probe_Reserved_65 {
                    bits 32;
                    access rw;
                    hard_reset 'h0;
                }
            }
            register ccf_Probe_T_sip6_main_Probe_Reserved_66 @0x134 {
                bytes 4;
                field ccf_Probe_T_sip6_main_Probe_Reserved_66 {
                    bits 32;
                    access rw;
                    hard_reset 'h0;
                }
            }
            register ccf_Probe_T_sip6_main_Probe_Counters_0_Src @0x138 {
                bytes 4;
                field INTEVENT @'h0 {
                    bits 5;
                    access rw;
                    hard_reset 'h0;
                    enum { OFF = 0, CYCLE = 1, IDLE = 2, XFER = 3, BUSY = 4, WAIT = 5, PKT = 6, LUT = 7, BYTE = 8, PRESS0 = 9, PRESS1 = 10, PRESS2 = 11, FILT0 = 12, FILT1 = 13, FILT2 = 14, FILT3 = 15, CHAIN = 16, LUT_BYTE_EN = 17, LUT_BYTE = 18, FILT_BYTE_EN = 19, FILT_BYTE = 20, PRESS3 = 21, PRESS4 = 22, PRESS5 = 23, PRESS6 = 24, RSV_0 = 25, RSV_1 = 26, RSV_2 = 27, RSV_3 = 28, RSV_4 = 29, RSV_5 = 30, RSV_6 = 31 };
                    doc {
                        Internal packet event
                    }
                }
                field EXTEVENT @'h5 {
                    access rw;
                    hard_reset 'h0;
                    doc {
                        When greater than 0, the entire register value is used to select an external hardware event source. The index of the external event is equal to {ExtEvent,IntEvent}.
                    }
                }
                doc {
                    Register CntSrc indicates the event source used to increment the counter. Unassigned values (non-existing Press level or ExtEvent index, or unimplemented Filter) are equivalent to OFF.
	Register CntSrc indicates the event source used to increment the counter. Unassigned values (non-existing Press level or ExtEvent index, or unimplemented Filter) are equivalent to OFF.
	
                }
            }
            register ccf_Probe_T_sip6_main_Probe_Counters_0_AlarmMode @0x13C {
                bytes 4;
                field COUNTERS_0_ALARMMODE @'h0 {
                    bits 2;
                    access rw;
                    hard_reset 'h0;
                    enum { OFF = 0, MIN = 1, MAX = 2, MIN_MAX = 3 };
                    doc {
                        Register AlarmMode is a 2-bit register that is present when parameter statisticsCounterAlarm is set to True. The register defines the statistics-alarm behavior of the counter.
                    }
                }
            }
            register ccf_Probe_T_sip6_main_Probe_Counters_0_Val @0x140 {
                bytes 4;
                field COUNTERS_0_VAL @'h0 {
                    bits 11;
                    access ro;
                    hard_reset 'h0;
                    doc {
                        Register Val is a read-only register that is always present. The register containsthe statistics counter value either pending StatAlarm output, or when statisticscollection is suspended subsequent to triggers or signal statSuspend.
                    }
                }
            }
            register ccf_Probe_T_sip6_main_Probe_Reserved_67 @0x144 {
                bytes 4;
                field ccf_Probe_T_sip6_main_Probe_Reserved_67 {
                    bits 32;
                    access rw;
                    hard_reset 'h0;
                }
            }
            register ccf_Probe_T_sip6_main_Probe_Reserved_68 @0x148 {
                bytes 4;
                field ccf_Probe_T_sip6_main_Probe_Reserved_68 {
                    bits 32;
                    access rw;
                    hard_reset 'h0;
                }
            }
            register ccf_Probe_T_sip6_main_Probe_Counters_1_Src @0x14C {
                bytes 4;
                field INTEVENT @'h0 {
                    bits 5;
                    access rw;
                    hard_reset 'h0;
                    enum { OFF = 0, CYCLE = 1, IDLE = 2, XFER = 3, BUSY = 4, WAIT = 5, PKT = 6, LUT = 7, BYTE = 8, PRESS0 = 9, PRESS1 = 10, PRESS2 = 11, FILT0 = 12, FILT1 = 13, FILT2 = 14, FILT3 = 15, CHAIN = 16, LUT_BYTE_EN = 17, LUT_BYTE = 18, FILT_BYTE_EN = 19, FILT_BYTE = 20, PRESS3 = 21, PRESS4 = 22, PRESS5 = 23, PRESS6 = 24, RSV_0 = 25, RSV_1 = 26, RSV_2 = 27, RSV_3 = 28, RSV_4 = 29, RSV_5 = 30, RSV_6 = 31 };
                    doc {
                        Internal packet event
                    }
                }
                field EXTEVENT @'h5 {
                    access rw;
                    hard_reset 'h0;
                    doc {
                        When greater than 0, the entire register value is used to select an external hardware event source. The index of the external event is equal to {ExtEvent,IntEvent}.
                    }
                }
                doc {
                    Register CntSrc indicates the event source used to increment the counter. Unassigned values (non-existing Press level or ExtEvent index, or unimplemented Filter) are equivalent to OFF.
	Register CntSrc indicates the event source used to increment the counter. Unassigned values (non-existing Press level or ExtEvent index, or unimplemented Filter) are equivalent to OFF.
	
                }
            }
            register ccf_Probe_T_sip6_main_Probe_Counters_1_AlarmMode @0x150 {
                bytes 4;
                field COUNTERS_1_ALARMMODE @'h0 {
                    bits 2;
                    access rw;
                    hard_reset 'h0;
                    enum { OFF = 0, MIN = 1, MAX = 2, MIN_MAX = 3 };
                    doc {
                        Register AlarmMode is a 2-bit register that is present when parameter statisticsCounterAlarm is set to True. The register defines the statistics-alarm behavior of the counter.
                    }
                }
            }
            register ccf_Probe_T_sip6_main_Probe_Counters_1_Val @0x154 {
                bytes 4;
                field COUNTERS_1_VAL @'h0 {
                    bits 11;
                    access ro;
                    hard_reset 'h0;
                    doc {
                        Register Val is a read-only register that is always present. The register containsthe statistics counter value either pending StatAlarm output, or when statisticscollection is suspended subsequent to triggers or signal statSuspend.
                    }
                }
            }
            register ccf_Probe_T_sip6_main_Probe_Reserved_69 @0x158 {
                bytes 4;
                field ccf_Probe_T_sip6_main_Probe_Reserved_69 {
                    bits 32;
                    access rw;
                    hard_reset 'h0;
                }
            }
            register ccf_Probe_T_sip6_main_Probe_Reserved_70 @0x15C {
                bytes 4;
                field ccf_Probe_T_sip6_main_Probe_Reserved_70 {
                    bits 32;
                    access rw;
                    hard_reset 'h0;
                }
            }
            register ccf_Probe_T_sip6_main_Probe_Reserved_71 @0x160 {
                bytes 4;
                field ccf_Probe_T_sip6_main_Probe_Reserved_71 {
                    bits 32;
                    access rw;
                    hard_reset 'h0;
                }
            }
            register ccf_Probe_T_sip6_main_Probe_Reserved_72 @0x164 {
                bytes 4;
                field ccf_Probe_T_sip6_main_Probe_Reserved_72 {
                    bits 32;
                    access rw;
                    hard_reset 'h0;
                }
            }
            register ccf_Probe_T_sip6_main_Probe_Reserved_73 @0x168 {
                bytes 4;
                field ccf_Probe_T_sip6_main_Probe_Reserved_73 {
                    bits 32;
                    access rw;
                    hard_reset 'h0;
                }
            }
            register ccf_Probe_T_sip6_main_Probe_Reserved_74 @0x16C {
                bytes 4;
                field ccf_Probe_T_sip6_main_Probe_Reserved_74 {
                    bits 32;
                    access rw;
                    hard_reset 'h0;
                }
            }
            register ccf_Probe_T_sip6_main_Probe_Reserved_75 @0x170 {
                bytes 4;
                field ccf_Probe_T_sip6_main_Probe_Reserved_75 {
                    bits 32;
                    access rw;
                    hard_reset 'h0;
                }
            }
            register ccf_Probe_T_sip6_main_Probe_Reserved_76 @0x174 {
                bytes 4;
                field ccf_Probe_T_sip6_main_Probe_Reserved_76 {
                    bits 32;
                    access rw;
                    hard_reset 'h0;
                }
            }
            register ccf_Probe_T_sip6_main_Probe_Reserved_77 @0x178 {
                bytes 4;
                field ccf_Probe_T_sip6_main_Probe_Reserved_77 {
                    bits 32;
                    access rw;
                    hard_reset 'h0;
                }
            }
            register ccf_Probe_T_sip6_main_Probe_Reserved_78 @0x17C {
                bytes 4;
                field ccf_Probe_T_sip6_main_Probe_Reserved_78 {
                    bits 32;
                    access rw;
                    hard_reset 'h0;
                }
            }
            register ccf_Probe_T_sip6_main_Probe_Reserved_79 @0x180 {
                bytes 4;
                field ccf_Probe_T_sip6_main_Probe_Reserved_79 {
                    bits 32;
                    access rw;
                    hard_reset 'h0;
                }
            }
            register ccf_Probe_T_sip6_main_Probe_Reserved_80 @0x184 {
                bytes 4;
                field ccf_Probe_T_sip6_main_Probe_Reserved_80 {
                    bits 32;
                    access rw;
                    hard_reset 'h0;
                }
            }
            register ccf_Probe_T_sip6_main_Probe_Reserved_81 @0x188 {
                bytes 4;
                field ccf_Probe_T_sip6_main_Probe_Reserved_81 {
                    bits 32;
                    access rw;
                    hard_reset 'h0;
                }
            }
            register ccf_Probe_T_sip6_main_Probe_Reserved_82 @0x18C {
                bytes 4;
                field ccf_Probe_T_sip6_main_Probe_Reserved_82 {
                    bits 32;
                    access rw;
                    hard_reset 'h0;
                }
            }
            register ccf_Probe_T_sip6_main_Probe_Reserved_83 @0x190 {
                bytes 4;
                field ccf_Probe_T_sip6_main_Probe_Reserved_83 {
                    bits 32;
                    access rw;
                    hard_reset 'h0;
                }
            }
            register ccf_Probe_T_sip6_main_Probe_Reserved_84 @0x194 {
                bytes 4;
                field ccf_Probe_T_sip6_main_Probe_Reserved_84 {
                    bits 32;
                    access rw;
                    hard_reset 'h0;
                }
            }
            register ccf_Probe_T_sip6_main_Probe_Reserved_85 @0x198 {
                bytes 4;
                field ccf_Probe_T_sip6_main_Probe_Reserved_85 {
                    bits 32;
                    access rw;
                    hard_reset 'h0;
                }
            }
            register ccf_Probe_T_sip6_main_Probe_Reserved_86 @0x19C {
                bytes 4;
                field ccf_Probe_T_sip6_main_Probe_Reserved_86 {
                    bits 32;
                    access rw;
                    hard_reset 'h0;
                }
            }
            register ccf_Probe_T_sip6_main_Probe_Reserved_87 @0x1A0 {
                bytes 4;
                field ccf_Probe_T_sip6_main_Probe_Reserved_87 {
                    bits 32;
                    access rw;
                    hard_reset 'h0;
                }
            }
            register ccf_Probe_T_sip6_main_Probe_Reserved_88 @0x1A4 {
                bytes 4;
                field ccf_Probe_T_sip6_main_Probe_Reserved_88 {
                    bits 32;
                    access rw;
                    hard_reset 'h0;
                }
            }
            register ccf_Probe_T_sip6_main_Probe_Reserved_89 @0x1A8 {
                bytes 4;
                field ccf_Probe_T_sip6_main_Probe_Reserved_89 {
                    bits 32;
                    access rw;
                    hard_reset 'h0;
                }
            }
            register ccf_Probe_T_sip6_main_Probe_Reserved_90 @0x1AC {
                bytes 4;
                field ccf_Probe_T_sip6_main_Probe_Reserved_90 {
                    bits 32;
                    access rw;
                    hard_reset 'h0;
                }
            }
            register ccf_Probe_T_sip6_main_Probe_Reserved_91 @0x1B0 {
                bytes 4;
                field ccf_Probe_T_sip6_main_Probe_Reserved_91 {
                    bits 32;
                    access rw;
                    hard_reset 'h0;
                }
            }
            register ccf_Probe_T_sip6_main_Probe_Reserved_92 @0x1B4 {
                bytes 4;
                field ccf_Probe_T_sip6_main_Probe_Reserved_92 {
                    bits 32;
                    access rw;
                    hard_reset 'h0;
                }
            }
            register ccf_Probe_T_sip6_main_Probe_Reserved_93 @0x1B8 {
                bytes 4;
                field ccf_Probe_T_sip6_main_Probe_Reserved_93 {
                    bits 32;
                    access rw;
                    hard_reset 'h0;
                }
            }
            register ccf_Probe_T_sip6_main_Probe_Reserved_94 @0x1BC {
                bytes 4;
                field ccf_Probe_T_sip6_main_Probe_Reserved_94 {
                    bits 32;
                    access rw;
                    hard_reset 'h0;
                }
            }
            register ccf_Probe_T_sip6_main_Probe_Reserved_95 @0x1C0 {
                bytes 4;
                field ccf_Probe_T_sip6_main_Probe_Reserved_95 {
                    bits 32;
                    access rw;
                    hard_reset 'h0;
                }
            }
            register ccf_Probe_T_sip6_main_Probe_Reserved_96 @0x1C4 {
                bytes 4;
                field ccf_Probe_T_sip6_main_Probe_Reserved_96 {
                    bits 32;
                    access rw;
                    hard_reset 'h0;
                }
            }
            register ccf_Probe_T_sip6_main_Probe_Reserved_97 @0x1C8 {
                bytes 4;
                field ccf_Probe_T_sip6_main_Probe_Reserved_97 {
                    bits 32;
                    access rw;
                    hard_reset 'h0;
                }
            }
            register ccf_Probe_T_sip6_main_Probe_Reserved_98 @0x1CC {
                bytes 4;
                field ccf_Probe_T_sip6_main_Probe_Reserved_98 {
                    bits 32;
                    access rw;
                    hard_reset 'h0;
                }
            }
            register ccf_Probe_T_sip6_main_Probe_Reserved_99 @0x1D0 {
                bytes 4;
                field ccf_Probe_T_sip6_main_Probe_Reserved_99 {
                    bits 32;
                    access rw;
                    hard_reset 'h0;
                }
            }
            register ccf_Probe_T_sip6_main_Probe_Reserved_100 @0x1D4 {
                bytes 4;
                field ccf_Probe_T_sip6_main_Probe_Reserved_100 {
                    bits 32;
                    access rw;
                    hard_reset 'h0;
                }
            }
            register ccf_Probe_T_sip6_main_Probe_Reserved_101 @0x1D8 {
                bytes 4;
                field ccf_Probe_T_sip6_main_Probe_Reserved_101 {
                    bits 32;
                    access rw;
                    hard_reset 'h0;
                }
            }
            register ccf_Probe_T_sip6_main_Probe_Reserved_102 @0x1DC {
                bytes 4;
                field ccf_Probe_T_sip6_main_Probe_Reserved_102 {
                    bits 32;
                    access rw;
                    hard_reset 'h0;
                }
            }
            register ccf_Probe_T_sip6_main_Probe_Reserved_103 @0x1E0 {
                bytes 4;
                field ccf_Probe_T_sip6_main_Probe_Reserved_103 {
                    bits 32;
                    access rw;
                    hard_reset 'h0;
                }
            }
            register ccf_Probe_T_sip6_main_Probe_Reserved_104 @0x1E4 {
                bytes 4;
                field ccf_Probe_T_sip6_main_Probe_Reserved_104 {
                    bits 32;
                    access rw;
                    hard_reset 'h0;
                }
            }
            register ccf_Probe_T_sip6_main_Probe_Reserved_105 @0x1E8 {
                bytes 4;
                field ccf_Probe_T_sip6_main_Probe_Reserved_105 {
                    bits 32;
                    access rw;
                    hard_reset 'h0;
                }
            }
            register ccf_Probe_T_sip6_main_Probe_Reserved_106 @0x1EC {
                bytes 4;
                field ccf_Probe_T_sip6_main_Probe_Reserved_106 {
                    bits 32;
                    access rw;
                    hard_reset 'h0;
                }
            }
            register ccf_Probe_T_sip6_main_Probe_Reserved_107 @0x1F0 {
                bytes 4;
                field ccf_Probe_T_sip6_main_Probe_Reserved_107 {
                    bits 32;
                    access rw;
                    hard_reset 'h0;
                }
            }
            register ccf_Probe_T_sip6_main_Probe_Reserved_108 @0x1F4 {
                bytes 4;
                field ccf_Probe_T_sip6_main_Probe_Reserved_108 {
                    bits 32;
                    access rw;
                    hard_reset 'h0;
                }
            }
            register ccf_Probe_T_sip6_main_Probe_Reserved_109 @0x1F8 {
                bytes 4;
                field ccf_Probe_T_sip6_main_Probe_Reserved_109 {
                    bits 32;
                    access rw;
                    hard_reset 'h0;
                }
            }
            register ccf_Probe_T_sip6_main_Probe_Reserved_110 @0x1FC {
                bytes 4;
                field ccf_Probe_T_sip6_main_Probe_Reserved_110 {
                    bits 32;
                    access rw;
                    hard_reset 'h0;
                }
            }
            register ccf_Probe_T_sip6_main_Probe_Reserved_111 @0x200 {
                bytes 4;
                field ccf_Probe_T_sip6_main_Probe_Reserved_111 {
                    bits 32;
                    access rw;
                    hard_reset 'h0;
                }
            }
            register ccf_Probe_T_sip6_main_Probe_Reserved_112 @0x204 {
                bytes 4;
                field ccf_Probe_T_sip6_main_Probe_Reserved_112 {
                    bits 32;
                    access rw;
                    hard_reset 'h0;
                }
            }
            register ccf_Probe_T_sip6_main_Probe_Reserved_113 @0x208 {
                bytes 4;
                field ccf_Probe_T_sip6_main_Probe_Reserved_113 {
                    bits 32;
                    access rw;
                    hard_reset 'h0;
                }
            }
            register ccf_Probe_T_sip6_main_Probe_Reserved_114 @0x20C {
                bytes 4;
                field ccf_Probe_T_sip6_main_Probe_Reserved_114 {
                    bits 32;
                    access rw;
                    hard_reset 'h0;
                }
            }
            register ccf_Probe_T_sip6_main_Probe_Reserved_115 @0x210 {
                bytes 4;
                field ccf_Probe_T_sip6_main_Probe_Reserved_115 {
                    bits 32;
                    access rw;
                    hard_reset 'h0;
                }
            }
            register ccf_Probe_T_sip6_main_Probe_Reserved_116 @0x214 {
                bytes 4;
                field ccf_Probe_T_sip6_main_Probe_Reserved_116 {
                    bits 32;
                    access rw;
                    hard_reset 'h0;
                }
            }
            register ccf_Probe_T_sip6_main_Probe_Reserved_117 @0x218 {
                bytes 4;
                field ccf_Probe_T_sip6_main_Probe_Reserved_117 {
                    bits 32;
                    access rw;
                    hard_reset 'h0;
                }
            }
            register ccf_Probe_T_sip6_main_Probe_Reserved_118 @0x21C {
                bytes 4;
                field ccf_Probe_T_sip6_main_Probe_Reserved_118 {
                    bits 32;
                    access rw;
                    hard_reset 'h0;
                }
            }
            register ccf_Probe_T_sip6_main_Probe_Reserved_119 @0x220 {
                bytes 4;
                field ccf_Probe_T_sip6_main_Probe_Reserved_119 {
                    bits 32;
                    access rw;
                    hard_reset 'h0;
                }
            }
            register ccf_Probe_T_sip6_main_Probe_Reserved_120 @0x224 {
                bytes 4;
                field ccf_Probe_T_sip6_main_Probe_Reserved_120 {
                    bits 32;
                    access rw;
                    hard_reset 'h0;
                }
            }
            register ccf_Probe_T_sip6_main_Probe_Reserved_121 @0x228 {
                bytes 4;
                field ccf_Probe_T_sip6_main_Probe_Reserved_121 {
                    bits 32;
                    access rw;
                    hard_reset 'h0;
                }
            }
            register ccf_Probe_T_sip6_main_Probe_Reserved_122 @0x22C {
                bytes 4;
                field ccf_Probe_T_sip6_main_Probe_Reserved_122 {
                    bits 32;
                    access rw;
                    hard_reset 'h0;
                }
            }
            register ccf_Probe_T_sip6_main_Probe_Reserved_123 @0x230 {
                bytes 4;
                field ccf_Probe_T_sip6_main_Probe_Reserved_123 {
                    bits 32;
                    access rw;
                    hard_reset 'h0;
                }
            }
            register ccf_Probe_T_sip6_main_Probe_Reserved_124 @0x234 {
                bytes 4;
                field ccf_Probe_T_sip6_main_Probe_Reserved_124 {
                    bits 32;
                    access rw;
                    hard_reset 'h0;
                }
            }
            register ccf_Probe_T_sip6_main_Probe_Reserved_125 @0x238 {
                bytes 4;
                field ccf_Probe_T_sip6_main_Probe_Reserved_125 {
                    bits 32;
                    access rw;
                    hard_reset 'h0;
                }
            }
            register ccf_Probe_T_sip6_main_Probe_Reserved_126 @0x23C {
                bytes 4;
                field ccf_Probe_T_sip6_main_Probe_Reserved_126 {
                    bits 32;
                    access rw;
                    hard_reset 'h0;
                }
            }
            register ccf_Probe_T_sip6_main_Probe_Reserved_127 @0x240 {
                bytes 4;
                field ccf_Probe_T_sip6_main_Probe_Reserved_127 {
                    bits 32;
                    access rw;
                    hard_reset 'h0;
                }
            }
            register ccf_Probe_T_sip6_main_Probe_Reserved_128 @0x244 {
                bytes 4;
                field ccf_Probe_T_sip6_main_Probe_Reserved_128 {
                    bits 32;
                    access rw;
                    hard_reset 'h0;
                }
            }
            register ccf_Probe_T_sip6_main_Probe_Reserved_129 @0x248 {
                bytes 4;
                field ccf_Probe_T_sip6_main_Probe_Reserved_129 {
                    bits 32;
                    access rw;
                    hard_reset 'h0;
                }
            }
            register ccf_Probe_T_sip6_main_Probe_Reserved_130 @0x24C {
                bytes 4;
                field ccf_Probe_T_sip6_main_Probe_Reserved_130 {
                    bits 32;
                    access rw;
                    hard_reset 'h0;
                }
            }
            register ccf_Probe_T_sip6_main_Probe_Reserved_131 @0x250 {
                bytes 4;
                field ccf_Probe_T_sip6_main_Probe_Reserved_131 {
                    bits 32;
                    access rw;
                    hard_reset 'h0;
                }
            }
            register ccf_Probe_T_sip6_main_Probe_Reserved_132 @0x254 {
                bytes 4;
                field ccf_Probe_T_sip6_main_Probe_Reserved_132 {
                    bits 32;
                    access rw;
                    hard_reset 'h0;
                }
            }
            register ccf_Probe_T_sip6_main_Probe_Reserved_133 @0x258 {
                bytes 4;
                field ccf_Probe_T_sip6_main_Probe_Reserved_133 {
                    bits 32;
                    access rw;
                    hard_reset 'h0;
                }
            }
            register ccf_Probe_T_sip6_main_Probe_Reserved_134 @0x25C {
                bytes 4;
                field ccf_Probe_T_sip6_main_Probe_Reserved_134 {
                    bits 32;
                    access rw;
                    hard_reset 'h0;
                }
            }
            register ccf_Probe_T_sip6_main_Probe_Reserved_135 @0x260 {
                bytes 4;
                field ccf_Probe_T_sip6_main_Probe_Reserved_135 {
                    bits 32;
                    access rw;
                    hard_reset 'h0;
                }
            }
            register ccf_Probe_T_sip6_main_Probe_Reserved_136 @0x264 {
                bytes 4;
                field ccf_Probe_T_sip6_main_Probe_Reserved_136 {
                    bits 32;
                    access rw;
                    hard_reset 'h0;
                }
            }
            register ccf_Probe_T_sip6_main_Probe_Reserved_137 @0x268 {
                bytes 4;
                field ccf_Probe_T_sip6_main_Probe_Reserved_137 {
                    bits 32;
                    access rw;
                    hard_reset 'h0;
                }
            }
            register ccf_Probe_T_sip6_main_Probe_Reserved_138 @0x26C {
                bytes 4;
                field ccf_Probe_T_sip6_main_Probe_Reserved_138 {
                    bits 32;
                    access rw;
                    hard_reset 'h0;
                }
            }
            register ccf_Probe_T_sip6_main_Probe_Reserved_139 @0x270 {
                bytes 4;
                field ccf_Probe_T_sip6_main_Probe_Reserved_139 {
                    bits 32;
                    access rw;
                    hard_reset 'h0;
                }
            }
            register ccf_Probe_T_sip6_main_Probe_Reserved_140 @0x274 {
                bytes 4;
                field ccf_Probe_T_sip6_main_Probe_Reserved_140 {
                    bits 32;
                    access rw;
                    hard_reset 'h0;
                }
            }
            register ccf_Probe_T_sip6_main_Probe_Reserved_141 @0x278 {
                bytes 4;
                field ccf_Probe_T_sip6_main_Probe_Reserved_141 {
                    bits 32;
                    access rw;
                    hard_reset 'h0;
                }
            }
            register ccf_Probe_T_sip6_main_Probe_Reserved_142 @0x27C {
                bytes 4;
                field ccf_Probe_T_sip6_main_Probe_Reserved_142 {
                    bits 32;
                    access rw;
                    hard_reset 'h0;
                }
            }
            register ccf_Probe_T_sip6_main_Probe_Reserved_143 @0x280 {
                bytes 4;
                field ccf_Probe_T_sip6_main_Probe_Reserved_143 {
                    bits 32;
                    access rw;
                    hard_reset 'h0;
                }
            }
            register ccf_Probe_T_sip6_main_Probe_Reserved_144 @0x284 {
                bytes 4;
                field ccf_Probe_T_sip6_main_Probe_Reserved_144 {
                    bits 32;
                    access rw;
                    hard_reset 'h0;
                }
            }
            register ccf_Probe_T_sip6_main_Probe_Reserved_145 @0x288 {
                bytes 4;
                field ccf_Probe_T_sip6_main_Probe_Reserved_145 {
                    bits 32;
                    access rw;
                    hard_reset 'h0;
                }
            }
            register ccf_Probe_T_sip6_main_Probe_Reserved_146 @0x28C {
                bytes 4;
                field ccf_Probe_T_sip6_main_Probe_Reserved_146 {
                    bits 32;
                    access rw;
                    hard_reset 'h0;
                }
            }
            register ccf_Probe_T_sip6_main_Probe_Reserved_147 @0x290 {
                bytes 4;
                field ccf_Probe_T_sip6_main_Probe_Reserved_147 {
                    bits 32;
                    access rw;
                    hard_reset 'h0;
                }
            }
            register ccf_Probe_T_sip6_main_Probe_Reserved_148 @0x294 {
                bytes 4;
                field ccf_Probe_T_sip6_main_Probe_Reserved_148 {
                    bits 32;
                    access rw;
                    hard_reset 'h0;
                }
            }
            register ccf_Probe_T_sip6_main_Probe_Reserved_149 @0x298 {
                bytes 4;
                field ccf_Probe_T_sip6_main_Probe_Reserved_149 {
                    bits 32;
                    access rw;
                    hard_reset 'h0;
                }
            }
            register ccf_Probe_T_sip6_main_Probe_Reserved_150 @0x29C {
                bytes 4;
                field ccf_Probe_T_sip6_main_Probe_Reserved_150 {
                    bits 32;
                    access rw;
                    hard_reset 'h0;
                }
            }
            register ccf_Probe_T_sip6_main_Probe_Reserved_151 @0x2A0 {
                bytes 4;
                field ccf_Probe_T_sip6_main_Probe_Reserved_151 {
                    bits 32;
                    access rw;
                    hard_reset 'h0;
                }
            }
            register ccf_Probe_T_sip6_main_Probe_Reserved_152 @0x2A4 {
                bytes 4;
                field ccf_Probe_T_sip6_main_Probe_Reserved_152 {
                    bits 32;
                    access rw;
                    hard_reset 'h0;
                }
            }
            register ccf_Probe_T_sip6_main_Probe_Reserved_153 @0x2A8 {
                bytes 4;
                field ccf_Probe_T_sip6_main_Probe_Reserved_153 {
                    bits 32;
                    access rw;
                    hard_reset 'h0;
                }
            }
            register ccf_Probe_T_sip6_main_Probe_Reserved_154 @0x2AC {
                bytes 4;
                field ccf_Probe_T_sip6_main_Probe_Reserved_154 {
                    bits 32;
                    access rw;
                    hard_reset 'h0;
                }
            }
            register ccf_Probe_T_sip6_main_Probe_Reserved_155 @0x2B0 {
                bytes 4;
                field ccf_Probe_T_sip6_main_Probe_Reserved_155 {
                    bits 32;
                    access rw;
                    hard_reset 'h0;
                }
            }
            register ccf_Probe_T_sip6_main_Probe_Reserved_156 @0x2B4 {
                bytes 4;
                field ccf_Probe_T_sip6_main_Probe_Reserved_156 {
                    bits 32;
                    access rw;
                    hard_reset 'h0;
                }
            }
            register ccf_Probe_T_sip6_main_Probe_Reserved_157 @0x2B8 {
                bytes 4;
                field ccf_Probe_T_sip6_main_Probe_Reserved_157 {
                    bits 32;
                    access rw;
                    hard_reset 'h0;
                }
            }
            register ccf_Probe_T_sip6_main_Probe_Reserved_158 @0x2BC {
                bytes 4;
                field ccf_Probe_T_sip6_main_Probe_Reserved_158 {
                    bits 32;
                    access rw;
                    hard_reset 'h0;
                }
            }
            register ccf_Probe_T_sip6_main_Probe_Reserved_159 @0x2C0 {
                bytes 4;
                field ccf_Probe_T_sip6_main_Probe_Reserved_159 {
                    bits 32;
                    access rw;
                    hard_reset 'h0;
                }
            }
            register ccf_Probe_T_sip6_main_Probe_Reserved_160 @0x2C4 {
                bytes 4;
                field ccf_Probe_T_sip6_main_Probe_Reserved_160 {
                    bits 32;
                    access rw;
                    hard_reset 'h0;
                }
            }
            register ccf_Probe_T_sip6_main_Probe_Reserved_161 @0x2C8 {
                bytes 4;
                field ccf_Probe_T_sip6_main_Probe_Reserved_161 {
                    bits 32;
                    access rw;
                    hard_reset 'h0;
                }
            }
            register ccf_Probe_T_sip6_main_Probe_Reserved_162 @0x2CC {
                bytes 4;
                field ccf_Probe_T_sip6_main_Probe_Reserved_162 {
                    bits 32;
                    access rw;
                    hard_reset 'h0;
                }
            }
            register ccf_Probe_T_sip6_main_Probe_Reserved_163 @0x2D0 {
                bytes 4;
                field ccf_Probe_T_sip6_main_Probe_Reserved_163 {
                    bits 32;
                    access rw;
                    hard_reset 'h0;
                }
            }
            register ccf_Probe_T_sip6_main_Probe_Reserved_164 @0x2D4 {
                bytes 4;
                field ccf_Probe_T_sip6_main_Probe_Reserved_164 {
                    bits 32;
                    access rw;
                    hard_reset 'h0;
                }
            }
            register ccf_Probe_T_sip6_main_Probe_Reserved_165 @0x2D8 {
                bytes 4;
                field ccf_Probe_T_sip6_main_Probe_Reserved_165 {
                    bits 32;
                    access rw;
                    hard_reset 'h0;
                }
            }
            register ccf_Probe_T_sip6_main_Probe_Reserved_166 @0x2DC {
                bytes 4;
                field ccf_Probe_T_sip6_main_Probe_Reserved_166 {
                    bits 32;
                    access rw;
                    hard_reset 'h0;
                }
            }
            register ccf_Probe_T_sip6_main_Probe_Reserved_167 @0x2E0 {
                bytes 4;
                field ccf_Probe_T_sip6_main_Probe_Reserved_167 {
                    bits 32;
                    access rw;
                    hard_reset 'h0;
                }
            }
            register ccf_Probe_T_sip6_main_Probe_Reserved_168 @0x2E4 {
                bytes 4;
                field ccf_Probe_T_sip6_main_Probe_Reserved_168 {
                    bits 32;
                    access rw;
                    hard_reset 'h0;
                }
            }
            register ccf_Probe_T_sip6_main_Probe_Reserved_169 @0x2E8 {
                bytes 4;
                field ccf_Probe_T_sip6_main_Probe_Reserved_169 {
                    bits 32;
                    access rw;
                    hard_reset 'h0;
                }
            }
            register ccf_Probe_T_sip6_main_Probe_Reserved_170 @0x2EC {
                bytes 4;
                field ccf_Probe_T_sip6_main_Probe_Reserved_170 {
                    bits 32;
                    access rw;
                    hard_reset 'h0;
                }
            }
            register ccf_Probe_T_sip6_main_Probe_Reserved_171 @0x2F0 {
                bytes 4;
                field ccf_Probe_T_sip6_main_Probe_Reserved_171 {
                    bits 32;
                    access rw;
                    hard_reset 'h0;
                }
            }
            register ccf_Probe_T_sip6_main_Probe_Reserved_172 @0x2F4 {
                bytes 4;
                field ccf_Probe_T_sip6_main_Probe_Reserved_172 {
                    bits 32;
                    access rw;
                    hard_reset 'h0;
                }
            }
            register ccf_Probe_T_sip6_main_Probe_Reserved_173 @0x2F8 {
                bytes 4;
                field ccf_Probe_T_sip6_main_Probe_Reserved_173 {
                    bits 32;
                    access rw;
                    hard_reset 'h0;
                }
            }
            register ccf_Probe_T_sip6_main_Probe_Reserved_174 @0x2FC {
                bytes 4;
                field ccf_Probe_T_sip6_main_Probe_Reserved_174 {
                    bits 32;
                    access rw;
                    hard_reset 'h0;
                }
            }
            register ccf_Probe_T_sip6_main_Probe_Reserved_175 @0x300 {
                bytes 4;
                field ccf_Probe_T_sip6_main_Probe_Reserved_175 {
                    bits 32;
                    access rw;
                    hard_reset 'h0;
                }
            }
            register ccf_Probe_T_sip6_main_Probe_Reserved_176 @0x304 {
                bytes 4;
                field ccf_Probe_T_sip6_main_Probe_Reserved_176 {
                    bits 32;
                    access rw;
                    hard_reset 'h0;
                }
            }
            register ccf_Probe_T_sip6_main_Probe_Reserved_177 @0x308 {
                bytes 4;
                field ccf_Probe_T_sip6_main_Probe_Reserved_177 {
                    bits 32;
                    access rw;
                    hard_reset 'h0;
                }
            }
            register ccf_Probe_T_sip6_main_Probe_Reserved_178 @0x30C {
                bytes 4;
                field ccf_Probe_T_sip6_main_Probe_Reserved_178 {
                    bits 32;
                    access rw;
                    hard_reset 'h0;
                }
            }
            register ccf_Probe_T_sip6_main_Probe_Reserved_179 @0x310 {
                bytes 4;
                field ccf_Probe_T_sip6_main_Probe_Reserved_179 {
                    bits 32;
                    access rw;
                    hard_reset 'h0;
                }
            }
            register ccf_Probe_T_sip6_main_Probe_Reserved_180 @0x314 {
                bytes 4;
                field ccf_Probe_T_sip6_main_Probe_Reserved_180 {
                    bits 32;
                    access rw;
                    hard_reset 'h0;
                }
            }
            register ccf_Probe_T_sip6_main_Probe_Reserved_181 @0x318 {
                bytes 4;
                field ccf_Probe_T_sip6_main_Probe_Reserved_181 {
                    bits 32;
                    access rw;
                    hard_reset 'h0;
                }
            }
            register ccf_Probe_T_sip6_main_Probe_Reserved_182 @0x31C {
                bytes 4;
                field ccf_Probe_T_sip6_main_Probe_Reserved_182 {
                    bits 32;
                    access rw;
                    hard_reset 'h0;
                }
            }
            register ccf_Probe_T_sip6_main_Probe_Reserved_183 @0x320 {
                bytes 4;
                field ccf_Probe_T_sip6_main_Probe_Reserved_183 {
                    bits 32;
                    access rw;
                    hard_reset 'h0;
                }
            }
            register ccf_Probe_T_sip6_main_Probe_Reserved_184 @0x324 {
                bytes 4;
                field ccf_Probe_T_sip6_main_Probe_Reserved_184 {
                    bits 32;
                    access rw;
                    hard_reset 'h0;
                }
            }
            register ccf_Probe_T_sip6_main_Probe_Reserved_185 @0x328 {
                bytes 4;
                field ccf_Probe_T_sip6_main_Probe_Reserved_185 {
                    bits 32;
                    access rw;
                    hard_reset 'h0;
                }
            }
            register ccf_Probe_T_sip6_main_Probe_Reserved_186 @0x32C {
                bytes 4;
                field ccf_Probe_T_sip6_main_Probe_Reserved_186 {
                    bits 32;
                    access rw;
                    hard_reset 'h0;
                }
            }
            register ccf_Probe_T_sip6_main_Probe_Reserved_187 @0x330 {
                bytes 4;
                field ccf_Probe_T_sip6_main_Probe_Reserved_187 {
                    bits 32;
                    access rw;
                    hard_reset 'h0;
                }
            }
            register ccf_Probe_T_sip6_main_Probe_Reserved_188 @0x334 {
                bytes 4;
                field ccf_Probe_T_sip6_main_Probe_Reserved_188 {
                    bits 32;
                    access rw;
                    hard_reset 'h0;
                }
            }
            register ccf_Probe_T_sip6_main_Probe_Reserved_189 @0x338 {
                bytes 4;
                field ccf_Probe_T_sip6_main_Probe_Reserved_189 {
                    bits 32;
                    access rw;
                    hard_reset 'h0;
                }
            }
            register ccf_Probe_T_sip6_main_Probe_Reserved_190 @0x33C {
                bytes 4;
                field ccf_Probe_T_sip6_main_Probe_Reserved_190 {
                    bits 32;
                    access rw;
                    hard_reset 'h0;
                }
            }
            register ccf_Probe_T_sip6_main_Probe_Reserved_191 @0x340 {
                bytes 4;
                field ccf_Probe_T_sip6_main_Probe_Reserved_191 {
                    bits 32;
                    access rw;
                    hard_reset 'h0;
                }
            }
            register ccf_Probe_T_sip6_main_Probe_Reserved_192 @0x344 {
                bytes 4;
                field ccf_Probe_T_sip6_main_Probe_Reserved_192 {
                    bits 32;
                    access rw;
                    hard_reset 'h0;
                }
            }
            register ccf_Probe_T_sip6_main_Probe_Reserved_193 @0x348 {
                bytes 4;
                field ccf_Probe_T_sip6_main_Probe_Reserved_193 {
                    bits 32;
                    access rw;
                    hard_reset 'h0;
                }
            }
            register ccf_Probe_T_sip6_main_Probe_Reserved_194 @0x34C {
                bytes 4;
                field ccf_Probe_T_sip6_main_Probe_Reserved_194 {
                    bits 32;
                    access rw;
                    hard_reset 'h0;
                }
            }
            register ccf_Probe_T_sip6_main_Probe_Reserved_195 @0x350 {
                bytes 4;
                field ccf_Probe_T_sip6_main_Probe_Reserved_195 {
                    bits 32;
                    access rw;
                    hard_reset 'h0;
                }
            }
            register ccf_Probe_T_sip6_main_Probe_Reserved_196 @0x354 {
                bytes 4;
                field ccf_Probe_T_sip6_main_Probe_Reserved_196 {
                    bits 32;
                    access rw;
                    hard_reset 'h0;
                }
            }
            register ccf_Probe_T_sip6_main_Probe_Reserved_197 @0x358 {
                bytes 4;
                field ccf_Probe_T_sip6_main_Probe_Reserved_197 {
                    bits 32;
                    access rw;
                    hard_reset 'h0;
                }
            }
            register ccf_Probe_T_sip6_main_Probe_Reserved_198 @0x35C {
                bytes 4;
                field ccf_Probe_T_sip6_main_Probe_Reserved_198 {
                    bits 32;
                    access rw;
                    hard_reset 'h0;
                }
            }
            register ccf_Probe_T_sip6_main_Probe_Reserved_199 @0x360 {
                bytes 4;
                field ccf_Probe_T_sip6_main_Probe_Reserved_199 {
                    bits 32;
                    access rw;
                    hard_reset 'h0;
                }
            }
            register ccf_Probe_T_sip6_main_Probe_Reserved_200 @0x364 {
                bytes 4;
                field ccf_Probe_T_sip6_main_Probe_Reserved_200 {
                    bits 32;
                    access rw;
                    hard_reset 'h0;
                }
            }
            register ccf_Probe_T_sip6_main_Probe_Reserved_201 @0x368 {
                bytes 4;
                field ccf_Probe_T_sip6_main_Probe_Reserved_201 {
                    bits 32;
                    access rw;
                    hard_reset 'h0;
                }
            }
            register ccf_Probe_T_sip6_main_Probe_Reserved_202 @0x36C {
                bytes 4;
                field ccf_Probe_T_sip6_main_Probe_Reserved_202 {
                    bits 32;
                    access rw;
                    hard_reset 'h0;
                }
            }
            register ccf_Probe_T_sip6_main_Probe_Reserved_203 @0x370 {
                bytes 4;
                field ccf_Probe_T_sip6_main_Probe_Reserved_203 {
                    bits 32;
                    access rw;
                    hard_reset 'h0;
                }
            }
            register ccf_Probe_T_sip6_main_Probe_Reserved_204 @0x374 {
                bytes 4;
                field ccf_Probe_T_sip6_main_Probe_Reserved_204 {
                    bits 32;
                    access rw;
                    hard_reset 'h0;
                }
            }
            register ccf_Probe_T_sip6_main_Probe_Reserved_205 @0x378 {
                bytes 4;
                field ccf_Probe_T_sip6_main_Probe_Reserved_205 {
                    bits 32;
                    access rw;
                    hard_reset 'h0;
                }
            }
            register ccf_Probe_T_sip6_main_Probe_Reserved_206 @0x37C {
                bytes 4;
                field ccf_Probe_T_sip6_main_Probe_Reserved_206 {
                    bits 32;
                    access rw;
                    hard_reset 'h0;
                }
            }
            register ccf_Probe_T_sip6_main_Probe_Reserved_207 @0x380 {
                bytes 4;
                field ccf_Probe_T_sip6_main_Probe_Reserved_207 {
                    bits 32;
                    access rw;
                    hard_reset 'h0;
                }
            }
            register ccf_Probe_T_sip6_main_Probe_Reserved_208 @0x384 {
                bytes 4;
                field ccf_Probe_T_sip6_main_Probe_Reserved_208 {
                    bits 32;
                    access rw;
                    hard_reset 'h0;
                }
            }
            register ccf_Probe_T_sip6_main_Probe_Reserved_209 @0x388 {
                bytes 4;
                field ccf_Probe_T_sip6_main_Probe_Reserved_209 {
                    bits 32;
                    access rw;
                    hard_reset 'h0;
                }
            }
            register ccf_Probe_T_sip6_main_Probe_Reserved_210 @0x38C {
                bytes 4;
                field ccf_Probe_T_sip6_main_Probe_Reserved_210 {
                    bits 32;
                    access rw;
                    hard_reset 'h0;
                }
            }
            register ccf_Probe_T_sip6_main_Probe_Reserved_211 @0x390 {
                bytes 4;
                field ccf_Probe_T_sip6_main_Probe_Reserved_211 {
                    bits 32;
                    access rw;
                    hard_reset 'h0;
                }
            }
            register ccf_Probe_T_sip6_main_Probe_Reserved_212 @0x394 {
                bytes 4;
                field ccf_Probe_T_sip6_main_Probe_Reserved_212 {
                    bits 32;
                    access rw;
                    hard_reset 'h0;
                }
            }
            register ccf_Probe_T_sip6_main_Probe_Reserved_213 @0x398 {
                bytes 4;
                field ccf_Probe_T_sip6_main_Probe_Reserved_213 {
                    bits 32;
                    access rw;
                    hard_reset 'h0;
                }
            }
            register ccf_Probe_T_sip6_main_Probe_Reserved_214 @0x39C {
                bytes 4;
                field ccf_Probe_T_sip6_main_Probe_Reserved_214 {
                    bits 32;
                    access rw;
                    hard_reset 'h0;
                }
            }
            register ccf_Probe_T_sip6_main_Probe_Reserved_215 @0x3A0 {
                bytes 4;
                field ccf_Probe_T_sip6_main_Probe_Reserved_215 {
                    bits 32;
                    access rw;
                    hard_reset 'h0;
                }
            }
            register ccf_Probe_T_sip6_main_Probe_Reserved_216 @0x3A4 {
                bytes 4;
                field ccf_Probe_T_sip6_main_Probe_Reserved_216 {
                    bits 32;
                    access rw;
                    hard_reset 'h0;
                }
            }
            register ccf_Probe_T_sip6_main_Probe_Reserved_217 @0x3A8 {
                bytes 4;
                field ccf_Probe_T_sip6_main_Probe_Reserved_217 {
                    bits 32;
                    access rw;
                    hard_reset 'h0;
                }
            }
            register ccf_Probe_T_sip6_main_Probe_Reserved_218 @0x3AC {
                bytes 4;
                field ccf_Probe_T_sip6_main_Probe_Reserved_218 {
                    bits 32;
                    access rw;
                    hard_reset 'h0;
                }
            }
            register ccf_Probe_T_sip6_main_Probe_Reserved_219 @0x3B0 {
                bytes 4;
                field ccf_Probe_T_sip6_main_Probe_Reserved_219 {
                    bits 32;
                    access rw;
                    hard_reset 'h0;
                }
            }
            register ccf_Probe_T_sip6_main_Probe_Reserved_220 @0x3B4 {
                bytes 4;
                field ccf_Probe_T_sip6_main_Probe_Reserved_220 {
                    bits 32;
                    access rw;
                    hard_reset 'h0;
                }
            }
            register ccf_Probe_T_sip6_main_Probe_Reserved_221 @0x3B8 {
                bytes 4;
                field ccf_Probe_T_sip6_main_Probe_Reserved_221 {
                    bits 32;
                    access rw;
                    hard_reset 'h0;
                }
            }
            register ccf_Probe_T_sip6_main_Probe_Reserved_222 @0x3BC {
                bytes 4;
                field ccf_Probe_T_sip6_main_Probe_Reserved_222 {
                    bits 32;
                    access rw;
                    hard_reset 'h0;
                }
            }
            register ccf_Probe_T_sip6_main_Probe_Reserved_223 @0x3C0 {
                bytes 4;
                field ccf_Probe_T_sip6_main_Probe_Reserved_223 {
                    bits 32;
                    access rw;
                    hard_reset 'h0;
                }
            }
            register ccf_Probe_T_sip6_main_Probe_Reserved_224 @0x3C4 {
                bytes 4;
                field ccf_Probe_T_sip6_main_Probe_Reserved_224 {
                    bits 32;
                    access rw;
                    hard_reset 'h0;
                }
            }
            register ccf_Probe_T_sip6_main_Probe_Reserved_225 @0x3C8 {
                bytes 4;
                field ccf_Probe_T_sip6_main_Probe_Reserved_225 {
                    bits 32;
                    access rw;
                    hard_reset 'h0;
                }
            }
            register ccf_Probe_T_sip6_main_Probe_Reserved_226 @0x3CC {
                bytes 4;
                field ccf_Probe_T_sip6_main_Probe_Reserved_226 {
                    bits 32;
                    access rw;
                    hard_reset 'h0;
                }
            }
            register ccf_Probe_T_sip6_main_Probe_Reserved_227 @0x3D0 {
                bytes 4;
                field ccf_Probe_T_sip6_main_Probe_Reserved_227 {
                    bits 32;
                    access rw;
                    hard_reset 'h0;
                }
            }
            register ccf_Probe_T_sip6_main_Probe_Reserved_228 @0x3D4 {
                bytes 4;
                field ccf_Probe_T_sip6_main_Probe_Reserved_228 {
                    bits 32;
                    access rw;
                    hard_reset 'h0;
                }
            }
            register ccf_Probe_T_sip6_main_Probe_Reserved_229 @0x3D8 {
                bytes 4;
                field ccf_Probe_T_sip6_main_Probe_Reserved_229 {
                    bits 32;
                    access rw;
                    hard_reset 'h0;
                }
            }
            register ccf_Probe_T_sip6_main_Probe_Reserved_230 @0x3DC {
                bytes 4;
                field ccf_Probe_T_sip6_main_Probe_Reserved_230 {
                    bits 32;
                    access rw;
                    hard_reset 'h0;
                }
            }
            register ccf_Probe_T_sip6_main_Probe_Reserved_231 @0x3E0 {
                bytes 4;
                field ccf_Probe_T_sip6_main_Probe_Reserved_231 {
                    bits 32;
                    access rw;
                    hard_reset 'h0;
                }
            }
            register ccf_Probe_T_sip6_main_Probe_Reserved_232 @0x3E4 {
                bytes 4;
                field ccf_Probe_T_sip6_main_Probe_Reserved_232 {
                    bits 32;
                    access rw;
                    hard_reset 'h0;
                }
            }
            register ccf_Probe_T_sip6_main_Probe_Reserved_233 @0x3E8 {
                bytes 4;
                field ccf_Probe_T_sip6_main_Probe_Reserved_233 {
                    bits 32;
                    access rw;
                    hard_reset 'h0;
                }
            }
            register ccf_Probe_T_sip6_main_Probe_Reserved_234 @0x3EC {
                bytes 4;
                field ccf_Probe_T_sip6_main_Probe_Reserved_234 {
                    bits 32;
                    access rw;
                    hard_reset 'h0;
                }
            }
            register ccf_Probe_T_sip6_main_Probe_Reserved_235 @0x3F0 {
                bytes 4;
                field ccf_Probe_T_sip6_main_Probe_Reserved_235 {
                    bits 32;
                    access rw;
                    hard_reset 'h0;
                }
            }
            register ccf_Probe_T_sip6_main_Probe_Reserved_236 @0x3F4 {
                bytes 4;
                field ccf_Probe_T_sip6_main_Probe_Reserved_236 {
                    bits 32;
                    access rw;
                    hard_reset 'h0;
                }
            }
            register ccf_Probe_T_sip6_main_Probe_Reserved_237 @0x3F8 {
                bytes 4;
                field ccf_Probe_T_sip6_main_Probe_Reserved_237 {
                    bits 32;
                    access rw;
                    hard_reset 'h0;
                }
            }
            register ccf_Probe_T_sip6_main_Probe_Reserved_238 @0x3FC {
                bytes 4;
                field ccf_Probe_T_sip6_main_Probe_Reserved_238 {
                    bits 32;
                    access rw;
                    hard_reset 'h0;
                }
            }
        }
        block ecf_ccf_axi_ccf_Probe_T_sip7_main_Probe @0xDAC00 {
            bytes 4;
            register ccf_Probe_T_sip7_main_Probe_Id_CoreId @0x0 {
                bytes 4;
                field CORETYPEID @'h0 {
                    bits 8;
                    access ro;
                    hard_reset 'h6;
                    doc {
                        Field identifying the type of IP.
                    }
                }
                field CORECHECKSUM @'h8 {
                    bits 24;
                    access ro;
                    hard_reset 'heb0644;
                    doc {
                        Field containing a checksum of the parameters of the IP.
                    }
                }
            }
            register ccf_Probe_T_sip7_main_Probe_Id_RevisionId @0x4 {
                bytes 4;
                field USERID @'h0 {
                    bits 8;
                    access ro;
                    hard_reset 'h0;
                    doc {
                        Field containing a user defined value, not used anywhere inside the IP itself.
                    }
                }
                field FLEXNOCID @'h8 {
                    bits 24;
                    access ro;
                    hard_reset 'h84f8c6;
                    doc {
                        Field containing the build revision of the software used to generate the IP HDL code.
                    }
                }
            }
            register ccf_Probe_T_sip7_main_Probe_MainCtl @0x8 {
                bytes 4;
                field ERREN @'h0 {
                    access rw;
                    hard_reset 'h0;
                    doc {
                        Register field ErrEn enables the probe to send on the ObsTx output any packet with Error status, independently of filtering mechanisms, thus constituting a simple supplementary global filter.
                    }
                }
                field TRACEEN @'h1 {
                    access ro;
                    hard_reset 'h0;
                    doc {
                        Register field TraceEn enables the probe to send filtered packets (Trace) on the ObsTx observation output.
                    }
                }
                field PAYLOADEN @'h2 {
                    access rw;
                    hard_reset 'h0;
                    doc {
                        Register field PayloadEn, when set to 1, enables traces to contain headers and payload. When set ot 0, only headers are reported.
                    }
                }
                field STATEN @'h3 {
                    access rw;
                    hard_reset 'h0;
                    doc {
                        When set to 1, register field StatEn enables statistics profiling. The probe sendS statistics results to the output for signal ObsTx. All statistics counters are cleared when the StatEn bit goes from 0 to 1. When set to 0, counters are disabled.
                    }
                }
                field ALARMEN @'h4 {
                    access rw;
                    hard_reset 'h0;
                    doc {
                        When set, register field AlarmEn enables the probe to collect alarm-related information. When the register field bit is null, both TraceAlarm and StatAlarm outputs are driven to 0.
                    }
                }
                field STATCONDDUMP @'h5 {
                    access rw;
                    hard_reset 'h0;
                    doc {
                        When set, register field StatCondDump enables the dump of a statistics frame to the range of counter values set for registers StatAlarmMin, StatAlarmMax, and AlarmMode. This field also renders register StatAlarmStatus inoperative. When parameter statisticsCounterAlarm is set to False, the StatCondDump register bit is reserved.
                    }
                }
                field INTRUSIVEMODE @'h6 {
                    access ro;
                    hard_reset 'h0;
                    doc {
                        When set to 1, register field IntrusiveMode enables trace operation in Intrusive flow-control mode. When set to 0, the register  enables trace operation in Overflow flow-control mode
                    }
                }
                field FILTBYTEALWAYSCHAINABLEEN @'h7 {
                    access rw;
                    hard_reset 'h0;
                    doc {
                        When set to 0, filters are mapped to all statistic counters when counting bytes or enabled bytes. Therefore, only filter events mapped to even counters can be counted using a pair of chained counters.When set to 1, filters are mapped only to even statistic counters when counting bytes or enabled bytes. Thus events from any filter can be counted using a pair of chained counters.
                    }
                }
                doc {
                    Register MainCtl contains probe global control bits. The register has seven bit fields:Register MainCtl contains probe global control bits. The register has seven bit fields:
                }
            }
            register ccf_Probe_T_sip7_main_Probe_CfgCtl @0xC {
                bytes 4;
                field GLOBALEN @'h0 {
                    access rw;
                    hard_reset 'h0;
                }
                field ACTIVE @'h1 {
                    access ro;
                    hard_reset 'h0;
                }
            }
            register ccf_Probe_T_sip7_main_Probe_Reserved_00 @0x10 {
                bytes 4;
                field ccf_Probe_T_sip7_main_Probe_Reserved_00 {
                    bits 32;
                    access rw;
                    hard_reset 'h0;
                }
            }
            register ccf_Probe_T_sip7_main_Probe_Reserved_01 @0x14 {
                bytes 4;
                field ccf_Probe_T_sip7_main_Probe_Reserved_01 {
                    bits 32;
                    access rw;
                    hard_reset 'h0;
                }
            }
            register ccf_Probe_T_sip7_main_Probe_Reserved_02 @0x18 {
                bytes 4;
                field ccf_Probe_T_sip7_main_Probe_Reserved_02 {
                    bits 32;
                    access rw;
                    hard_reset 'h0;
                }
            }
            register ccf_Probe_T_sip7_main_Probe_Reserved_03 @0x1C {
                bytes 4;
                field ccf_Probe_T_sip7_main_Probe_Reserved_03 {
                    bits 32;
                    access rw;
                    hard_reset 'h0;
                }
            }
            register ccf_Probe_T_sip7_main_Probe_Reserved_04 @0x20 {
                bytes 4;
                field ccf_Probe_T_sip7_main_Probe_Reserved_04 {
                    bits 32;
                    access rw;
                    hard_reset 'h0;
                }
            }
            register ccf_Probe_T_sip7_main_Probe_StatPeriod @0x24 {
                bytes 4;
                field STATPERIOD @'h0 {
                    bits 5;
                    access rw;
                    hard_reset 'h0;
                    doc {
                        Register StatPeriod is a 5-bit register that sets a period, within a range of 2 cycles to 2 gigacycles, during which statistics are collected before being dumped automatically. Setting the register implicitly enables automatic mode operation for statistics collection. The period is calculated with the formula: N_Cycle = 2**StatPeriodWhen register StatPeriod is set to its default value 0, automatic dump mode is disabled, and register StatGo is activated for manual mode operation. Note: When parameter statisticsCollection is set to False, StatPeriod is reserved.
                    }
                }
            }
            register ccf_Probe_T_sip7_main_Probe_StatGo @0x28 {
                bytes 4;
                field STATGO @'h0 {
                    access w1c;
                    hard_reset 'h0;
                    doc {
                        Writing a 1 to the 1-bit pulse register StatGo generates a statistics dump.The register is active when statistics collection operates in manual mode, that is, when register StatPeriod is set to 0.NOTE  The written value is not stored in StatGo. A read always returns 0.
                    }
                }
            }
            register ccf_Probe_T_sip7_main_Probe_StatAlarmMin @0x2C {
                bytes 4;
                field STATALARMMIN @'h0 {
                    bits 22;
                    access rw;
                    hard_reset 'h0;
                    doc {
                        Register StatAlarmMin contains the minimum count value used in statistics alarm comparisons. The number of bits is equal to twice the value set forparameter wStatisticsCounter. When parameter statisticsCounterAlarm is set to False, StatAlarmMin is reserved.
                    }
                }
            }
            register ccf_Probe_T_sip7_main_Probe_StatAlarmMax @0x30 {
                bytes 4;
                field STATALARMMAX @'h0 {
                    bits 22;
                    access rw;
                    hard_reset 'h0;
                    doc {
                        Register StatAlarmMax contains the maximum count value used in statistics alarm comparisons.The number of bits is equal to twice the value set for parameter wStatisticsCounter. When parameter statisticsCounterAlarm is set to False, StatAlarmMax is reserved.
                    }
                }
            }
            register ccf_Probe_T_sip7_main_Probe_StatAlarmStatus @0x34 {
                bytes 4;
                field STATALARMSTATUS @'h0 {
                    access ro;
                    hard_reset 'h0;
                    doc {
                        Register StatAlarmStatus is a read-only 1-bit register indicating that at least one statistics counter has exceeded the programmed values for registers StatAlarmMin or StatAlarmMax. Output signal StatAlarm is equal to the values stored in register MainCtl fields StatAlarmStatus and AlarmEn. When parameter statisticsCounterAlarm is set to False, StatAlarmStatus is reserved.
                    }
                }
            }
            register ccf_Probe_T_sip7_main_Probe_StatAlarmClr @0x38 {
                bytes 4;
                field STATALARMCLR @'h0 {
                    access w1c;
                    hard_reset 'h0;
                    doc {
                        Register StatAlarmClr is a 1-bit register. Writing a 1 to this register clears the StatAlarmStatus register bit.When parameter statisticsCounterAlarm is set to False, StatAlarmClr is reserved.NOTE  The written value is not stored in StatAlarmClr. A read always returns 0.
                    }
                }
            }
            register ccf_Probe_T_sip7_main_Probe_StatAlarmEn @0x3C {
                bytes 4;
                field STATALARMEN @'h0 {
                    access rw;
                    hard_reset 'h1;
                    doc {
                        Register StatAlarmEn is a 1-bit register. When set to 0 it masks StatAlarm and CtiTrigOut(1) signal interrupts.
                    }
                }
            }
            register ccf_Probe_T_sip7_main_Probe_Reserved_05 @0x40 {
                bytes 4;
                field ccf_Probe_T_sip7_main_Probe_Reserved_05 {
                    bits 32;
                    access rw;
                    hard_reset 'h0;
                }
            }
            register ccf_Probe_T_sip7_main_Probe_Reserved_06 @0x44 {
                bytes 4;
                field ccf_Probe_T_sip7_main_Probe_Reserved_06 {
                    bits 32;
                    access rw;
                    hard_reset 'h0;
                }
            }
            register ccf_Probe_T_sip7_main_Probe_Reserved_07 @0x48 {
                bytes 4;
                field ccf_Probe_T_sip7_main_Probe_Reserved_07 {
                    bits 32;
                    access rw;
                    hard_reset 'h0;
                }
            }
            register ccf_Probe_T_sip7_main_Probe_Reserved_08 @0x4C {
                bytes 4;
                field ccf_Probe_T_sip7_main_Probe_Reserved_08 {
                    bits 32;
                    access rw;
                    hard_reset 'h0;
                }
            }
            register ccf_Probe_T_sip7_main_Probe_Reserved_09 @0x50 {
                bytes 4;
                field ccf_Probe_T_sip7_main_Probe_Reserved_09 {
                    bits 32;
                    access rw;
                    hard_reset 'h0;
                }
            }
            register ccf_Probe_T_sip7_main_Probe_Reserved_10 @0x54 {
                bytes 4;
                field ccf_Probe_T_sip7_main_Probe_Reserved_10 {
                    bits 32;
                    access rw;
                    hard_reset 'h0;
                }
            }
            register ccf_Probe_T_sip7_main_Probe_Reserved_11 @0x58 {
                bytes 4;
                field ccf_Probe_T_sip7_main_Probe_Reserved_11 {
                    bits 32;
                    access rw;
                    hard_reset 'h0;
                }
            }
            register ccf_Probe_T_sip7_main_Probe_Reserved_12 @0x5C {
                bytes 4;
                field ccf_Probe_T_sip7_main_Probe_Reserved_12 {
                    bits 32;
                    access rw;
                    hard_reset 'h0;
                }
            }
            register ccf_Probe_T_sip7_main_Probe_Reserved_13 @0x60 {
                bytes 4;
                field ccf_Probe_T_sip7_main_Probe_Reserved_13 {
                    bits 32;
                    access rw;
                    hard_reset 'h0;
                }
            }
            register ccf_Probe_T_sip7_main_Probe_Reserved_14 @0x64 {
                bytes 4;
                field ccf_Probe_T_sip7_main_Probe_Reserved_14 {
                    bits 32;
                    access rw;
                    hard_reset 'h0;
                }
            }
            register ccf_Probe_T_sip7_main_Probe_Reserved_15 @0x68 {
                bytes 4;
                field ccf_Probe_T_sip7_main_Probe_Reserved_15 {
                    bits 32;
                    access rw;
                    hard_reset 'h0;
                }
            }
            register ccf_Probe_T_sip7_main_Probe_Reserved_16 @0x6C {
                bytes 4;
                field ccf_Probe_T_sip7_main_Probe_Reserved_16 {
                    bits 32;
                    access rw;
                    hard_reset 'h0;
                }
            }
            register ccf_Probe_T_sip7_main_Probe_Reserved_17 @0x70 {
                bytes 4;
                field ccf_Probe_T_sip7_main_Probe_Reserved_17 {
                    bits 32;
                    access rw;
                    hard_reset 'h0;
                }
            }
            register ccf_Probe_T_sip7_main_Probe_Reserved_18 @0x74 {
                bytes 4;
                field ccf_Probe_T_sip7_main_Probe_Reserved_18 {
                    bits 32;
                    access rw;
                    hard_reset 'h0;
                }
            }
            register ccf_Probe_T_sip7_main_Probe_Reserved_19 @0x78 {
                bytes 4;
                field ccf_Probe_T_sip7_main_Probe_Reserved_19 {
                    bits 32;
                    access rw;
                    hard_reset 'h0;
                }
            }
            register ccf_Probe_T_sip7_main_Probe_Reserved_20 @0x7C {
                bytes 4;
                field ccf_Probe_T_sip7_main_Probe_Reserved_20 {
                    bits 32;
                    access rw;
                    hard_reset 'h0;
                }
            }
            register ccf_Probe_T_sip7_main_Probe_Reserved_21 @0x80 {
                bytes 4;
                field ccf_Probe_T_sip7_main_Probe_Reserved_21 {
                    bits 32;
                    access rw;
                    hard_reset 'h0;
                }
            }
            register ccf_Probe_T_sip7_main_Probe_Reserved_22 @0x84 {
                bytes 4;
                field ccf_Probe_T_sip7_main_Probe_Reserved_22 {
                    bits 32;
                    access rw;
                    hard_reset 'h0;
                }
            }
            register ccf_Probe_T_sip7_main_Probe_Reserved_23 @0x88 {
                bytes 4;
                field ccf_Probe_T_sip7_main_Probe_Reserved_23 {
                    bits 32;
                    access rw;
                    hard_reset 'h0;
                }
            }
            register ccf_Probe_T_sip7_main_Probe_Reserved_24 @0x8C {
                bytes 4;
                field ccf_Probe_T_sip7_main_Probe_Reserved_24 {
                    bits 32;
                    access rw;
                    hard_reset 'h0;
                }
            }
            register ccf_Probe_T_sip7_main_Probe_Reserved_25 @0x90 {
                bytes 4;
                field ccf_Probe_T_sip7_main_Probe_Reserved_25 {
                    bits 32;
                    access rw;
                    hard_reset 'h0;
                }
            }
            register ccf_Probe_T_sip7_main_Probe_Reserved_26 @0x94 {
                bytes 4;
                field ccf_Probe_T_sip7_main_Probe_Reserved_26 {
                    bits 32;
                    access rw;
                    hard_reset 'h0;
                }
            }
            register ccf_Probe_T_sip7_main_Probe_Reserved_27 @0x98 {
                bytes 4;
                field ccf_Probe_T_sip7_main_Probe_Reserved_27 {
                    bits 32;
                    access rw;
                    hard_reset 'h0;
                }
            }
            register ccf_Probe_T_sip7_main_Probe_Reserved_28 @0x9C {
                bytes 4;
                field ccf_Probe_T_sip7_main_Probe_Reserved_28 {
                    bits 32;
                    access rw;
                    hard_reset 'h0;
                }
            }
            register ccf_Probe_T_sip7_main_Probe_Reserved_29 @0xA0 {
                bytes 4;
                field ccf_Probe_T_sip7_main_Probe_Reserved_29 {
                    bits 32;
                    access rw;
                    hard_reset 'h0;
                }
            }
            register ccf_Probe_T_sip7_main_Probe_Reserved_30 @0xA4 {
                bytes 4;
                field ccf_Probe_T_sip7_main_Probe_Reserved_30 {
                    bits 32;
                    access rw;
                    hard_reset 'h0;
                }
            }
            register ccf_Probe_T_sip7_main_Probe_Reserved_31 @0xA8 {
                bytes 4;
                field ccf_Probe_T_sip7_main_Probe_Reserved_31 {
                    bits 32;
                    access rw;
                    hard_reset 'h0;
                }
            }
            register ccf_Probe_T_sip7_main_Probe_Reserved_32 @0xAC {
                bytes 4;
                field ccf_Probe_T_sip7_main_Probe_Reserved_32 {
                    bits 32;
                    access rw;
                    hard_reset 'h0;
                }
            }
            register ccf_Probe_T_sip7_main_Probe_Reserved_33 @0xB0 {
                bytes 4;
                field ccf_Probe_T_sip7_main_Probe_Reserved_33 {
                    bits 32;
                    access rw;
                    hard_reset 'h0;
                }
            }
            register ccf_Probe_T_sip7_main_Probe_Reserved_34 @0xB4 {
                bytes 4;
                field ccf_Probe_T_sip7_main_Probe_Reserved_34 {
                    bits 32;
                    access rw;
                    hard_reset 'h0;
                }
            }
            register ccf_Probe_T_sip7_main_Probe_Reserved_35 @0xB8 {
                bytes 4;
                field ccf_Probe_T_sip7_main_Probe_Reserved_35 {
                    bits 32;
                    access rw;
                    hard_reset 'h0;
                }
            }
            register ccf_Probe_T_sip7_main_Probe_Reserved_36 @0xBC {
                bytes 4;
                field ccf_Probe_T_sip7_main_Probe_Reserved_36 {
                    bits 32;
                    access rw;
                    hard_reset 'h0;
                }
            }
            register ccf_Probe_T_sip7_main_Probe_Reserved_37 @0xC0 {
                bytes 4;
                field ccf_Probe_T_sip7_main_Probe_Reserved_37 {
                    bits 32;
                    access rw;
                    hard_reset 'h0;
                }
            }
            register ccf_Probe_T_sip7_main_Probe_Reserved_38 @0xC4 {
                bytes 4;
                field ccf_Probe_T_sip7_main_Probe_Reserved_38 {
                    bits 32;
                    access rw;
                    hard_reset 'h0;
                }
            }
            register ccf_Probe_T_sip7_main_Probe_Reserved_39 @0xC8 {
                bytes 4;
                field ccf_Probe_T_sip7_main_Probe_Reserved_39 {
                    bits 32;
                    access rw;
                    hard_reset 'h0;
                }
            }
            register ccf_Probe_T_sip7_main_Probe_Reserved_40 @0xCC {
                bytes 4;
                field ccf_Probe_T_sip7_main_Probe_Reserved_40 {
                    bits 32;
                    access rw;
                    hard_reset 'h0;
                }
            }
            register ccf_Probe_T_sip7_main_Probe_Reserved_41 @0xD0 {
                bytes 4;
                field ccf_Probe_T_sip7_main_Probe_Reserved_41 {
                    bits 32;
                    access rw;
                    hard_reset 'h0;
                }
            }
            register ccf_Probe_T_sip7_main_Probe_Reserved_42 @0xD4 {
                bytes 4;
                field ccf_Probe_T_sip7_main_Probe_Reserved_42 {
                    bits 32;
                    access rw;
                    hard_reset 'h0;
                }
            }
            register ccf_Probe_T_sip7_main_Probe_Reserved_43 @0xD8 {
                bytes 4;
                field ccf_Probe_T_sip7_main_Probe_Reserved_43 {
                    bits 32;
                    access rw;
                    hard_reset 'h0;
                }
            }
            register ccf_Probe_T_sip7_main_Probe_Reserved_44 @0xDC {
                bytes 4;
                field ccf_Probe_T_sip7_main_Probe_Reserved_44 {
                    bits 32;
                    access rw;
                    hard_reset 'h0;
                }
            }
            register ccf_Probe_T_sip7_main_Probe_Reserved_45 @0xE0 {
                bytes 4;
                field ccf_Probe_T_sip7_main_Probe_Reserved_45 {
                    bits 32;
                    access rw;
                    hard_reset 'h0;
                }
            }
            register ccf_Probe_T_sip7_main_Probe_Reserved_46 @0xE4 {
                bytes 4;
                field ccf_Probe_T_sip7_main_Probe_Reserved_46 {
                    bits 32;
                    access rw;
                    hard_reset 'h0;
                }
            }
            register ccf_Probe_T_sip7_main_Probe_Reserved_47 @0xE8 {
                bytes 4;
                field ccf_Probe_T_sip7_main_Probe_Reserved_47 {
                    bits 32;
                    access rw;
                    hard_reset 'h0;
                }
            }
            register ccf_Probe_T_sip7_main_Probe_Reserved_48 @0xEC {
                bytes 4;
                field ccf_Probe_T_sip7_main_Probe_Reserved_48 {
                    bits 32;
                    access rw;
                    hard_reset 'h0;
                }
            }
            register ccf_Probe_T_sip7_main_Probe_Reserved_49 @0xF0 {
                bytes 4;
                field ccf_Probe_T_sip7_main_Probe_Reserved_49 {
                    bits 32;
                    access rw;
                    hard_reset 'h0;
                }
            }
            register ccf_Probe_T_sip7_main_Probe_Reserved_50 @0xF4 {
                bytes 4;
                field ccf_Probe_T_sip7_main_Probe_Reserved_50 {
                    bits 32;
                    access rw;
                    hard_reset 'h0;
                }
            }
            register ccf_Probe_T_sip7_main_Probe_Reserved_51 @0xF8 {
                bytes 4;
                field ccf_Probe_T_sip7_main_Probe_Reserved_51 {
                    bits 32;
                    access rw;
                    hard_reset 'h0;
                }
            }
            register ccf_Probe_T_sip7_main_Probe_Reserved_52 @0xFC {
                bytes 4;
                field ccf_Probe_T_sip7_main_Probe_Reserved_52 {
                    bits 32;
                    access rw;
                    hard_reset 'h0;
                }
            }
            register ccf_Probe_T_sip7_main_Probe_Reserved_53 @0x100 {
                bytes 4;
                field ccf_Probe_T_sip7_main_Probe_Reserved_53 {
                    bits 32;
                    access rw;
                    hard_reset 'h0;
                }
            }
            register ccf_Probe_T_sip7_main_Probe_Reserved_54 @0x104 {
                bytes 4;
                field ccf_Probe_T_sip7_main_Probe_Reserved_54 {
                    bits 32;
                    access rw;
                    hard_reset 'h0;
                }
            }
            register ccf_Probe_T_sip7_main_Probe_Reserved_55 @0x108 {
                bytes 4;
                field ccf_Probe_T_sip7_main_Probe_Reserved_55 {
                    bits 32;
                    access rw;
                    hard_reset 'h0;
                }
            }
            register ccf_Probe_T_sip7_main_Probe_Reserved_56 @0x10C {
                bytes 4;
                field ccf_Probe_T_sip7_main_Probe_Reserved_56 {
                    bits 32;
                    access rw;
                    hard_reset 'h0;
                }
            }
            register ccf_Probe_T_sip7_main_Probe_Reserved_57 @0x110 {
                bytes 4;
                field ccf_Probe_T_sip7_main_Probe_Reserved_57 {
                    bits 32;
                    access rw;
                    hard_reset 'h0;
                }
            }
            register ccf_Probe_T_sip7_main_Probe_Reserved_58 @0x114 {
                bytes 4;
                field ccf_Probe_T_sip7_main_Probe_Reserved_58 {
                    bits 32;
                    access rw;
                    hard_reset 'h0;
                }
            }
            register ccf_Probe_T_sip7_main_Probe_Reserved_59 @0x118 {
                bytes 4;
                field ccf_Probe_T_sip7_main_Probe_Reserved_59 {
                    bits 32;
                    access rw;
                    hard_reset 'h0;
                }
            }
            register ccf_Probe_T_sip7_main_Probe_Reserved_60 @0x11C {
                bytes 4;
                field ccf_Probe_T_sip7_main_Probe_Reserved_60 {
                    bits 32;
                    access rw;
                    hard_reset 'h0;
                }
            }
            register ccf_Probe_T_sip7_main_Probe_Reserved_61 @0x120 {
                bytes 4;
                field ccf_Probe_T_sip7_main_Probe_Reserved_61 {
                    bits 32;
                    access rw;
                    hard_reset 'h0;
                }
            }
            register ccf_Probe_T_sip7_main_Probe_Reserved_62 @0x124 {
                bytes 4;
                field ccf_Probe_T_sip7_main_Probe_Reserved_62 {
                    bits 32;
                    access rw;
                    hard_reset 'h0;
                }
            }
            register ccf_Probe_T_sip7_main_Probe_Reserved_63 @0x128 {
                bytes 4;
                field ccf_Probe_T_sip7_main_Probe_Reserved_63 {
                    bits 32;
                    access rw;
                    hard_reset 'h0;
                }
            }
            register ccf_Probe_T_sip7_main_Probe_Reserved_64 @0x12C {
                bytes 4;
                field ccf_Probe_T_sip7_main_Probe_Reserved_64 {
                    bits 32;
                    access rw;
                    hard_reset 'h0;
                }
            }
            register ccf_Probe_T_sip7_main_Probe_Reserved_65 @0x130 {
                bytes 4;
                field ccf_Probe_T_sip7_main_Probe_Reserved_65 {
                    bits 32;
                    access rw;
                    hard_reset 'h0;
                }
            }
            register ccf_Probe_T_sip7_main_Probe_Reserved_66 @0x134 {
                bytes 4;
                field ccf_Probe_T_sip7_main_Probe_Reserved_66 {
                    bits 32;
                    access rw;
                    hard_reset 'h0;
                }
            }
            register ccf_Probe_T_sip7_main_Probe_Counters_0_Src @0x138 {
                bytes 4;
                field INTEVENT @'h0 {
                    bits 5;
                    access rw;
                    hard_reset 'h0;
                    enum { OFF = 0, CYCLE = 1, IDLE = 2, XFER = 3, BUSY = 4, WAIT = 5, PKT = 6, LUT = 7, BYTE = 8, PRESS0 = 9, PRESS1 = 10, PRESS2 = 11, FILT0 = 12, FILT1 = 13, FILT2 = 14, FILT3 = 15, CHAIN = 16, LUT_BYTE_EN = 17, LUT_BYTE = 18, FILT_BYTE_EN = 19, FILT_BYTE = 20, PRESS3 = 21, PRESS4 = 22, PRESS5 = 23, PRESS6 = 24, RSV_0 = 25, RSV_1 = 26, RSV_2 = 27, RSV_3 = 28, RSV_4 = 29, RSV_5 = 30, RSV_6 = 31 };
                    doc {
                        Internal packet event
                    }
                }
                field EXTEVENT @'h5 {
                    access rw;
                    hard_reset 'h0;
                    doc {
                        When greater than 0, the entire register value is used to select an external hardware event source. The index of the external event is equal to {ExtEvent,IntEvent}.
                    }
                }
                doc {
                    Register CntSrc indicates the event source used to increment the counter. Unassigned values (non-existing Press level or ExtEvent index, or unimplemented Filter) are equivalent to OFF.
	Register CntSrc indicates the event source used to increment the counter. Unassigned values (non-existing Press level or ExtEvent index, or unimplemented Filter) are equivalent to OFF.
	
                }
            }
            register ccf_Probe_T_sip7_main_Probe_Counters_0_AlarmMode @0x13C {
                bytes 4;
                field COUNTERS_0_ALARMMODE @'h0 {
                    bits 2;
                    access rw;
                    hard_reset 'h0;
                    enum { OFF = 0, MIN = 1, MAX = 2, MIN_MAX = 3 };
                    doc {
                        Register AlarmMode is a 2-bit register that is present when parameter statisticsCounterAlarm is set to True. The register defines the statistics-alarm behavior of the counter.
                    }
                }
            }
            register ccf_Probe_T_sip7_main_Probe_Counters_0_Val @0x140 {
                bytes 4;
                field COUNTERS_0_VAL @'h0 {
                    bits 11;
                    access ro;
                    hard_reset 'h0;
                    doc {
                        Register Val is a read-only register that is always present. The register containsthe statistics counter value either pending StatAlarm output, or when statisticscollection is suspended subsequent to triggers or signal statSuspend.
                    }
                }
            }
            register ccf_Probe_T_sip7_main_Probe_Reserved_67 @0x144 {
                bytes 4;
                field ccf_Probe_T_sip7_main_Probe_Reserved_67 {
                    bits 32;
                    access rw;
                    hard_reset 'h0;
                }
            }
            register ccf_Probe_T_sip7_main_Probe_Reserved_68 @0x148 {
                bytes 4;
                field ccf_Probe_T_sip7_main_Probe_Reserved_68 {
                    bits 32;
                    access rw;
                    hard_reset 'h0;
                }
            }
            register ccf_Probe_T_sip7_main_Probe_Counters_1_Src @0x14C {
                bytes 4;
                field INTEVENT @'h0 {
                    bits 5;
                    access rw;
                    hard_reset 'h0;
                    enum { OFF = 0, CYCLE = 1, IDLE = 2, XFER = 3, BUSY = 4, WAIT = 5, PKT = 6, LUT = 7, BYTE = 8, PRESS0 = 9, PRESS1 = 10, PRESS2 = 11, FILT0 = 12, FILT1 = 13, FILT2 = 14, FILT3 = 15, CHAIN = 16, LUT_BYTE_EN = 17, LUT_BYTE = 18, FILT_BYTE_EN = 19, FILT_BYTE = 20, PRESS3 = 21, PRESS4 = 22, PRESS5 = 23, PRESS6 = 24, RSV_0 = 25, RSV_1 = 26, RSV_2 = 27, RSV_3 = 28, RSV_4 = 29, RSV_5 = 30, RSV_6 = 31 };
                    doc {
                        Internal packet event
                    }
                }
                field EXTEVENT @'h5 {
                    access rw;
                    hard_reset 'h0;
                    doc {
                        When greater than 0, the entire register value is used to select an external hardware event source. The index of the external event is equal to {ExtEvent,IntEvent}.
                    }
                }
                doc {
                    Register CntSrc indicates the event source used to increment the counter. Unassigned values (non-existing Press level or ExtEvent index, or unimplemented Filter) are equivalent to OFF.
	Register CntSrc indicates the event source used to increment the counter. Unassigned values (non-existing Press level or ExtEvent index, or unimplemented Filter) are equivalent to OFF.
	
                }
            }
            register ccf_Probe_T_sip7_main_Probe_Counters_1_AlarmMode @0x150 {
                bytes 4;
                field COUNTERS_1_ALARMMODE @'h0 {
                    bits 2;
                    access rw;
                    hard_reset 'h0;
                    enum { OFF = 0, MIN = 1, MAX = 2, MIN_MAX = 3 };
                    doc {
                        Register AlarmMode is a 2-bit register that is present when parameter statisticsCounterAlarm is set to True. The register defines the statistics-alarm behavior of the counter.
                    }
                }
            }
            register ccf_Probe_T_sip7_main_Probe_Counters_1_Val @0x154 {
                bytes 4;
                field COUNTERS_1_VAL @'h0 {
                    bits 11;
                    access ro;
                    hard_reset 'h0;
                    doc {
                        Register Val is a read-only register that is always present. The register containsthe statistics counter value either pending StatAlarm output, or when statisticscollection is suspended subsequent to triggers or signal statSuspend.
                    }
                }
            }
            register ccf_Probe_T_sip7_main_Probe_Reserved_69 @0x158 {
                bytes 4;
                field ccf_Probe_T_sip7_main_Probe_Reserved_69 {
                    bits 32;
                    access rw;
                    hard_reset 'h0;
                }
            }
            register ccf_Probe_T_sip7_main_Probe_Reserved_70 @0x15C {
                bytes 4;
                field ccf_Probe_T_sip7_main_Probe_Reserved_70 {
                    bits 32;
                    access rw;
                    hard_reset 'h0;
                }
            }
            register ccf_Probe_T_sip7_main_Probe_Reserved_71 @0x160 {
                bytes 4;
                field ccf_Probe_T_sip7_main_Probe_Reserved_71 {
                    bits 32;
                    access rw;
                    hard_reset 'h0;
                }
            }
            register ccf_Probe_T_sip7_main_Probe_Reserved_72 @0x164 {
                bytes 4;
                field ccf_Probe_T_sip7_main_Probe_Reserved_72 {
                    bits 32;
                    access rw;
                    hard_reset 'h0;
                }
            }
            register ccf_Probe_T_sip7_main_Probe_Reserved_73 @0x168 {
                bytes 4;
                field ccf_Probe_T_sip7_main_Probe_Reserved_73 {
                    bits 32;
                    access rw;
                    hard_reset 'h0;
                }
            }
            register ccf_Probe_T_sip7_main_Probe_Reserved_74 @0x16C {
                bytes 4;
                field ccf_Probe_T_sip7_main_Probe_Reserved_74 {
                    bits 32;
                    access rw;
                    hard_reset 'h0;
                }
            }
            register ccf_Probe_T_sip7_main_Probe_Reserved_75 @0x170 {
                bytes 4;
                field ccf_Probe_T_sip7_main_Probe_Reserved_75 {
                    bits 32;
                    access rw;
                    hard_reset 'h0;
                }
            }
            register ccf_Probe_T_sip7_main_Probe_Reserved_76 @0x174 {
                bytes 4;
                field ccf_Probe_T_sip7_main_Probe_Reserved_76 {
                    bits 32;
                    access rw;
                    hard_reset 'h0;
                }
            }
            register ccf_Probe_T_sip7_main_Probe_Reserved_77 @0x178 {
                bytes 4;
                field ccf_Probe_T_sip7_main_Probe_Reserved_77 {
                    bits 32;
                    access rw;
                    hard_reset 'h0;
                }
            }
            register ccf_Probe_T_sip7_main_Probe_Reserved_78 @0x17C {
                bytes 4;
                field ccf_Probe_T_sip7_main_Probe_Reserved_78 {
                    bits 32;
                    access rw;
                    hard_reset 'h0;
                }
            }
            register ccf_Probe_T_sip7_main_Probe_Reserved_79 @0x180 {
                bytes 4;
                field ccf_Probe_T_sip7_main_Probe_Reserved_79 {
                    bits 32;
                    access rw;
                    hard_reset 'h0;
                }
            }
            register ccf_Probe_T_sip7_main_Probe_Reserved_80 @0x184 {
                bytes 4;
                field ccf_Probe_T_sip7_main_Probe_Reserved_80 {
                    bits 32;
                    access rw;
                    hard_reset 'h0;
                }
            }
            register ccf_Probe_T_sip7_main_Probe_Reserved_81 @0x188 {
                bytes 4;
                field ccf_Probe_T_sip7_main_Probe_Reserved_81 {
                    bits 32;
                    access rw;
                    hard_reset 'h0;
                }
            }
            register ccf_Probe_T_sip7_main_Probe_Reserved_82 @0x18C {
                bytes 4;
                field ccf_Probe_T_sip7_main_Probe_Reserved_82 {
                    bits 32;
                    access rw;
                    hard_reset 'h0;
                }
            }
            register ccf_Probe_T_sip7_main_Probe_Reserved_83 @0x190 {
                bytes 4;
                field ccf_Probe_T_sip7_main_Probe_Reserved_83 {
                    bits 32;
                    access rw;
                    hard_reset 'h0;
                }
            }
            register ccf_Probe_T_sip7_main_Probe_Reserved_84 @0x194 {
                bytes 4;
                field ccf_Probe_T_sip7_main_Probe_Reserved_84 {
                    bits 32;
                    access rw;
                    hard_reset 'h0;
                }
            }
            register ccf_Probe_T_sip7_main_Probe_Reserved_85 @0x198 {
                bytes 4;
                field ccf_Probe_T_sip7_main_Probe_Reserved_85 {
                    bits 32;
                    access rw;
                    hard_reset 'h0;
                }
            }
            register ccf_Probe_T_sip7_main_Probe_Reserved_86 @0x19C {
                bytes 4;
                field ccf_Probe_T_sip7_main_Probe_Reserved_86 {
                    bits 32;
                    access rw;
                    hard_reset 'h0;
                }
            }
            register ccf_Probe_T_sip7_main_Probe_Reserved_87 @0x1A0 {
                bytes 4;
                field ccf_Probe_T_sip7_main_Probe_Reserved_87 {
                    bits 32;
                    access rw;
                    hard_reset 'h0;
                }
            }
            register ccf_Probe_T_sip7_main_Probe_Reserved_88 @0x1A4 {
                bytes 4;
                field ccf_Probe_T_sip7_main_Probe_Reserved_88 {
                    bits 32;
                    access rw;
                    hard_reset 'h0;
                }
            }
            register ccf_Probe_T_sip7_main_Probe_Reserved_89 @0x1A8 {
                bytes 4;
                field ccf_Probe_T_sip7_main_Probe_Reserved_89 {
                    bits 32;
                    access rw;
                    hard_reset 'h0;
                }
            }
            register ccf_Probe_T_sip7_main_Probe_Reserved_90 @0x1AC {
                bytes 4;
                field ccf_Probe_T_sip7_main_Probe_Reserved_90 {
                    bits 32;
                    access rw;
                    hard_reset 'h0;
                }
            }
            register ccf_Probe_T_sip7_main_Probe_Reserved_91 @0x1B0 {
                bytes 4;
                field ccf_Probe_T_sip7_main_Probe_Reserved_91 {
                    bits 32;
                    access rw;
                    hard_reset 'h0;
                }
            }
            register ccf_Probe_T_sip7_main_Probe_Reserved_92 @0x1B4 {
                bytes 4;
                field ccf_Probe_T_sip7_main_Probe_Reserved_92 {
                    bits 32;
                    access rw;
                    hard_reset 'h0;
                }
            }
            register ccf_Probe_T_sip7_main_Probe_Reserved_93 @0x1B8 {
                bytes 4;
                field ccf_Probe_T_sip7_main_Probe_Reserved_93 {
                    bits 32;
                    access rw;
                    hard_reset 'h0;
                }
            }
            register ccf_Probe_T_sip7_main_Probe_Reserved_94 @0x1BC {
                bytes 4;
                field ccf_Probe_T_sip7_main_Probe_Reserved_94 {
                    bits 32;
                    access rw;
                    hard_reset 'h0;
                }
            }
            register ccf_Probe_T_sip7_main_Probe_Reserved_95 @0x1C0 {
                bytes 4;
                field ccf_Probe_T_sip7_main_Probe_Reserved_95 {
                    bits 32;
                    access rw;
                    hard_reset 'h0;
                }
            }
            register ccf_Probe_T_sip7_main_Probe_Reserved_96 @0x1C4 {
                bytes 4;
                field ccf_Probe_T_sip7_main_Probe_Reserved_96 {
                    bits 32;
                    access rw;
                    hard_reset 'h0;
                }
            }
            register ccf_Probe_T_sip7_main_Probe_Reserved_97 @0x1C8 {
                bytes 4;
                field ccf_Probe_T_sip7_main_Probe_Reserved_97 {
                    bits 32;
                    access rw;
                    hard_reset 'h0;
                }
            }
            register ccf_Probe_T_sip7_main_Probe_Reserved_98 @0x1CC {
                bytes 4;
                field ccf_Probe_T_sip7_main_Probe_Reserved_98 {
                    bits 32;
                    access rw;
                    hard_reset 'h0;
                }
            }
            register ccf_Probe_T_sip7_main_Probe_Reserved_99 @0x1D0 {
                bytes 4;
                field ccf_Probe_T_sip7_main_Probe_Reserved_99 {
                    bits 32;
                    access rw;
                    hard_reset 'h0;
                }
            }
            register ccf_Probe_T_sip7_main_Probe_Reserved_100 @0x1D4 {
                bytes 4;
                field ccf_Probe_T_sip7_main_Probe_Reserved_100 {
                    bits 32;
                    access rw;
                    hard_reset 'h0;
                }
            }
            register ccf_Probe_T_sip7_main_Probe_Reserved_101 @0x1D8 {
                bytes 4;
                field ccf_Probe_T_sip7_main_Probe_Reserved_101 {
                    bits 32;
                    access rw;
                    hard_reset 'h0;
                }
            }
            register ccf_Probe_T_sip7_main_Probe_Reserved_102 @0x1DC {
                bytes 4;
                field ccf_Probe_T_sip7_main_Probe_Reserved_102 {
                    bits 32;
                    access rw;
                    hard_reset 'h0;
                }
            }
            register ccf_Probe_T_sip7_main_Probe_Reserved_103 @0x1E0 {
                bytes 4;
                field ccf_Probe_T_sip7_main_Probe_Reserved_103 {
                    bits 32;
                    access rw;
                    hard_reset 'h0;
                }
            }
            register ccf_Probe_T_sip7_main_Probe_Reserved_104 @0x1E4 {
                bytes 4;
                field ccf_Probe_T_sip7_main_Probe_Reserved_104 {
                    bits 32;
                    access rw;
                    hard_reset 'h0;
                }
            }
            register ccf_Probe_T_sip7_main_Probe_Reserved_105 @0x1E8 {
                bytes 4;
                field ccf_Probe_T_sip7_main_Probe_Reserved_105 {
                    bits 32;
                    access rw;
                    hard_reset 'h0;
                }
            }
            register ccf_Probe_T_sip7_main_Probe_Reserved_106 @0x1EC {
                bytes 4;
                field ccf_Probe_T_sip7_main_Probe_Reserved_106 {
                    bits 32;
                    access rw;
                    hard_reset 'h0;
                }
            }
            register ccf_Probe_T_sip7_main_Probe_Reserved_107 @0x1F0 {
                bytes 4;
                field ccf_Probe_T_sip7_main_Probe_Reserved_107 {
                    bits 32;
                    access rw;
                    hard_reset 'h0;
                }
            }
            register ccf_Probe_T_sip7_main_Probe_Reserved_108 @0x1F4 {
                bytes 4;
                field ccf_Probe_T_sip7_main_Probe_Reserved_108 {
                    bits 32;
                    access rw;
                    hard_reset 'h0;
                }
            }
            register ccf_Probe_T_sip7_main_Probe_Reserved_109 @0x1F8 {
                bytes 4;
                field ccf_Probe_T_sip7_main_Probe_Reserved_109 {
                    bits 32;
                    access rw;
                    hard_reset 'h0;
                }
            }
            register ccf_Probe_T_sip7_main_Probe_Reserved_110 @0x1FC {
                bytes 4;
                field ccf_Probe_T_sip7_main_Probe_Reserved_110 {
                    bits 32;
                    access rw;
                    hard_reset 'h0;
                }
            }
            register ccf_Probe_T_sip7_main_Probe_Reserved_111 @0x200 {
                bytes 4;
                field ccf_Probe_T_sip7_main_Probe_Reserved_111 {
                    bits 32;
                    access rw;
                    hard_reset 'h0;
                }
            }
            register ccf_Probe_T_sip7_main_Probe_Reserved_112 @0x204 {
                bytes 4;
                field ccf_Probe_T_sip7_main_Probe_Reserved_112 {
                    bits 32;
                    access rw;
                    hard_reset 'h0;
                }
            }
            register ccf_Probe_T_sip7_main_Probe_Reserved_113 @0x208 {
                bytes 4;
                field ccf_Probe_T_sip7_main_Probe_Reserved_113 {
                    bits 32;
                    access rw;
                    hard_reset 'h0;
                }
            }
            register ccf_Probe_T_sip7_main_Probe_Reserved_114 @0x20C {
                bytes 4;
                field ccf_Probe_T_sip7_main_Probe_Reserved_114 {
                    bits 32;
                    access rw;
                    hard_reset 'h0;
                }
            }
            register ccf_Probe_T_sip7_main_Probe_Reserved_115 @0x210 {
                bytes 4;
                field ccf_Probe_T_sip7_main_Probe_Reserved_115 {
                    bits 32;
                    access rw;
                    hard_reset 'h0;
                }
            }
            register ccf_Probe_T_sip7_main_Probe_Reserved_116 @0x214 {
                bytes 4;
                field ccf_Probe_T_sip7_main_Probe_Reserved_116 {
                    bits 32;
                    access rw;
                    hard_reset 'h0;
                }
            }
            register ccf_Probe_T_sip7_main_Probe_Reserved_117 @0x218 {
                bytes 4;
                field ccf_Probe_T_sip7_main_Probe_Reserved_117 {
                    bits 32;
                    access rw;
                    hard_reset 'h0;
                }
            }
            register ccf_Probe_T_sip7_main_Probe_Reserved_118 @0x21C {
                bytes 4;
                field ccf_Probe_T_sip7_main_Probe_Reserved_118 {
                    bits 32;
                    access rw;
                    hard_reset 'h0;
                }
            }
            register ccf_Probe_T_sip7_main_Probe_Reserved_119 @0x220 {
                bytes 4;
                field ccf_Probe_T_sip7_main_Probe_Reserved_119 {
                    bits 32;
                    access rw;
                    hard_reset 'h0;
                }
            }
            register ccf_Probe_T_sip7_main_Probe_Reserved_120 @0x224 {
                bytes 4;
                field ccf_Probe_T_sip7_main_Probe_Reserved_120 {
                    bits 32;
                    access rw;
                    hard_reset 'h0;
                }
            }
            register ccf_Probe_T_sip7_main_Probe_Reserved_121 @0x228 {
                bytes 4;
                field ccf_Probe_T_sip7_main_Probe_Reserved_121 {
                    bits 32;
                    access rw;
                    hard_reset 'h0;
                }
            }
            register ccf_Probe_T_sip7_main_Probe_Reserved_122 @0x22C {
                bytes 4;
                field ccf_Probe_T_sip7_main_Probe_Reserved_122 {
                    bits 32;
                    access rw;
                    hard_reset 'h0;
                }
            }
            register ccf_Probe_T_sip7_main_Probe_Reserved_123 @0x230 {
                bytes 4;
                field ccf_Probe_T_sip7_main_Probe_Reserved_123 {
                    bits 32;
                    access rw;
                    hard_reset 'h0;
                }
            }
            register ccf_Probe_T_sip7_main_Probe_Reserved_124 @0x234 {
                bytes 4;
                field ccf_Probe_T_sip7_main_Probe_Reserved_124 {
                    bits 32;
                    access rw;
                    hard_reset 'h0;
                }
            }
            register ccf_Probe_T_sip7_main_Probe_Reserved_125 @0x238 {
                bytes 4;
                field ccf_Probe_T_sip7_main_Probe_Reserved_125 {
                    bits 32;
                    access rw;
                    hard_reset 'h0;
                }
            }
            register ccf_Probe_T_sip7_main_Probe_Reserved_126 @0x23C {
                bytes 4;
                field ccf_Probe_T_sip7_main_Probe_Reserved_126 {
                    bits 32;
                    access rw;
                    hard_reset 'h0;
                }
            }
            register ccf_Probe_T_sip7_main_Probe_Reserved_127 @0x240 {
                bytes 4;
                field ccf_Probe_T_sip7_main_Probe_Reserved_127 {
                    bits 32;
                    access rw;
                    hard_reset 'h0;
                }
            }
            register ccf_Probe_T_sip7_main_Probe_Reserved_128 @0x244 {
                bytes 4;
                field ccf_Probe_T_sip7_main_Probe_Reserved_128 {
                    bits 32;
                    access rw;
                    hard_reset 'h0;
                }
            }
            register ccf_Probe_T_sip7_main_Probe_Reserved_129 @0x248 {
                bytes 4;
                field ccf_Probe_T_sip7_main_Probe_Reserved_129 {
                    bits 32;
                    access rw;
                    hard_reset 'h0;
                }
            }
            register ccf_Probe_T_sip7_main_Probe_Reserved_130 @0x24C {
                bytes 4;
                field ccf_Probe_T_sip7_main_Probe_Reserved_130 {
                    bits 32;
                    access rw;
                    hard_reset 'h0;
                }
            }
            register ccf_Probe_T_sip7_main_Probe_Reserved_131 @0x250 {
                bytes 4;
                field ccf_Probe_T_sip7_main_Probe_Reserved_131 {
                    bits 32;
                    access rw;
                    hard_reset 'h0;
                }
            }
            register ccf_Probe_T_sip7_main_Probe_Reserved_132 @0x254 {
                bytes 4;
                field ccf_Probe_T_sip7_main_Probe_Reserved_132 {
                    bits 32;
                    access rw;
                    hard_reset 'h0;
                }
            }
            register ccf_Probe_T_sip7_main_Probe_Reserved_133 @0x258 {
                bytes 4;
                field ccf_Probe_T_sip7_main_Probe_Reserved_133 {
                    bits 32;
                    access rw;
                    hard_reset 'h0;
                }
            }
            register ccf_Probe_T_sip7_main_Probe_Reserved_134 @0x25C {
                bytes 4;
                field ccf_Probe_T_sip7_main_Probe_Reserved_134 {
                    bits 32;
                    access rw;
                    hard_reset 'h0;
                }
            }
            register ccf_Probe_T_sip7_main_Probe_Reserved_135 @0x260 {
                bytes 4;
                field ccf_Probe_T_sip7_main_Probe_Reserved_135 {
                    bits 32;
                    access rw;
                    hard_reset 'h0;
                }
            }
            register ccf_Probe_T_sip7_main_Probe_Reserved_136 @0x264 {
                bytes 4;
                field ccf_Probe_T_sip7_main_Probe_Reserved_136 {
                    bits 32;
                    access rw;
                    hard_reset 'h0;
                }
            }
            register ccf_Probe_T_sip7_main_Probe_Reserved_137 @0x268 {
                bytes 4;
                field ccf_Probe_T_sip7_main_Probe_Reserved_137 {
                    bits 32;
                    access rw;
                    hard_reset 'h0;
                }
            }
            register ccf_Probe_T_sip7_main_Probe_Reserved_138 @0x26C {
                bytes 4;
                field ccf_Probe_T_sip7_main_Probe_Reserved_138 {
                    bits 32;
                    access rw;
                    hard_reset 'h0;
                }
            }
            register ccf_Probe_T_sip7_main_Probe_Reserved_139 @0x270 {
                bytes 4;
                field ccf_Probe_T_sip7_main_Probe_Reserved_139 {
                    bits 32;
                    access rw;
                    hard_reset 'h0;
                }
            }
            register ccf_Probe_T_sip7_main_Probe_Reserved_140 @0x274 {
                bytes 4;
                field ccf_Probe_T_sip7_main_Probe_Reserved_140 {
                    bits 32;
                    access rw;
                    hard_reset 'h0;
                }
            }
            register ccf_Probe_T_sip7_main_Probe_Reserved_141 @0x278 {
                bytes 4;
                field ccf_Probe_T_sip7_main_Probe_Reserved_141 {
                    bits 32;
                    access rw;
                    hard_reset 'h0;
                }
            }
            register ccf_Probe_T_sip7_main_Probe_Reserved_142 @0x27C {
                bytes 4;
                field ccf_Probe_T_sip7_main_Probe_Reserved_142 {
                    bits 32;
                    access rw;
                    hard_reset 'h0;
                }
            }
            register ccf_Probe_T_sip7_main_Probe_Reserved_143 @0x280 {
                bytes 4;
                field ccf_Probe_T_sip7_main_Probe_Reserved_143 {
                    bits 32;
                    access rw;
                    hard_reset 'h0;
                }
            }
            register ccf_Probe_T_sip7_main_Probe_Reserved_144 @0x284 {
                bytes 4;
                field ccf_Probe_T_sip7_main_Probe_Reserved_144 {
                    bits 32;
                    access rw;
                    hard_reset 'h0;
                }
            }
            register ccf_Probe_T_sip7_main_Probe_Reserved_145 @0x288 {
                bytes 4;
                field ccf_Probe_T_sip7_main_Probe_Reserved_145 {
                    bits 32;
                    access rw;
                    hard_reset 'h0;
                }
            }
            register ccf_Probe_T_sip7_main_Probe_Reserved_146 @0x28C {
                bytes 4;
                field ccf_Probe_T_sip7_main_Probe_Reserved_146 {
                    bits 32;
                    access rw;
                    hard_reset 'h0;
                }
            }
            register ccf_Probe_T_sip7_main_Probe_Reserved_147 @0x290 {
                bytes 4;
                field ccf_Probe_T_sip7_main_Probe_Reserved_147 {
                    bits 32;
                    access rw;
                    hard_reset 'h0;
                }
            }
            register ccf_Probe_T_sip7_main_Probe_Reserved_148 @0x294 {
                bytes 4;
                field ccf_Probe_T_sip7_main_Probe_Reserved_148 {
                    bits 32;
                    access rw;
                    hard_reset 'h0;
                }
            }
            register ccf_Probe_T_sip7_main_Probe_Reserved_149 @0x298 {
                bytes 4;
                field ccf_Probe_T_sip7_main_Probe_Reserved_149 {
                    bits 32;
                    access rw;
                    hard_reset 'h0;
                }
            }
            register ccf_Probe_T_sip7_main_Probe_Reserved_150 @0x29C {
                bytes 4;
                field ccf_Probe_T_sip7_main_Probe_Reserved_150 {
                    bits 32;
                    access rw;
                    hard_reset 'h0;
                }
            }
            register ccf_Probe_T_sip7_main_Probe_Reserved_151 @0x2A0 {
                bytes 4;
                field ccf_Probe_T_sip7_main_Probe_Reserved_151 {
                    bits 32;
                    access rw;
                    hard_reset 'h0;
                }
            }
            register ccf_Probe_T_sip7_main_Probe_Reserved_152 @0x2A4 {
                bytes 4;
                field ccf_Probe_T_sip7_main_Probe_Reserved_152 {
                    bits 32;
                    access rw;
                    hard_reset 'h0;
                }
            }
            register ccf_Probe_T_sip7_main_Probe_Reserved_153 @0x2A8 {
                bytes 4;
                field ccf_Probe_T_sip7_main_Probe_Reserved_153 {
                    bits 32;
                    access rw;
                    hard_reset 'h0;
                }
            }
            register ccf_Probe_T_sip7_main_Probe_Reserved_154 @0x2AC {
                bytes 4;
                field ccf_Probe_T_sip7_main_Probe_Reserved_154 {
                    bits 32;
                    access rw;
                    hard_reset 'h0;
                }
            }
            register ccf_Probe_T_sip7_main_Probe_Reserved_155 @0x2B0 {
                bytes 4;
                field ccf_Probe_T_sip7_main_Probe_Reserved_155 {
                    bits 32;
                    access rw;
                    hard_reset 'h0;
                }
            }
            register ccf_Probe_T_sip7_main_Probe_Reserved_156 @0x2B4 {
                bytes 4;
                field ccf_Probe_T_sip7_main_Probe_Reserved_156 {
                    bits 32;
                    access rw;
                    hard_reset 'h0;
                }
            }
            register ccf_Probe_T_sip7_main_Probe_Reserved_157 @0x2B8 {
                bytes 4;
                field ccf_Probe_T_sip7_main_Probe_Reserved_157 {
                    bits 32;
                    access rw;
                    hard_reset 'h0;
                }
            }
            register ccf_Probe_T_sip7_main_Probe_Reserved_158 @0x2BC {
                bytes 4;
                field ccf_Probe_T_sip7_main_Probe_Reserved_158 {
                    bits 32;
                    access rw;
                    hard_reset 'h0;
                }
            }
            register ccf_Probe_T_sip7_main_Probe_Reserved_159 @0x2C0 {
                bytes 4;
                field ccf_Probe_T_sip7_main_Probe_Reserved_159 {
                    bits 32;
                    access rw;
                    hard_reset 'h0;
                }
            }
            register ccf_Probe_T_sip7_main_Probe_Reserved_160 @0x2C4 {
                bytes 4;
                field ccf_Probe_T_sip7_main_Probe_Reserved_160 {
                    bits 32;
                    access rw;
                    hard_reset 'h0;
                }
            }
            register ccf_Probe_T_sip7_main_Probe_Reserved_161 @0x2C8 {
                bytes 4;
                field ccf_Probe_T_sip7_main_Probe_Reserved_161 {
                    bits 32;
                    access rw;
                    hard_reset 'h0;
                }
            }
            register ccf_Probe_T_sip7_main_Probe_Reserved_162 @0x2CC {
                bytes 4;
                field ccf_Probe_T_sip7_main_Probe_Reserved_162 {
                    bits 32;
                    access rw;
                    hard_reset 'h0;
                }
            }
            register ccf_Probe_T_sip7_main_Probe_Reserved_163 @0x2D0 {
                bytes 4;
                field ccf_Probe_T_sip7_main_Probe_Reserved_163 {
                    bits 32;
                    access rw;
                    hard_reset 'h0;
                }
            }
            register ccf_Probe_T_sip7_main_Probe_Reserved_164 @0x2D4 {
                bytes 4;
                field ccf_Probe_T_sip7_main_Probe_Reserved_164 {
                    bits 32;
                    access rw;
                    hard_reset 'h0;
                }
            }
            register ccf_Probe_T_sip7_main_Probe_Reserved_165 @0x2D8 {
                bytes 4;
                field ccf_Probe_T_sip7_main_Probe_Reserved_165 {
                    bits 32;
                    access rw;
                    hard_reset 'h0;
                }
            }
            register ccf_Probe_T_sip7_main_Probe_Reserved_166 @0x2DC {
                bytes 4;
                field ccf_Probe_T_sip7_main_Probe_Reserved_166 {
                    bits 32;
                    access rw;
                    hard_reset 'h0;
                }
            }
            register ccf_Probe_T_sip7_main_Probe_Reserved_167 @0x2E0 {
                bytes 4;
                field ccf_Probe_T_sip7_main_Probe_Reserved_167 {
                    bits 32;
                    access rw;
                    hard_reset 'h0;
                }
            }
            register ccf_Probe_T_sip7_main_Probe_Reserved_168 @0x2E4 {
                bytes 4;
                field ccf_Probe_T_sip7_main_Probe_Reserved_168 {
                    bits 32;
                    access rw;
                    hard_reset 'h0;
                }
            }
            register ccf_Probe_T_sip7_main_Probe_Reserved_169 @0x2E8 {
                bytes 4;
                field ccf_Probe_T_sip7_main_Probe_Reserved_169 {
                    bits 32;
                    access rw;
                    hard_reset 'h0;
                }
            }
            register ccf_Probe_T_sip7_main_Probe_Reserved_170 @0x2EC {
                bytes 4;
                field ccf_Probe_T_sip7_main_Probe_Reserved_170 {
                    bits 32;
                    access rw;
                    hard_reset 'h0;
                }
            }
            register ccf_Probe_T_sip7_main_Probe_Reserved_171 @0x2F0 {
                bytes 4;
                field ccf_Probe_T_sip7_main_Probe_Reserved_171 {
                    bits 32;
                    access rw;
                    hard_reset 'h0;
                }
            }
            register ccf_Probe_T_sip7_main_Probe_Reserved_172 @0x2F4 {
                bytes 4;
                field ccf_Probe_T_sip7_main_Probe_Reserved_172 {
                    bits 32;
                    access rw;
                    hard_reset 'h0;
                }
            }
            register ccf_Probe_T_sip7_main_Probe_Reserved_173 @0x2F8 {
                bytes 4;
                field ccf_Probe_T_sip7_main_Probe_Reserved_173 {
                    bits 32;
                    access rw;
                    hard_reset 'h0;
                }
            }
            register ccf_Probe_T_sip7_main_Probe_Reserved_174 @0x2FC {
                bytes 4;
                field ccf_Probe_T_sip7_main_Probe_Reserved_174 {
                    bits 32;
                    access rw;
                    hard_reset 'h0;
                }
            }
            register ccf_Probe_T_sip7_main_Probe_Reserved_175 @0x300 {
                bytes 4;
                field ccf_Probe_T_sip7_main_Probe_Reserved_175 {
                    bits 32;
                    access rw;
                    hard_reset 'h0;
                }
            }
            register ccf_Probe_T_sip7_main_Probe_Reserved_176 @0x304 {
                bytes 4;
                field ccf_Probe_T_sip7_main_Probe_Reserved_176 {
                    bits 32;
                    access rw;
                    hard_reset 'h0;
                }
            }
            register ccf_Probe_T_sip7_main_Probe_Reserved_177 @0x308 {
                bytes 4;
                field ccf_Probe_T_sip7_main_Probe_Reserved_177 {
                    bits 32;
                    access rw;
                    hard_reset 'h0;
                }
            }
            register ccf_Probe_T_sip7_main_Probe_Reserved_178 @0x30C {
                bytes 4;
                field ccf_Probe_T_sip7_main_Probe_Reserved_178 {
                    bits 32;
                    access rw;
                    hard_reset 'h0;
                }
            }
            register ccf_Probe_T_sip7_main_Probe_Reserved_179 @0x310 {
                bytes 4;
                field ccf_Probe_T_sip7_main_Probe_Reserved_179 {
                    bits 32;
                    access rw;
                    hard_reset 'h0;
                }
            }
            register ccf_Probe_T_sip7_main_Probe_Reserved_180 @0x314 {
                bytes 4;
                field ccf_Probe_T_sip7_main_Probe_Reserved_180 {
                    bits 32;
                    access rw;
                    hard_reset 'h0;
                }
            }
            register ccf_Probe_T_sip7_main_Probe_Reserved_181 @0x318 {
                bytes 4;
                field ccf_Probe_T_sip7_main_Probe_Reserved_181 {
                    bits 32;
                    access rw;
                    hard_reset 'h0;
                }
            }
            register ccf_Probe_T_sip7_main_Probe_Reserved_182 @0x31C {
                bytes 4;
                field ccf_Probe_T_sip7_main_Probe_Reserved_182 {
                    bits 32;
                    access rw;
                    hard_reset 'h0;
                }
            }
            register ccf_Probe_T_sip7_main_Probe_Reserved_183 @0x320 {
                bytes 4;
                field ccf_Probe_T_sip7_main_Probe_Reserved_183 {
                    bits 32;
                    access rw;
                    hard_reset 'h0;
                }
            }
            register ccf_Probe_T_sip7_main_Probe_Reserved_184 @0x324 {
                bytes 4;
                field ccf_Probe_T_sip7_main_Probe_Reserved_184 {
                    bits 32;
                    access rw;
                    hard_reset 'h0;
                }
            }
            register ccf_Probe_T_sip7_main_Probe_Reserved_185 @0x328 {
                bytes 4;
                field ccf_Probe_T_sip7_main_Probe_Reserved_185 {
                    bits 32;
                    access rw;
                    hard_reset 'h0;
                }
            }
            register ccf_Probe_T_sip7_main_Probe_Reserved_186 @0x32C {
                bytes 4;
                field ccf_Probe_T_sip7_main_Probe_Reserved_186 {
                    bits 32;
                    access rw;
                    hard_reset 'h0;
                }
            }
            register ccf_Probe_T_sip7_main_Probe_Reserved_187 @0x330 {
                bytes 4;
                field ccf_Probe_T_sip7_main_Probe_Reserved_187 {
                    bits 32;
                    access rw;
                    hard_reset 'h0;
                }
            }
            register ccf_Probe_T_sip7_main_Probe_Reserved_188 @0x334 {
                bytes 4;
                field ccf_Probe_T_sip7_main_Probe_Reserved_188 {
                    bits 32;
                    access rw;
                    hard_reset 'h0;
                }
            }
            register ccf_Probe_T_sip7_main_Probe_Reserved_189 @0x338 {
                bytes 4;
                field ccf_Probe_T_sip7_main_Probe_Reserved_189 {
                    bits 32;
                    access rw;
                    hard_reset 'h0;
                }
            }
            register ccf_Probe_T_sip7_main_Probe_Reserved_190 @0x33C {
                bytes 4;
                field ccf_Probe_T_sip7_main_Probe_Reserved_190 {
                    bits 32;
                    access rw;
                    hard_reset 'h0;
                }
            }
            register ccf_Probe_T_sip7_main_Probe_Reserved_191 @0x340 {
                bytes 4;
                field ccf_Probe_T_sip7_main_Probe_Reserved_191 {
                    bits 32;
                    access rw;
                    hard_reset 'h0;
                }
            }
            register ccf_Probe_T_sip7_main_Probe_Reserved_192 @0x344 {
                bytes 4;
                field ccf_Probe_T_sip7_main_Probe_Reserved_192 {
                    bits 32;
                    access rw;
                    hard_reset 'h0;
                }
            }
            register ccf_Probe_T_sip7_main_Probe_Reserved_193 @0x348 {
                bytes 4;
                field ccf_Probe_T_sip7_main_Probe_Reserved_193 {
                    bits 32;
                    access rw;
                    hard_reset 'h0;
                }
            }
            register ccf_Probe_T_sip7_main_Probe_Reserved_194 @0x34C {
                bytes 4;
                field ccf_Probe_T_sip7_main_Probe_Reserved_194 {
                    bits 32;
                    access rw;
                    hard_reset 'h0;
                }
            }
            register ccf_Probe_T_sip7_main_Probe_Reserved_195 @0x350 {
                bytes 4;
                field ccf_Probe_T_sip7_main_Probe_Reserved_195 {
                    bits 32;
                    access rw;
                    hard_reset 'h0;
                }
            }
            register ccf_Probe_T_sip7_main_Probe_Reserved_196 @0x354 {
                bytes 4;
                field ccf_Probe_T_sip7_main_Probe_Reserved_196 {
                    bits 32;
                    access rw;
                    hard_reset 'h0;
                }
            }
            register ccf_Probe_T_sip7_main_Probe_Reserved_197 @0x358 {
                bytes 4;
                field ccf_Probe_T_sip7_main_Probe_Reserved_197 {
                    bits 32;
                    access rw;
                    hard_reset 'h0;
                }
            }
            register ccf_Probe_T_sip7_main_Probe_Reserved_198 @0x35C {
                bytes 4;
                field ccf_Probe_T_sip7_main_Probe_Reserved_198 {
                    bits 32;
                    access rw;
                    hard_reset 'h0;
                }
            }
            register ccf_Probe_T_sip7_main_Probe_Reserved_199 @0x360 {
                bytes 4;
                field ccf_Probe_T_sip7_main_Probe_Reserved_199 {
                    bits 32;
                    access rw;
                    hard_reset 'h0;
                }
            }
            register ccf_Probe_T_sip7_main_Probe_Reserved_200 @0x364 {
                bytes 4;
                field ccf_Probe_T_sip7_main_Probe_Reserved_200 {
                    bits 32;
                    access rw;
                    hard_reset 'h0;
                }
            }
            register ccf_Probe_T_sip7_main_Probe_Reserved_201 @0x368 {
                bytes 4;
                field ccf_Probe_T_sip7_main_Probe_Reserved_201 {
                    bits 32;
                    access rw;
                    hard_reset 'h0;
                }
            }
            register ccf_Probe_T_sip7_main_Probe_Reserved_202 @0x36C {
                bytes 4;
                field ccf_Probe_T_sip7_main_Probe_Reserved_202 {
                    bits 32;
                    access rw;
                    hard_reset 'h0;
                }
            }
            register ccf_Probe_T_sip7_main_Probe_Reserved_203 @0x370 {
                bytes 4;
                field ccf_Probe_T_sip7_main_Probe_Reserved_203 {
                    bits 32;
                    access rw;
                    hard_reset 'h0;
                }
            }
            register ccf_Probe_T_sip7_main_Probe_Reserved_204 @0x374 {
                bytes 4;
                field ccf_Probe_T_sip7_main_Probe_Reserved_204 {
                    bits 32;
                    access rw;
                    hard_reset 'h0;
                }
            }
            register ccf_Probe_T_sip7_main_Probe_Reserved_205 @0x378 {
                bytes 4;
                field ccf_Probe_T_sip7_main_Probe_Reserved_205 {
                    bits 32;
                    access rw;
                    hard_reset 'h0;
                }
            }
            register ccf_Probe_T_sip7_main_Probe_Reserved_206 @0x37C {
                bytes 4;
                field ccf_Probe_T_sip7_main_Probe_Reserved_206 {
                    bits 32;
                    access rw;
                    hard_reset 'h0;
                }
            }
            register ccf_Probe_T_sip7_main_Probe_Reserved_207 @0x380 {
                bytes 4;
                field ccf_Probe_T_sip7_main_Probe_Reserved_207 {
                    bits 32;
                    access rw;
                    hard_reset 'h0;
                }
            }
            register ccf_Probe_T_sip7_main_Probe_Reserved_208 @0x384 {
                bytes 4;
                field ccf_Probe_T_sip7_main_Probe_Reserved_208 {
                    bits 32;
                    access rw;
                    hard_reset 'h0;
                }
            }
            register ccf_Probe_T_sip7_main_Probe_Reserved_209 @0x388 {
                bytes 4;
                field ccf_Probe_T_sip7_main_Probe_Reserved_209 {
                    bits 32;
                    access rw;
                    hard_reset 'h0;
                }
            }
            register ccf_Probe_T_sip7_main_Probe_Reserved_210 @0x38C {
                bytes 4;
                field ccf_Probe_T_sip7_main_Probe_Reserved_210 {
                    bits 32;
                    access rw;
                    hard_reset 'h0;
                }
            }
            register ccf_Probe_T_sip7_main_Probe_Reserved_211 @0x390 {
                bytes 4;
                field ccf_Probe_T_sip7_main_Probe_Reserved_211 {
                    bits 32;
                    access rw;
                    hard_reset 'h0;
                }
            }
            register ccf_Probe_T_sip7_main_Probe_Reserved_212 @0x394 {
                bytes 4;
                field ccf_Probe_T_sip7_main_Probe_Reserved_212 {
                    bits 32;
                    access rw;
                    hard_reset 'h0;
                }
            }
            register ccf_Probe_T_sip7_main_Probe_Reserved_213 @0x398 {
                bytes 4;
                field ccf_Probe_T_sip7_main_Probe_Reserved_213 {
                    bits 32;
                    access rw;
                    hard_reset 'h0;
                }
            }
            register ccf_Probe_T_sip7_main_Probe_Reserved_214 @0x39C {
                bytes 4;
                field ccf_Probe_T_sip7_main_Probe_Reserved_214 {
                    bits 32;
                    access rw;
                    hard_reset 'h0;
                }
            }
            register ccf_Probe_T_sip7_main_Probe_Reserved_215 @0x3A0 {
                bytes 4;
                field ccf_Probe_T_sip7_main_Probe_Reserved_215 {
                    bits 32;
                    access rw;
                    hard_reset 'h0;
                }
            }
            register ccf_Probe_T_sip7_main_Probe_Reserved_216 @0x3A4 {
                bytes 4;
                field ccf_Probe_T_sip7_main_Probe_Reserved_216 {
                    bits 32;
                    access rw;
                    hard_reset 'h0;
                }
            }
            register ccf_Probe_T_sip7_main_Probe_Reserved_217 @0x3A8 {
                bytes 4;
                field ccf_Probe_T_sip7_main_Probe_Reserved_217 {
                    bits 32;
                    access rw;
                    hard_reset 'h0;
                }
            }
            register ccf_Probe_T_sip7_main_Probe_Reserved_218 @0x3AC {
                bytes 4;
                field ccf_Probe_T_sip7_main_Probe_Reserved_218 {
                    bits 32;
                    access rw;
                    hard_reset 'h0;
                }
            }
            register ccf_Probe_T_sip7_main_Probe_Reserved_219 @0x3B0 {
                bytes 4;
                field ccf_Probe_T_sip7_main_Probe_Reserved_219 {
                    bits 32;
                    access rw;
                    hard_reset 'h0;
                }
            }
            register ccf_Probe_T_sip7_main_Probe_Reserved_220 @0x3B4 {
                bytes 4;
                field ccf_Probe_T_sip7_main_Probe_Reserved_220 {
                    bits 32;
                    access rw;
                    hard_reset 'h0;
                }
            }
            register ccf_Probe_T_sip7_main_Probe_Reserved_221 @0x3B8 {
                bytes 4;
                field ccf_Probe_T_sip7_main_Probe_Reserved_221 {
                    bits 32;
                    access rw;
                    hard_reset 'h0;
                }
            }
            register ccf_Probe_T_sip7_main_Probe_Reserved_222 @0x3BC {
                bytes 4;
                field ccf_Probe_T_sip7_main_Probe_Reserved_222 {
                    bits 32;
                    access rw;
                    hard_reset 'h0;
                }
            }
            register ccf_Probe_T_sip7_main_Probe_Reserved_223 @0x3C0 {
                bytes 4;
                field ccf_Probe_T_sip7_main_Probe_Reserved_223 {
                    bits 32;
                    access rw;
                    hard_reset 'h0;
                }
            }
            register ccf_Probe_T_sip7_main_Probe_Reserved_224 @0x3C4 {
                bytes 4;
                field ccf_Probe_T_sip7_main_Probe_Reserved_224 {
                    bits 32;
                    access rw;
                    hard_reset 'h0;
                }
            }
            register ccf_Probe_T_sip7_main_Probe_Reserved_225 @0x3C8 {
                bytes 4;
                field ccf_Probe_T_sip7_main_Probe_Reserved_225 {
                    bits 32;
                    access rw;
                    hard_reset 'h0;
                }
            }
            register ccf_Probe_T_sip7_main_Probe_Reserved_226 @0x3CC {
                bytes 4;
                field ccf_Probe_T_sip7_main_Probe_Reserved_226 {
                    bits 32;
                    access rw;
                    hard_reset 'h0;
                }
            }
            register ccf_Probe_T_sip7_main_Probe_Reserved_227 @0x3D0 {
                bytes 4;
                field ccf_Probe_T_sip7_main_Probe_Reserved_227 {
                    bits 32;
                    access rw;
                    hard_reset 'h0;
                }
            }
            register ccf_Probe_T_sip7_main_Probe_Reserved_228 @0x3D4 {
                bytes 4;
                field ccf_Probe_T_sip7_main_Probe_Reserved_228 {
                    bits 32;
                    access rw;
                    hard_reset 'h0;
                }
            }
            register ccf_Probe_T_sip7_main_Probe_Reserved_229 @0x3D8 {
                bytes 4;
                field ccf_Probe_T_sip7_main_Probe_Reserved_229 {
                    bits 32;
                    access rw;
                    hard_reset 'h0;
                }
            }
            register ccf_Probe_T_sip7_main_Probe_Reserved_230 @0x3DC {
                bytes 4;
                field ccf_Probe_T_sip7_main_Probe_Reserved_230 {
                    bits 32;
                    access rw;
                    hard_reset 'h0;
                }
            }
            register ccf_Probe_T_sip7_main_Probe_Reserved_231 @0x3E0 {
                bytes 4;
                field ccf_Probe_T_sip7_main_Probe_Reserved_231 {
                    bits 32;
                    access rw;
                    hard_reset 'h0;
                }
            }
            register ccf_Probe_T_sip7_main_Probe_Reserved_232 @0x3E4 {
                bytes 4;
                field ccf_Probe_T_sip7_main_Probe_Reserved_232 {
                    bits 32;
                    access rw;
                    hard_reset 'h0;
                }
            }
            register ccf_Probe_T_sip7_main_Probe_Reserved_233 @0x3E8 {
                bytes 4;
                field ccf_Probe_T_sip7_main_Probe_Reserved_233 {
                    bits 32;
                    access rw;
                    hard_reset 'h0;
                }
            }
            register ccf_Probe_T_sip7_main_Probe_Reserved_234 @0x3EC {
                bytes 4;
                field ccf_Probe_T_sip7_main_Probe_Reserved_234 {
                    bits 32;
                    access rw;
                    hard_reset 'h0;
                }
            }
            register ccf_Probe_T_sip7_main_Probe_Reserved_235 @0x3F0 {
                bytes 4;
                field ccf_Probe_T_sip7_main_Probe_Reserved_235 {
                    bits 32;
                    access rw;
                    hard_reset 'h0;
                }
            }
            register ccf_Probe_T_sip7_main_Probe_Reserved_236 @0x3F4 {
                bytes 4;
                field ccf_Probe_T_sip7_main_Probe_Reserved_236 {
                    bits 32;
                    access rw;
                    hard_reset 'h0;
                }
            }
            register ccf_Probe_T_sip7_main_Probe_Reserved_237 @0x3F8 {
                bytes 4;
                field ccf_Probe_T_sip7_main_Probe_Reserved_237 {
                    bits 32;
                    access rw;
                    hard_reset 'h0;
                }
            }
            register ccf_Probe_T_sip7_main_Probe_Reserved_238 @0x3FC {
                bytes 4;
                field ccf_Probe_T_sip7_main_Probe_Reserved_238 {
                    bits 32;
                    access rw;
                    hard_reset 'h0;
                }
            }
        }
        block ecf_ccf_axi_ccf_Probe_T_cdma0_main_TransactionStatProfiler @0xDC000 {
            bytes 4;
            register ccf_Probe_T_cdma0_main_TransactionStatProfiler_Id_CoreId @0x0 {
                bytes 4;
                field CORETYPEID @'h0 {
                    bits 8;
                    access ro;
                    hard_reset 'ha;
                    doc {
                        Field identifying the type of IP.
                    }
                }
                field CORECHECKSUM @'h8 {
                    bits 24;
                    access ro;
                    hard_reset 'h65d666;
                    doc {
                        Field containing a checksum of the parameters of the IP.
                    }
                }
            }
            register ccf_Probe_T_cdma0_main_TransactionStatProfiler_Id_RevisionId @0x4 {
                bytes 4;
                field USERID @'h0 {
                    bits 8;
                    access ro;
                    hard_reset 'h0;
                    doc {
                        Field containing a user defined value, not used anywhere inside the IP itself.
                    }
                }
                field FLEXNOCID @'h8 {
                    bits 24;
                    access ro;
                    hard_reset 'h84f8c6;
                    doc {
                        Field containing the build revision of the software used to generate the IP HDL code.
                    }
                }
            }
            register ccf_Probe_T_cdma0_main_TransactionStatProfiler_En @0x8 {
                bytes 4;
                field EN @'h0 {
                    access rw;
                    hard_reset 'h0;
                    doc {
                        Register En is a 1-bit register that enables the transaction probe counter unit.
                    }
                }
            }
            register ccf_Probe_T_cdma0_main_TransactionStatProfiler_Mode @0xC {
                bytes 4;
                field MODE @'h0 {
                    access rw;
                    hard_reset 'h0;
                    doc {
                        Register Mode sets the counting mode per observed port. Each bit per observation port defines the incrementing mode. (Mode = 0 for Delay, Mode = 1 for Pending)
                    }
                }
            }
            register ccf_Probe_T_cdma0_main_TransactionStatProfiler_Reserved_00 @0x10 {
                bytes 4;
                field ccf_Probe_T_cdma0_main_TransactionStatProfiler_Reserved_00 {
                    bits 32;
                    access rw;
                    hard_reset 'h0;
                }
            }
            register ccf_Probe_T_cdma0_main_TransactionStatProfiler_Reserved_01 @0x14 {
                bytes 4;
                field ccf_Probe_T_cdma0_main_TransactionStatProfiler_Reserved_01 {
                    bits 32;
                    access rw;
                    hard_reset 'h0;
                }
            }
            register ccf_Probe_T_cdma0_main_TransactionStatProfiler_Reserved_02 @0x18 {
                bytes 4;
                field ccf_Probe_T_cdma0_main_TransactionStatProfiler_Reserved_02 {
                    bits 32;
                    access rw;
                    hard_reset 'h0;
                }
            }
            register ccf_Probe_T_cdma0_main_TransactionStatProfiler_Reserved_03 @0x1C {
                bytes 4;
                field ccf_Probe_T_cdma0_main_TransactionStatProfiler_Reserved_03 {
                    bits 32;
                    access rw;
                    hard_reset 'h0;
                }
            }
            register ccf_Probe_T_cdma0_main_TransactionStatProfiler_Reserved_04 @0x20 {
                bytes 4;
                field ccf_Probe_T_cdma0_main_TransactionStatProfiler_Reserved_04 {
                    bits 32;
                    access rw;
                    hard_reset 'h0;
                }
            }
            register ccf_Probe_T_cdma0_main_TransactionStatProfiler_Reserved_05 @0x24 {
                bytes 4;
                field ccf_Probe_T_cdma0_main_TransactionStatProfiler_Reserved_05 {
                    bits 32;
                    access rw;
                    hard_reset 'h0;
                }
            }
            register ccf_Probe_T_cdma0_main_TransactionStatProfiler_Reserved_06 @0x28 {
                bytes 4;
                field ccf_Probe_T_cdma0_main_TransactionStatProfiler_Reserved_06 {
                    bits 32;
                    access rw;
                    hard_reset 'h0;
                }
            }
            register ccf_Probe_T_cdma0_main_TransactionStatProfiler_Thresholds_0_0 @0x2C {
                bytes 4;
                field THRESHOLDS_0_0 @'h0 {
                    bits 8;
                    access rw;
                    hard_reset 'h0;
                    doc {
                        Register Thresholds_i_j contains the threshold index "0" that allows computation of threshold values.
                    }
                }
            }
            register ccf_Probe_T_cdma0_main_TransactionStatProfiler_Reserved_07 @0x30 {
                bytes 4;
                field ccf_Probe_T_cdma0_main_TransactionStatProfiler_Reserved_07 {
                    bits 32;
                    access rw;
                    hard_reset 'h0;
                }
            }
            register ccf_Probe_T_cdma0_main_TransactionStatProfiler_Reserved_08 @0x34 {
                bytes 4;
                field ccf_Probe_T_cdma0_main_TransactionStatProfiler_Reserved_08 {
                    bits 32;
                    access rw;
                    hard_reset 'h0;
                }
            }
            register ccf_Probe_T_cdma0_main_TransactionStatProfiler_Reserved_09 @0x38 {
                bytes 4;
                field ccf_Probe_T_cdma0_main_TransactionStatProfiler_Reserved_09 {
                    bits 32;
                    access rw;
                    hard_reset 'h0;
                }
            }
            register ccf_Probe_T_cdma0_main_TransactionStatProfiler_Reserved_10 @0x3C {
                bytes 4;
                field ccf_Probe_T_cdma0_main_TransactionStatProfiler_Reserved_10 {
                    bits 32;
                    access rw;
                    hard_reset 'h0;
                }
            }
            register ccf_Probe_T_cdma0_main_TransactionStatProfiler_Reserved_11 @0x40 {
                bytes 4;
                field ccf_Probe_T_cdma0_main_TransactionStatProfiler_Reserved_11 {
                    bits 32;
                    access rw;
                    hard_reset 'h0;
                }
            }
            register ccf_Probe_T_cdma0_main_TransactionStatProfiler_Reserved_12 @0x44 {
                bytes 4;
                field ccf_Probe_T_cdma0_main_TransactionStatProfiler_Reserved_12 {
                    bits 32;
                    access rw;
                    hard_reset 'h0;
                }
            }
            register ccf_Probe_T_cdma0_main_TransactionStatProfiler_Reserved_13 @0x48 {
                bytes 4;
                field ccf_Probe_T_cdma0_main_TransactionStatProfiler_Reserved_13 {
                    bits 32;
                    access rw;
                    hard_reset 'h0;
                }
            }
            register ccf_Probe_T_cdma0_main_TransactionStatProfiler_Reserved_14 @0x4C {
                bytes 4;
                field ccf_Probe_T_cdma0_main_TransactionStatProfiler_Reserved_14 {
                    bits 32;
                    access rw;
                    hard_reset 'h0;
                }
            }
            register ccf_Probe_T_cdma0_main_TransactionStatProfiler_Reserved_15 @0x50 {
                bytes 4;
                field ccf_Probe_T_cdma0_main_TransactionStatProfiler_Reserved_15 {
                    bits 32;
                    access rw;
                    hard_reset 'h0;
                }
            }
            register ccf_Probe_T_cdma0_main_TransactionStatProfiler_Reserved_16 @0x54 {
                bytes 4;
                field ccf_Probe_T_cdma0_main_TransactionStatProfiler_Reserved_16 {
                    bits 32;
                    access rw;
                    hard_reset 'h0;
                }
            }
            register ccf_Probe_T_cdma0_main_TransactionStatProfiler_Reserved_17 @0x58 {
                bytes 4;
                field ccf_Probe_T_cdma0_main_TransactionStatProfiler_Reserved_17 {
                    bits 32;
                    access rw;
                    hard_reset 'h0;
                }
            }
            register ccf_Probe_T_cdma0_main_TransactionStatProfiler_Reserved_18 @0x5C {
                bytes 4;
                field ccf_Probe_T_cdma0_main_TransactionStatProfiler_Reserved_18 {
                    bits 32;
                    access rw;
                    hard_reset 'h0;
                }
            }
            register ccf_Probe_T_cdma0_main_TransactionStatProfiler_Reserved_19 @0x60 {
                bytes 4;
                field ccf_Probe_T_cdma0_main_TransactionStatProfiler_Reserved_19 {
                    bits 32;
                    access rw;
                    hard_reset 'h0;
                }
            }
            register ccf_Probe_T_cdma0_main_TransactionStatProfiler_Reserved_20 @0x64 {
                bytes 4;
                field ccf_Probe_T_cdma0_main_TransactionStatProfiler_Reserved_20 {
                    bits 32;
                    access rw;
                    hard_reset 'h0;
                }
            }
            register ccf_Probe_T_cdma0_main_TransactionStatProfiler_Reserved_21 @0x68 {
                bytes 4;
                field ccf_Probe_T_cdma0_main_TransactionStatProfiler_Reserved_21 {
                    bits 32;
                    access rw;
                    hard_reset 'h0;
                }
            }
            register ccf_Probe_T_cdma0_main_TransactionStatProfiler_OverflowStatus @0x6C {
                bytes 4;
                field OVERFLOWSTATUS @'h0 {
                    access ro;
                    hard_reset 'h0;
                    doc {
                        Bit n of register OverflowStatus is set to 1 if a start event occurs on observed port n and eitherof the following conditions occurs: All tenure counters allocated to the port are already in use. No tenure lines have been allocated to the port. The number of bits in this register is equal to the value set for parameter nObservable.
                    }
                }
            }
            register ccf_Probe_T_cdma0_main_TransactionStatProfiler_OverflowReset @0x70 {
                bytes 4;
                field OVERFLOWRESET @'h0 {
                    access w1c;
                    hard_reset 'h0;
                    doc {
                        Register OverflowReset is a pulse register that clears overflow status bits per observed port on each write access. OverflowReset = nObservable. Writing 0x2  clears the overflow status of observed port 1.
                    }
                }
            }
            register ccf_Probe_T_cdma0_main_TransactionStatProfiler_PendingEventMode @0x74 {
                bytes 4;
                field PENDINGEVENTMODE @'h0 {
                    access rw;
                    hard_reset 'h0;
                    doc {
                        Register pendingEventMode is a 1-bit register that configures the pending event mode. When set to 0 (CYCLE), and when register mode is set to PENDING, the pending event is generated on each cycle when the counter is greater than zero.When set to 1 (STOP) the pending event is generated on each stop event.
                    }
                }
            }
            register ccf_Probe_T_cdma0_main_TransactionStatProfiler_PreScaler @0x78 {
                bytes 4;
                field PRESCALER @'h0 {
                    bits 8;
                    access rw;
                    hard_reset 'h0;
                    doc {
                        8Register Prescaler is an-bit pre-scaling register that accepts any pre-scaling value between 1 (default) and 256. If set to 0, pre-scaling is disabled. If set to any other supported value "n", the threshold counter value is divided by (n + 1).
                    }
                }
            }
            register ccf_Probe_T_cdma0_main_TransactionStatProfiler_Reserved_22 @0x7C {
                bytes 4;
                field ccf_Probe_T_cdma0_main_TransactionStatProfiler_Reserved_22 {
                    bits 32;
                    access rw;
                    hard_reset 'h0;
                }
            }
        }
        block ecf_ccf_axi_ccf_Probe_T_cdma1_main_TransactionStatProfiler @0xDC080 {
            bytes 4;
            register ccf_Probe_T_cdma1_main_TransactionStatProfiler_Id_CoreId @0x0 {
                bytes 4;
                field CORETYPEID @'h0 {
                    bits 8;
                    access ro;
                    hard_reset 'ha;
                    doc {
                        Field identifying the type of IP.
                    }
                }
                field CORECHECKSUM @'h8 {
                    bits 24;
                    access ro;
                    hard_reset 'hf31ff0;
                    doc {
                        Field containing a checksum of the parameters of the IP.
                    }
                }
            }
            register ccf_Probe_T_cdma1_main_TransactionStatProfiler_Id_RevisionId @0x4 {
                bytes 4;
                field USERID @'h0 {
                    bits 8;
                    access ro;
                    hard_reset 'h0;
                    doc {
                        Field containing a user defined value, not used anywhere inside the IP itself.
                    }
                }
                field FLEXNOCID @'h8 {
                    bits 24;
                    access ro;
                    hard_reset 'h84f8c6;
                    doc {
                        Field containing the build revision of the software used to generate the IP HDL code.
                    }
                }
            }
            register ccf_Probe_T_cdma1_main_TransactionStatProfiler_En @0x8 {
                bytes 4;
                field EN @'h0 {
                    access rw;
                    hard_reset 'h0;
                    doc {
                        Register En is a 1-bit register that enables the transaction probe counter unit.
                    }
                }
            }
            register ccf_Probe_T_cdma1_main_TransactionStatProfiler_Mode @0xC {
                bytes 4;
                field MODE @'h0 {
                    access rw;
                    hard_reset 'h0;
                    doc {
                        Register Mode sets the counting mode per observed port. Each bit per observation port defines the incrementing mode. (Mode = 0 for Delay, Mode = 1 for Pending)
                    }
                }
            }
            register ccf_Probe_T_cdma1_main_TransactionStatProfiler_Reserved_00 @0x10 {
                bytes 4;
                field ccf_Probe_T_cdma1_main_TransactionStatProfiler_Reserved_00 {
                    bits 32;
                    access rw;
                    hard_reset 'h0;
                }
            }
            register ccf_Probe_T_cdma1_main_TransactionStatProfiler_Reserved_01 @0x14 {
                bytes 4;
                field ccf_Probe_T_cdma1_main_TransactionStatProfiler_Reserved_01 {
                    bits 32;
                    access rw;
                    hard_reset 'h0;
                }
            }
            register ccf_Probe_T_cdma1_main_TransactionStatProfiler_Reserved_02 @0x18 {
                bytes 4;
                field ccf_Probe_T_cdma1_main_TransactionStatProfiler_Reserved_02 {
                    bits 32;
                    access rw;
                    hard_reset 'h0;
                }
            }
            register ccf_Probe_T_cdma1_main_TransactionStatProfiler_Reserved_03 @0x1C {
                bytes 4;
                field ccf_Probe_T_cdma1_main_TransactionStatProfiler_Reserved_03 {
                    bits 32;
                    access rw;
                    hard_reset 'h0;
                }
            }
            register ccf_Probe_T_cdma1_main_TransactionStatProfiler_Reserved_04 @0x20 {
                bytes 4;
                field ccf_Probe_T_cdma1_main_TransactionStatProfiler_Reserved_04 {
                    bits 32;
                    access rw;
                    hard_reset 'h0;
                }
            }
            register ccf_Probe_T_cdma1_main_TransactionStatProfiler_Reserved_05 @0x24 {
                bytes 4;
                field ccf_Probe_T_cdma1_main_TransactionStatProfiler_Reserved_05 {
                    bits 32;
                    access rw;
                    hard_reset 'h0;
                }
            }
            register ccf_Probe_T_cdma1_main_TransactionStatProfiler_Reserved_06 @0x28 {
                bytes 4;
                field ccf_Probe_T_cdma1_main_TransactionStatProfiler_Reserved_06 {
                    bits 32;
                    access rw;
                    hard_reset 'h0;
                }
            }
            register ccf_Probe_T_cdma1_main_TransactionStatProfiler_Thresholds_0_0 @0x2C {
                bytes 4;
                field THRESHOLDS_0_0 @'h0 {
                    bits 8;
                    access rw;
                    hard_reset 'h0;
                    doc {
                        Register Thresholds_i_j contains the threshold index "0" that allows computation of threshold values.
                    }
                }
            }
            register ccf_Probe_T_cdma1_main_TransactionStatProfiler_Reserved_07 @0x30 {
                bytes 4;
                field ccf_Probe_T_cdma1_main_TransactionStatProfiler_Reserved_07 {
                    bits 32;
                    access rw;
                    hard_reset 'h0;
                }
            }
            register ccf_Probe_T_cdma1_main_TransactionStatProfiler_Reserved_08 @0x34 {
                bytes 4;
                field ccf_Probe_T_cdma1_main_TransactionStatProfiler_Reserved_08 {
                    bits 32;
                    access rw;
                    hard_reset 'h0;
                }
            }
            register ccf_Probe_T_cdma1_main_TransactionStatProfiler_Reserved_09 @0x38 {
                bytes 4;
                field ccf_Probe_T_cdma1_main_TransactionStatProfiler_Reserved_09 {
                    bits 32;
                    access rw;
                    hard_reset 'h0;
                }
            }
            register ccf_Probe_T_cdma1_main_TransactionStatProfiler_Reserved_10 @0x3C {
                bytes 4;
                field ccf_Probe_T_cdma1_main_TransactionStatProfiler_Reserved_10 {
                    bits 32;
                    access rw;
                    hard_reset 'h0;
                }
            }
            register ccf_Probe_T_cdma1_main_TransactionStatProfiler_Reserved_11 @0x40 {
                bytes 4;
                field ccf_Probe_T_cdma1_main_TransactionStatProfiler_Reserved_11 {
                    bits 32;
                    access rw;
                    hard_reset 'h0;
                }
            }
            register ccf_Probe_T_cdma1_main_TransactionStatProfiler_Reserved_12 @0x44 {
                bytes 4;
                field ccf_Probe_T_cdma1_main_TransactionStatProfiler_Reserved_12 {
                    bits 32;
                    access rw;
                    hard_reset 'h0;
                }
            }
            register ccf_Probe_T_cdma1_main_TransactionStatProfiler_Reserved_13 @0x48 {
                bytes 4;
                field ccf_Probe_T_cdma1_main_TransactionStatProfiler_Reserved_13 {
                    bits 32;
                    access rw;
                    hard_reset 'h0;
                }
            }
            register ccf_Probe_T_cdma1_main_TransactionStatProfiler_Reserved_14 @0x4C {
                bytes 4;
                field ccf_Probe_T_cdma1_main_TransactionStatProfiler_Reserved_14 {
                    bits 32;
                    access rw;
                    hard_reset 'h0;
                }
            }
            register ccf_Probe_T_cdma1_main_TransactionStatProfiler_Reserved_15 @0x50 {
                bytes 4;
                field ccf_Probe_T_cdma1_main_TransactionStatProfiler_Reserved_15 {
                    bits 32;
                    access rw;
                    hard_reset 'h0;
                }
            }
            register ccf_Probe_T_cdma1_main_TransactionStatProfiler_Reserved_16 @0x54 {
                bytes 4;
                field ccf_Probe_T_cdma1_main_TransactionStatProfiler_Reserved_16 {
                    bits 32;
                    access rw;
                    hard_reset 'h0;
                }
            }
            register ccf_Probe_T_cdma1_main_TransactionStatProfiler_Reserved_17 @0x58 {
                bytes 4;
                field ccf_Probe_T_cdma1_main_TransactionStatProfiler_Reserved_17 {
                    bits 32;
                    access rw;
                    hard_reset 'h0;
                }
            }
            register ccf_Probe_T_cdma1_main_TransactionStatProfiler_Reserved_18 @0x5C {
                bytes 4;
                field ccf_Probe_T_cdma1_main_TransactionStatProfiler_Reserved_18 {
                    bits 32;
                    access rw;
                    hard_reset 'h0;
                }
            }
            register ccf_Probe_T_cdma1_main_TransactionStatProfiler_Reserved_19 @0x60 {
                bytes 4;
                field ccf_Probe_T_cdma1_main_TransactionStatProfiler_Reserved_19 {
                    bits 32;
                    access rw;
                    hard_reset 'h0;
                }
            }
            register ccf_Probe_T_cdma1_main_TransactionStatProfiler_Reserved_20 @0x64 {
                bytes 4;
                field ccf_Probe_T_cdma1_main_TransactionStatProfiler_Reserved_20 {
                    bits 32;
                    access rw;
                    hard_reset 'h0;
                }
            }
            register ccf_Probe_T_cdma1_main_TransactionStatProfiler_Reserved_21 @0x68 {
                bytes 4;
                field ccf_Probe_T_cdma1_main_TransactionStatProfiler_Reserved_21 {
                    bits 32;
                    access rw;
                    hard_reset 'h0;
                }
            }
            register ccf_Probe_T_cdma1_main_TransactionStatProfiler_OverflowStatus @0x6C {
                bytes 4;
                field OVERFLOWSTATUS @'h0 {
                    access ro;
                    hard_reset 'h0;
                    doc {
                        Bit n of register OverflowStatus is set to 1 if a start event occurs on observed port n and eitherof the following conditions occurs: All tenure counters allocated to the port are already in use. No tenure lines have been allocated to the port. The number of bits in this register is equal to the value set for parameter nObservable.
                    }
                }
            }
            register ccf_Probe_T_cdma1_main_TransactionStatProfiler_OverflowReset @0x70 {
                bytes 4;
                field OVERFLOWRESET @'h0 {
                    access w1c;
                    hard_reset 'h0;
                    doc {
                        Register OverflowReset is a pulse register that clears overflow status bits per observed port on each write access. OverflowReset = nObservable. Writing 0x2  clears the overflow status of observed port 1.
                    }
                }
            }
            register ccf_Probe_T_cdma1_main_TransactionStatProfiler_PendingEventMode @0x74 {
                bytes 4;
                field PENDINGEVENTMODE @'h0 {
                    access rw;
                    hard_reset 'h0;
                    doc {
                        Register pendingEventMode is a 1-bit register that configures the pending event mode. When set to 0 (CYCLE), and when register mode is set to PENDING, the pending event is generated on each cycle when the counter is greater than zero.When set to 1 (STOP) the pending event is generated on each stop event.
                    }
                }
            }
            register ccf_Probe_T_cdma1_main_TransactionStatProfiler_PreScaler @0x78 {
                bytes 4;
                field PRESCALER @'h0 {
                    bits 8;
                    access rw;
                    hard_reset 'h0;
                    doc {
                        8Register Prescaler is an-bit pre-scaling register that accepts any pre-scaling value between 1 (default) and 256. If set to 0, pre-scaling is disabled. If set to any other supported value "n", the threshold counter value is divided by (n + 1).
                    }
                }
            }
            register ccf_Probe_T_cdma1_main_TransactionStatProfiler_Reserved_22 @0x7C {
                bytes 4;
                field ccf_Probe_T_cdma1_main_TransactionStatProfiler_Reserved_22 {
                    bits 32;
                    access rw;
                    hard_reset 'h0;
                }
            }
        }
        block ecf_ccf_axi_ccf_Probe_T_ecf_main_TransactionStatProfiler @0xDC100 {
            bytes 4;
            register ccf_Probe_T_ecf_main_TransactionStatProfiler_Id_CoreId @0x0 {
                bytes 4;
                field CORETYPEID @'h0 {
                    bits 8;
                    access ro;
                    hard_reset 'ha;
                    doc {
                        Field identifying the type of IP.
                    }
                }
                field CORECHECKSUM @'h8 {
                    bits 24;
                    access ro;
                    hard_reset 'hcc833f;
                    doc {
                        Field containing a checksum of the parameters of the IP.
                    }
                }
            }
            register ccf_Probe_T_ecf_main_TransactionStatProfiler_Id_RevisionId @0x4 {
                bytes 4;
                field USERID @'h0 {
                    bits 8;
                    access ro;
                    hard_reset 'h0;
                    doc {
                        Field containing a user defined value, not used anywhere inside the IP itself.
                    }
                }
                field FLEXNOCID @'h8 {
                    bits 24;
                    access ro;
                    hard_reset 'h84f8c6;
                    doc {
                        Field containing the build revision of the software used to generate the IP HDL code.
                    }
                }
            }
            register ccf_Probe_T_ecf_main_TransactionStatProfiler_En @0x8 {
                bytes 4;
                field EN @'h0 {
                    access rw;
                    hard_reset 'h0;
                    doc {
                        Register En is a 1-bit register that enables the transaction probe counter unit.
                    }
                }
            }
            register ccf_Probe_T_ecf_main_TransactionStatProfiler_Mode @0xC {
                bytes 4;
                field MODE @'h0 {
                    access rw;
                    hard_reset 'h0;
                    doc {
                        Register Mode sets the counting mode per observed port. Each bit per observation port defines the incrementing mode. (Mode = 0 for Delay, Mode = 1 for Pending)
                    }
                }
            }
            register ccf_Probe_T_ecf_main_TransactionStatProfiler_Reserved_00 @0x10 {
                bytes 4;
                field ccf_Probe_T_ecf_main_TransactionStatProfiler_Reserved_00 {
                    bits 32;
                    access rw;
                    hard_reset 'h0;
                }
            }
            register ccf_Probe_T_ecf_main_TransactionStatProfiler_Reserved_01 @0x14 {
                bytes 4;
                field ccf_Probe_T_ecf_main_TransactionStatProfiler_Reserved_01 {
                    bits 32;
                    access rw;
                    hard_reset 'h0;
                }
            }
            register ccf_Probe_T_ecf_main_TransactionStatProfiler_Reserved_02 @0x18 {
                bytes 4;
                field ccf_Probe_T_ecf_main_TransactionStatProfiler_Reserved_02 {
                    bits 32;
                    access rw;
                    hard_reset 'h0;
                }
            }
            register ccf_Probe_T_ecf_main_TransactionStatProfiler_Reserved_03 @0x1C {
                bytes 4;
                field ccf_Probe_T_ecf_main_TransactionStatProfiler_Reserved_03 {
                    bits 32;
                    access rw;
                    hard_reset 'h0;
                }
            }
            register ccf_Probe_T_ecf_main_TransactionStatProfiler_Reserved_04 @0x20 {
                bytes 4;
                field ccf_Probe_T_ecf_main_TransactionStatProfiler_Reserved_04 {
                    bits 32;
                    access rw;
                    hard_reset 'h0;
                }
            }
            register ccf_Probe_T_ecf_main_TransactionStatProfiler_Reserved_05 @0x24 {
                bytes 4;
                field ccf_Probe_T_ecf_main_TransactionStatProfiler_Reserved_05 {
                    bits 32;
                    access rw;
                    hard_reset 'h0;
                }
            }
            register ccf_Probe_T_ecf_main_TransactionStatProfiler_Reserved_06 @0x28 {
                bytes 4;
                field ccf_Probe_T_ecf_main_TransactionStatProfiler_Reserved_06 {
                    bits 32;
                    access rw;
                    hard_reset 'h0;
                }
            }
            register ccf_Probe_T_ecf_main_TransactionStatProfiler_Thresholds_0_0 @0x2C {
                bytes 4;
                field THRESHOLDS_0_0 @'h0 {
                    bits 8;
                    access rw;
                    hard_reset 'h0;
                    doc {
                        Register Thresholds_i_j contains the threshold index "0" that allows computation of threshold values.
                    }
                }
            }
            register ccf_Probe_T_ecf_main_TransactionStatProfiler_Reserved_07 @0x30 {
                bytes 4;
                field ccf_Probe_T_ecf_main_TransactionStatProfiler_Reserved_07 {
                    bits 32;
                    access rw;
                    hard_reset 'h0;
                }
            }
            register ccf_Probe_T_ecf_main_TransactionStatProfiler_Reserved_08 @0x34 {
                bytes 4;
                field ccf_Probe_T_ecf_main_TransactionStatProfiler_Reserved_08 {
                    bits 32;
                    access rw;
                    hard_reset 'h0;
                }
            }
            register ccf_Probe_T_ecf_main_TransactionStatProfiler_Reserved_09 @0x38 {
                bytes 4;
                field ccf_Probe_T_ecf_main_TransactionStatProfiler_Reserved_09 {
                    bits 32;
                    access rw;
                    hard_reset 'h0;
                }
            }
            register ccf_Probe_T_ecf_main_TransactionStatProfiler_Reserved_10 @0x3C {
                bytes 4;
                field ccf_Probe_T_ecf_main_TransactionStatProfiler_Reserved_10 {
                    bits 32;
                    access rw;
                    hard_reset 'h0;
                }
            }
            register ccf_Probe_T_ecf_main_TransactionStatProfiler_Reserved_11 @0x40 {
                bytes 4;
                field ccf_Probe_T_ecf_main_TransactionStatProfiler_Reserved_11 {
                    bits 32;
                    access rw;
                    hard_reset 'h0;
                }
            }
            register ccf_Probe_T_ecf_main_TransactionStatProfiler_Reserved_12 @0x44 {
                bytes 4;
                field ccf_Probe_T_ecf_main_TransactionStatProfiler_Reserved_12 {
                    bits 32;
                    access rw;
                    hard_reset 'h0;
                }
            }
            register ccf_Probe_T_ecf_main_TransactionStatProfiler_Reserved_13 @0x48 {
                bytes 4;
                field ccf_Probe_T_ecf_main_TransactionStatProfiler_Reserved_13 {
                    bits 32;
                    access rw;
                    hard_reset 'h0;
                }
            }
            register ccf_Probe_T_ecf_main_TransactionStatProfiler_Reserved_14 @0x4C {
                bytes 4;
                field ccf_Probe_T_ecf_main_TransactionStatProfiler_Reserved_14 {
                    bits 32;
                    access rw;
                    hard_reset 'h0;
                }
            }
            register ccf_Probe_T_ecf_main_TransactionStatProfiler_Reserved_15 @0x50 {
                bytes 4;
                field ccf_Probe_T_ecf_main_TransactionStatProfiler_Reserved_15 {
                    bits 32;
                    access rw;
                    hard_reset 'h0;
                }
            }
            register ccf_Probe_T_ecf_main_TransactionStatProfiler_Reserved_16 @0x54 {
                bytes 4;
                field ccf_Probe_T_ecf_main_TransactionStatProfiler_Reserved_16 {
                    bits 32;
                    access rw;
                    hard_reset 'h0;
                }
            }
            register ccf_Probe_T_ecf_main_TransactionStatProfiler_Reserved_17 @0x58 {
                bytes 4;
                field ccf_Probe_T_ecf_main_TransactionStatProfiler_Reserved_17 {
                    bits 32;
                    access rw;
                    hard_reset 'h0;
                }
            }
            register ccf_Probe_T_ecf_main_TransactionStatProfiler_Reserved_18 @0x5C {
                bytes 4;
                field ccf_Probe_T_ecf_main_TransactionStatProfiler_Reserved_18 {
                    bits 32;
                    access rw;
                    hard_reset 'h0;
                }
            }
            register ccf_Probe_T_ecf_main_TransactionStatProfiler_Reserved_19 @0x60 {
                bytes 4;
                field ccf_Probe_T_ecf_main_TransactionStatProfiler_Reserved_19 {
                    bits 32;
                    access rw;
                    hard_reset 'h0;
                }
            }
            register ccf_Probe_T_ecf_main_TransactionStatProfiler_Reserved_20 @0x64 {
                bytes 4;
                field ccf_Probe_T_ecf_main_TransactionStatProfiler_Reserved_20 {
                    bits 32;
                    access rw;
                    hard_reset 'h0;
                }
            }
            register ccf_Probe_T_ecf_main_TransactionStatProfiler_Reserved_21 @0x68 {
                bytes 4;
                field ccf_Probe_T_ecf_main_TransactionStatProfiler_Reserved_21 {
                    bits 32;
                    access rw;
                    hard_reset 'h0;
                }
            }
            register ccf_Probe_T_ecf_main_TransactionStatProfiler_OverflowStatus @0x6C {
                bytes 4;
                field OVERFLOWSTATUS @'h0 {
                    access ro;
                    hard_reset 'h0;
                    doc {
                        Bit n of register OverflowStatus is set to 1 if a start event occurs on observed port n and eitherof the following conditions occurs: All tenure counters allocated to the port are already in use. No tenure lines have been allocated to the port. The number of bits in this register is equal to the value set for parameter nObservable.
                    }
                }
            }
            register ccf_Probe_T_ecf_main_TransactionStatProfiler_OverflowReset @0x70 {
                bytes 4;
                field OVERFLOWRESET @'h0 {
                    access w1c;
                    hard_reset 'h0;
                    doc {
                        Register OverflowReset is a pulse register that clears overflow status bits per observed port on each write access. OverflowReset = nObservable. Writing 0x2  clears the overflow status of observed port 1.
                    }
                }
            }
            register ccf_Probe_T_ecf_main_TransactionStatProfiler_PendingEventMode @0x74 {
                bytes 4;
                field PENDINGEVENTMODE @'h0 {
                    access rw;
                    hard_reset 'h0;
                    doc {
                        Register pendingEventMode is a 1-bit register that configures the pending event mode. When set to 0 (CYCLE), and when register mode is set to PENDING, the pending event is generated on each cycle when the counter is greater than zero.When set to 1 (STOP) the pending event is generated on each stop event.
                    }
                }
            }
            register ccf_Probe_T_ecf_main_TransactionStatProfiler_PreScaler @0x78 {
                bytes 4;
                field PRESCALER @'h0 {
                    bits 8;
                    access rw;
                    hard_reset 'h0;
                    doc {
                        8Register Prescaler is an-bit pre-scaling register that accepts any pre-scaling value between 1 (default) and 256. If set to 0, pre-scaling is disabled. If set to any other supported value "n", the threshold counter value is divided by (n + 1).
                    }
                }
            }
            register ccf_Probe_T_ecf_main_TransactionStatProfiler_Reserved_22 @0x7C {
                bytes 4;
                field ccf_Probe_T_ecf_main_TransactionStatProfiler_Reserved_22 {
                    bits 32;
                    access rw;
                    hard_reset 'h0;
                }
            }
        }
        block ecf_ccf_axi_ccf_Probe_T_jtag_main_TransactionStatProfiler @0xDC180 {
            bytes 4;
            register ccf_Probe_T_jtag_main_TransactionStatProfiler_Id_CoreId @0x0 {
                bytes 4;
                field CORETYPEID @'h0 {
                    bits 8;
                    access ro;
                    hard_reset 'ha;
                    doc {
                        Field identifying the type of IP.
                    }
                }
                field CORECHECKSUM @'h8 {
                    bits 24;
                    access ro;
                    hard_reset 'hca0833;
                    doc {
                        Field containing a checksum of the parameters of the IP.
                    }
                }
            }
            register ccf_Probe_T_jtag_main_TransactionStatProfiler_Id_RevisionId @0x4 {
                bytes 4;
                field USERID @'h0 {
                    bits 8;
                    access ro;
                    hard_reset 'h0;
                    doc {
                        Field containing a user defined value, not used anywhere inside the IP itself.
                    }
                }
                field FLEXNOCID @'h8 {
                    bits 24;
                    access ro;
                    hard_reset 'h84f8c6;
                    doc {
                        Field containing the build revision of the software used to generate the IP HDL code.
                    }
                }
            }
            register ccf_Probe_T_jtag_main_TransactionStatProfiler_En @0x8 {
                bytes 4;
                field EN @'h0 {
                    access rw;
                    hard_reset 'h0;
                    doc {
                        Register En is a 1-bit register that enables the transaction probe counter unit.
                    }
                }
            }
            register ccf_Probe_T_jtag_main_TransactionStatProfiler_Mode @0xC {
                bytes 4;
                field MODE @'h0 {
                    access rw;
                    hard_reset 'h0;
                    doc {
                        Register Mode sets the counting mode per observed port. Each bit per observation port defines the incrementing mode. (Mode = 0 for Delay, Mode = 1 for Pending)
                    }
                }
            }
            register ccf_Probe_T_jtag_main_TransactionStatProfiler_Reserved_00 @0x10 {
                bytes 4;
                field ccf_Probe_T_jtag_main_TransactionStatProfiler_Reserved_00 {
                    bits 32;
                    access rw;
                    hard_reset 'h0;
                }
            }
            register ccf_Probe_T_jtag_main_TransactionStatProfiler_Reserved_01 @0x14 {
                bytes 4;
                field ccf_Probe_T_jtag_main_TransactionStatProfiler_Reserved_01 {
                    bits 32;
                    access rw;
                    hard_reset 'h0;
                }
            }
            register ccf_Probe_T_jtag_main_TransactionStatProfiler_Reserved_02 @0x18 {
                bytes 4;
                field ccf_Probe_T_jtag_main_TransactionStatProfiler_Reserved_02 {
                    bits 32;
                    access rw;
                    hard_reset 'h0;
                }
            }
            register ccf_Probe_T_jtag_main_TransactionStatProfiler_Reserved_03 @0x1C {
                bytes 4;
                field ccf_Probe_T_jtag_main_TransactionStatProfiler_Reserved_03 {
                    bits 32;
                    access rw;
                    hard_reset 'h0;
                }
            }
            register ccf_Probe_T_jtag_main_TransactionStatProfiler_Reserved_04 @0x20 {
                bytes 4;
                field ccf_Probe_T_jtag_main_TransactionStatProfiler_Reserved_04 {
                    bits 32;
                    access rw;
                    hard_reset 'h0;
                }
            }
            register ccf_Probe_T_jtag_main_TransactionStatProfiler_Reserved_05 @0x24 {
                bytes 4;
                field ccf_Probe_T_jtag_main_TransactionStatProfiler_Reserved_05 {
                    bits 32;
                    access rw;
                    hard_reset 'h0;
                }
            }
            register ccf_Probe_T_jtag_main_TransactionStatProfiler_Reserved_06 @0x28 {
                bytes 4;
                field ccf_Probe_T_jtag_main_TransactionStatProfiler_Reserved_06 {
                    bits 32;
                    access rw;
                    hard_reset 'h0;
                }
            }
            register ccf_Probe_T_jtag_main_TransactionStatProfiler_Thresholds_0_0 @0x2C {
                bytes 4;
                field THRESHOLDS_0_0 @'h0 {
                    bits 8;
                    access rw;
                    hard_reset 'h0;
                    doc {
                        Register Thresholds_i_j contains the threshold index "0" that allows computation of threshold values.
                    }
                }
            }
            register ccf_Probe_T_jtag_main_TransactionStatProfiler_Reserved_07 @0x30 {
                bytes 4;
                field ccf_Probe_T_jtag_main_TransactionStatProfiler_Reserved_07 {
                    bits 32;
                    access rw;
                    hard_reset 'h0;
                }
            }
            register ccf_Probe_T_jtag_main_TransactionStatProfiler_Reserved_08 @0x34 {
                bytes 4;
                field ccf_Probe_T_jtag_main_TransactionStatProfiler_Reserved_08 {
                    bits 32;
                    access rw;
                    hard_reset 'h0;
                }
            }
            register ccf_Probe_T_jtag_main_TransactionStatProfiler_Reserved_09 @0x38 {
                bytes 4;
                field ccf_Probe_T_jtag_main_TransactionStatProfiler_Reserved_09 {
                    bits 32;
                    access rw;
                    hard_reset 'h0;
                }
            }
            register ccf_Probe_T_jtag_main_TransactionStatProfiler_Reserved_10 @0x3C {
                bytes 4;
                field ccf_Probe_T_jtag_main_TransactionStatProfiler_Reserved_10 {
                    bits 32;
                    access rw;
                    hard_reset 'h0;
                }
            }
            register ccf_Probe_T_jtag_main_TransactionStatProfiler_Reserved_11 @0x40 {
                bytes 4;
                field ccf_Probe_T_jtag_main_TransactionStatProfiler_Reserved_11 {
                    bits 32;
                    access rw;
                    hard_reset 'h0;
                }
            }
            register ccf_Probe_T_jtag_main_TransactionStatProfiler_Reserved_12 @0x44 {
                bytes 4;
                field ccf_Probe_T_jtag_main_TransactionStatProfiler_Reserved_12 {
                    bits 32;
                    access rw;
                    hard_reset 'h0;
                }
            }
            register ccf_Probe_T_jtag_main_TransactionStatProfiler_Reserved_13 @0x48 {
                bytes 4;
                field ccf_Probe_T_jtag_main_TransactionStatProfiler_Reserved_13 {
                    bits 32;
                    access rw;
                    hard_reset 'h0;
                }
            }
            register ccf_Probe_T_jtag_main_TransactionStatProfiler_Reserved_14 @0x4C {
                bytes 4;
                field ccf_Probe_T_jtag_main_TransactionStatProfiler_Reserved_14 {
                    bits 32;
                    access rw;
                    hard_reset 'h0;
                }
            }
            register ccf_Probe_T_jtag_main_TransactionStatProfiler_Reserved_15 @0x50 {
                bytes 4;
                field ccf_Probe_T_jtag_main_TransactionStatProfiler_Reserved_15 {
                    bits 32;
                    access rw;
                    hard_reset 'h0;
                }
            }
            register ccf_Probe_T_jtag_main_TransactionStatProfiler_Reserved_16 @0x54 {
                bytes 4;
                field ccf_Probe_T_jtag_main_TransactionStatProfiler_Reserved_16 {
                    bits 32;
                    access rw;
                    hard_reset 'h0;
                }
            }
            register ccf_Probe_T_jtag_main_TransactionStatProfiler_Reserved_17 @0x58 {
                bytes 4;
                field ccf_Probe_T_jtag_main_TransactionStatProfiler_Reserved_17 {
                    bits 32;
                    access rw;
                    hard_reset 'h0;
                }
            }
            register ccf_Probe_T_jtag_main_TransactionStatProfiler_Reserved_18 @0x5C {
                bytes 4;
                field ccf_Probe_T_jtag_main_TransactionStatProfiler_Reserved_18 {
                    bits 32;
                    access rw;
                    hard_reset 'h0;
                }
            }
            register ccf_Probe_T_jtag_main_TransactionStatProfiler_Reserved_19 @0x60 {
                bytes 4;
                field ccf_Probe_T_jtag_main_TransactionStatProfiler_Reserved_19 {
                    bits 32;
                    access rw;
                    hard_reset 'h0;
                }
            }
            register ccf_Probe_T_jtag_main_TransactionStatProfiler_Reserved_20 @0x64 {
                bytes 4;
                field ccf_Probe_T_jtag_main_TransactionStatProfiler_Reserved_20 {
                    bits 32;
                    access rw;
                    hard_reset 'h0;
                }
            }
            register ccf_Probe_T_jtag_main_TransactionStatProfiler_Reserved_21 @0x68 {
                bytes 4;
                field ccf_Probe_T_jtag_main_TransactionStatProfiler_Reserved_21 {
                    bits 32;
                    access rw;
                    hard_reset 'h0;
                }
            }
            register ccf_Probe_T_jtag_main_TransactionStatProfiler_OverflowStatus @0x6C {
                bytes 4;
                field OVERFLOWSTATUS @'h0 {
                    access ro;
                    hard_reset 'h0;
                    doc {
                        Bit n of register OverflowStatus is set to 1 if a start event occurs on observed port n and eitherof the following conditions occurs: All tenure counters allocated to the port are already in use. No tenure lines have been allocated to the port. The number of bits in this register is equal to the value set for parameter nObservable.
                    }
                }
            }
            register ccf_Probe_T_jtag_main_TransactionStatProfiler_OverflowReset @0x70 {
                bytes 4;
                field OVERFLOWRESET @'h0 {
                    access w1c;
                    hard_reset 'h0;
                    doc {
                        Register OverflowReset is a pulse register that clears overflow status bits per observed port on each write access. OverflowReset = nObservable. Writing 0x2  clears the overflow status of observed port 1.
                    }
                }
            }
            register ccf_Probe_T_jtag_main_TransactionStatProfiler_PendingEventMode @0x74 {
                bytes 4;
                field PENDINGEVENTMODE @'h0 {
                    access rw;
                    hard_reset 'h0;
                    doc {
                        Register pendingEventMode is a 1-bit register that configures the pending event mode. When set to 0 (CYCLE), and when register mode is set to PENDING, the pending event is generated on each cycle when the counter is greater than zero.When set to 1 (STOP) the pending event is generated on each stop event.
                    }
                }
            }
            register ccf_Probe_T_jtag_main_TransactionStatProfiler_PreScaler @0x78 {
                bytes 4;
                field PRESCALER @'h0 {
                    bits 8;
                    access rw;
                    hard_reset 'h0;
                    doc {
                        8Register Prescaler is an-bit pre-scaling register that accepts any pre-scaling value between 1 (default) and 256. If set to 0, pre-scaling is disabled. If set to any other supported value "n", the threshold counter value is divided by (n + 1).
                    }
                }
            }
            register ccf_Probe_T_jtag_main_TransactionStatProfiler_Reserved_22 @0x7C {
                bytes 4;
                field ccf_Probe_T_jtag_main_TransactionStatProfiler_Reserved_22 {
                    bits 32;
                    access rw;
                    hard_reset 'h0;
                }
            }
        }
        block ecf_ccf_axi_ccf_Probe_T_sip0_main_TransactionStatProfiler @0xDC200 {
            bytes 4;
            register ccf_Probe_T_sip0_main_TransactionStatProfiler_Id_CoreId @0x0 {
                bytes 4;
                field CORETYPEID @'h0 {
                    bits 8;
                    access ro;
                    hard_reset 'ha;
                    doc {
                        Field identifying the type of IP.
                    }
                }
                field CORECHECKSUM @'h8 {
                    bits 24;
                    access ro;
                    hard_reset 'h16055d;
                    doc {
                        Field containing a checksum of the parameters of the IP.
                    }
                }
            }
            register ccf_Probe_T_sip0_main_TransactionStatProfiler_Id_RevisionId @0x4 {
                bytes 4;
                field USERID @'h0 {
                    bits 8;
                    access ro;
                    hard_reset 'h0;
                    doc {
                        Field containing a user defined value, not used anywhere inside the IP itself.
                    }
                }
                field FLEXNOCID @'h8 {
                    bits 24;
                    access ro;
                    hard_reset 'h84f8c6;
                    doc {
                        Field containing the build revision of the software used to generate the IP HDL code.
                    }
                }
            }
            register ccf_Probe_T_sip0_main_TransactionStatProfiler_En @0x8 {
                bytes 4;
                field EN @'h0 {
                    access rw;
                    hard_reset 'h0;
                    doc {
                        Register En is a 1-bit register that enables the transaction probe counter unit.
                    }
                }
            }
            register ccf_Probe_T_sip0_main_TransactionStatProfiler_Mode @0xC {
                bytes 4;
                field MODE @'h0 {
                    access rw;
                    hard_reset 'h0;
                    doc {
                        Register Mode sets the counting mode per observed port. Each bit per observation port defines the incrementing mode. (Mode = 0 for Delay, Mode = 1 for Pending)
                    }
                }
            }
            register ccf_Probe_T_sip0_main_TransactionStatProfiler_Reserved_00 @0x10 {
                bytes 4;
                field ccf_Probe_T_sip0_main_TransactionStatProfiler_Reserved_00 {
                    bits 32;
                    access rw;
                    hard_reset 'h0;
                }
            }
            register ccf_Probe_T_sip0_main_TransactionStatProfiler_Reserved_01 @0x14 {
                bytes 4;
                field ccf_Probe_T_sip0_main_TransactionStatProfiler_Reserved_01 {
                    bits 32;
                    access rw;
                    hard_reset 'h0;
                }
            }
            register ccf_Probe_T_sip0_main_TransactionStatProfiler_Reserved_02 @0x18 {
                bytes 4;
                field ccf_Probe_T_sip0_main_TransactionStatProfiler_Reserved_02 {
                    bits 32;
                    access rw;
                    hard_reset 'h0;
                }
            }
            register ccf_Probe_T_sip0_main_TransactionStatProfiler_Reserved_03 @0x1C {
                bytes 4;
                field ccf_Probe_T_sip0_main_TransactionStatProfiler_Reserved_03 {
                    bits 32;
                    access rw;
                    hard_reset 'h0;
                }
            }
            register ccf_Probe_T_sip0_main_TransactionStatProfiler_Reserved_04 @0x20 {
                bytes 4;
                field ccf_Probe_T_sip0_main_TransactionStatProfiler_Reserved_04 {
                    bits 32;
                    access rw;
                    hard_reset 'h0;
                }
            }
            register ccf_Probe_T_sip0_main_TransactionStatProfiler_Reserved_05 @0x24 {
                bytes 4;
                field ccf_Probe_T_sip0_main_TransactionStatProfiler_Reserved_05 {
                    bits 32;
                    access rw;
                    hard_reset 'h0;
                }
            }
            register ccf_Probe_T_sip0_main_TransactionStatProfiler_Reserved_06 @0x28 {
                bytes 4;
                field ccf_Probe_T_sip0_main_TransactionStatProfiler_Reserved_06 {
                    bits 32;
                    access rw;
                    hard_reset 'h0;
                }
            }
            register ccf_Probe_T_sip0_main_TransactionStatProfiler_Thresholds_0_0 @0x2C {
                bytes 4;
                field THRESHOLDS_0_0 @'h0 {
                    bits 8;
                    access rw;
                    hard_reset 'h0;
                    doc {
                        Register Thresholds_i_j contains the threshold index "0" that allows computation of threshold values.
                    }
                }
            }
            register ccf_Probe_T_sip0_main_TransactionStatProfiler_Reserved_07 @0x30 {
                bytes 4;
                field ccf_Probe_T_sip0_main_TransactionStatProfiler_Reserved_07 {
                    bits 32;
                    access rw;
                    hard_reset 'h0;
                }
            }
            register ccf_Probe_T_sip0_main_TransactionStatProfiler_Reserved_08 @0x34 {
                bytes 4;
                field ccf_Probe_T_sip0_main_TransactionStatProfiler_Reserved_08 {
                    bits 32;
                    access rw;
                    hard_reset 'h0;
                }
            }
            register ccf_Probe_T_sip0_main_TransactionStatProfiler_Reserved_09 @0x38 {
                bytes 4;
                field ccf_Probe_T_sip0_main_TransactionStatProfiler_Reserved_09 {
                    bits 32;
                    access rw;
                    hard_reset 'h0;
                }
            }
            register ccf_Probe_T_sip0_main_TransactionStatProfiler_Reserved_10 @0x3C {
                bytes 4;
                field ccf_Probe_T_sip0_main_TransactionStatProfiler_Reserved_10 {
                    bits 32;
                    access rw;
                    hard_reset 'h0;
                }
            }
            register ccf_Probe_T_sip0_main_TransactionStatProfiler_Reserved_11 @0x40 {
                bytes 4;
                field ccf_Probe_T_sip0_main_TransactionStatProfiler_Reserved_11 {
                    bits 32;
                    access rw;
                    hard_reset 'h0;
                }
            }
            register ccf_Probe_T_sip0_main_TransactionStatProfiler_Reserved_12 @0x44 {
                bytes 4;
                field ccf_Probe_T_sip0_main_TransactionStatProfiler_Reserved_12 {
                    bits 32;
                    access rw;
                    hard_reset 'h0;
                }
            }
            register ccf_Probe_T_sip0_main_TransactionStatProfiler_Reserved_13 @0x48 {
                bytes 4;
                field ccf_Probe_T_sip0_main_TransactionStatProfiler_Reserved_13 {
                    bits 32;
                    access rw;
                    hard_reset 'h0;
                }
            }
            register ccf_Probe_T_sip0_main_TransactionStatProfiler_Reserved_14 @0x4C {
                bytes 4;
                field ccf_Probe_T_sip0_main_TransactionStatProfiler_Reserved_14 {
                    bits 32;
                    access rw;
                    hard_reset 'h0;
                }
            }
            register ccf_Probe_T_sip0_main_TransactionStatProfiler_Reserved_15 @0x50 {
                bytes 4;
                field ccf_Probe_T_sip0_main_TransactionStatProfiler_Reserved_15 {
                    bits 32;
                    access rw;
                    hard_reset 'h0;
                }
            }
            register ccf_Probe_T_sip0_main_TransactionStatProfiler_Reserved_16 @0x54 {
                bytes 4;
                field ccf_Probe_T_sip0_main_TransactionStatProfiler_Reserved_16 {
                    bits 32;
                    access rw;
                    hard_reset 'h0;
                }
            }
            register ccf_Probe_T_sip0_main_TransactionStatProfiler_Reserved_17 @0x58 {
                bytes 4;
                field ccf_Probe_T_sip0_main_TransactionStatProfiler_Reserved_17 {
                    bits 32;
                    access rw;
                    hard_reset 'h0;
                }
            }
            register ccf_Probe_T_sip0_main_TransactionStatProfiler_Reserved_18 @0x5C {
                bytes 4;
                field ccf_Probe_T_sip0_main_TransactionStatProfiler_Reserved_18 {
                    bits 32;
                    access rw;
                    hard_reset 'h0;
                }
            }
            register ccf_Probe_T_sip0_main_TransactionStatProfiler_Reserved_19 @0x60 {
                bytes 4;
                field ccf_Probe_T_sip0_main_TransactionStatProfiler_Reserved_19 {
                    bits 32;
                    access rw;
                    hard_reset 'h0;
                }
            }
            register ccf_Probe_T_sip0_main_TransactionStatProfiler_Reserved_20 @0x64 {
                bytes 4;
                field ccf_Probe_T_sip0_main_TransactionStatProfiler_Reserved_20 {
                    bits 32;
                    access rw;
                    hard_reset 'h0;
                }
            }
            register ccf_Probe_T_sip0_main_TransactionStatProfiler_Reserved_21 @0x68 {
                bytes 4;
                field ccf_Probe_T_sip0_main_TransactionStatProfiler_Reserved_21 {
                    bits 32;
                    access rw;
                    hard_reset 'h0;
                }
            }
            register ccf_Probe_T_sip0_main_TransactionStatProfiler_OverflowStatus @0x6C {
                bytes 4;
                field OVERFLOWSTATUS @'h0 {
                    access ro;
                    hard_reset 'h0;
                    doc {
                        Bit n of register OverflowStatus is set to 1 if a start event occurs on observed port n and eitherof the following conditions occurs: All tenure counters allocated to the port are already in use. No tenure lines have been allocated to the port. The number of bits in this register is equal to the value set for parameter nObservable.
                    }
                }
            }
            register ccf_Probe_T_sip0_main_TransactionStatProfiler_OverflowReset @0x70 {
                bytes 4;
                field OVERFLOWRESET @'h0 {
                    access w1c;
                    hard_reset 'h0;
                    doc {
                        Register OverflowReset is a pulse register that clears overflow status bits per observed port on each write access. OverflowReset = nObservable. Writing 0x2  clears the overflow status of observed port 1.
                    }
                }
            }
            register ccf_Probe_T_sip0_main_TransactionStatProfiler_PendingEventMode @0x74 {
                bytes 4;
                field PENDINGEVENTMODE @'h0 {
                    access rw;
                    hard_reset 'h0;
                    doc {
                        Register pendingEventMode is a 1-bit register that configures the pending event mode. When set to 0 (CYCLE), and when register mode is set to PENDING, the pending event is generated on each cycle when the counter is greater than zero.When set to 1 (STOP) the pending event is generated on each stop event.
                    }
                }
            }
            register ccf_Probe_T_sip0_main_TransactionStatProfiler_PreScaler @0x78 {
                bytes 4;
                field PRESCALER @'h0 {
                    bits 8;
                    access rw;
                    hard_reset 'h0;
                    doc {
                        8Register Prescaler is an-bit pre-scaling register that accepts any pre-scaling value between 1 (default) and 256. If set to 0, pre-scaling is disabled. If set to any other supported value "n", the threshold counter value is divided by (n + 1).
                    }
                }
            }
            register ccf_Probe_T_sip0_main_TransactionStatProfiler_Reserved_22 @0x7C {
                bytes 4;
                field ccf_Probe_T_sip0_main_TransactionStatProfiler_Reserved_22 {
                    bits 32;
                    access rw;
                    hard_reset 'h0;
                }
            }
        }
        block ecf_ccf_axi_ccf_Probe_T_sip1_main_TransactionStatProfiler @0xDC280 {
            bytes 4;
            register ccf_Probe_T_sip1_main_TransactionStatProfiler_Id_CoreId @0x0 {
                bytes 4;
                field CORETYPEID @'h0 {
                    bits 8;
                    access ro;
                    hard_reset 'ha;
                    doc {
                        Field identifying the type of IP.
                    }
                }
                field CORECHECKSUM @'h8 {
                    bits 24;
                    access ro;
                    hard_reset 'h2a0d28;
                    doc {
                        Field containing a checksum of the parameters of the IP.
                    }
                }
            }
            register ccf_Probe_T_sip1_main_TransactionStatProfiler_Id_RevisionId @0x4 {
                bytes 4;
                field USERID @'h0 {
                    bits 8;
                    access ro;
                    hard_reset 'h0;
                    doc {
                        Field containing a user defined value, not used anywhere inside the IP itself.
                    }
                }
                field FLEXNOCID @'h8 {
                    bits 24;
                    access ro;
                    hard_reset 'h84f8c6;
                    doc {
                        Field containing the build revision of the software used to generate the IP HDL code.
                    }
                }
            }
            register ccf_Probe_T_sip1_main_TransactionStatProfiler_En @0x8 {
                bytes 4;
                field EN @'h0 {
                    access rw;
                    hard_reset 'h0;
                    doc {
                        Register En is a 1-bit register that enables the transaction probe counter unit.
                    }
                }
            }
            register ccf_Probe_T_sip1_main_TransactionStatProfiler_Mode @0xC {
                bytes 4;
                field MODE @'h0 {
                    access rw;
                    hard_reset 'h0;
                    doc {
                        Register Mode sets the counting mode per observed port. Each bit per observation port defines the incrementing mode. (Mode = 0 for Delay, Mode = 1 for Pending)
                    }
                }
            }
            register ccf_Probe_T_sip1_main_TransactionStatProfiler_Reserved_00 @0x10 {
                bytes 4;
                field ccf_Probe_T_sip1_main_TransactionStatProfiler_Reserved_00 {
                    bits 32;
                    access rw;
                    hard_reset 'h0;
                }
            }
            register ccf_Probe_T_sip1_main_TransactionStatProfiler_Reserved_01 @0x14 {
                bytes 4;
                field ccf_Probe_T_sip1_main_TransactionStatProfiler_Reserved_01 {
                    bits 32;
                    access rw;
                    hard_reset 'h0;
                }
            }
            register ccf_Probe_T_sip1_main_TransactionStatProfiler_Reserved_02 @0x18 {
                bytes 4;
                field ccf_Probe_T_sip1_main_TransactionStatProfiler_Reserved_02 {
                    bits 32;
                    access rw;
                    hard_reset 'h0;
                }
            }
            register ccf_Probe_T_sip1_main_TransactionStatProfiler_Reserved_03 @0x1C {
                bytes 4;
                field ccf_Probe_T_sip1_main_TransactionStatProfiler_Reserved_03 {
                    bits 32;
                    access rw;
                    hard_reset 'h0;
                }
            }
            register ccf_Probe_T_sip1_main_TransactionStatProfiler_Reserved_04 @0x20 {
                bytes 4;
                field ccf_Probe_T_sip1_main_TransactionStatProfiler_Reserved_04 {
                    bits 32;
                    access rw;
                    hard_reset 'h0;
                }
            }
            register ccf_Probe_T_sip1_main_TransactionStatProfiler_Reserved_05 @0x24 {
                bytes 4;
                field ccf_Probe_T_sip1_main_TransactionStatProfiler_Reserved_05 {
                    bits 32;
                    access rw;
                    hard_reset 'h0;
                }
            }
            register ccf_Probe_T_sip1_main_TransactionStatProfiler_Reserved_06 @0x28 {
                bytes 4;
                field ccf_Probe_T_sip1_main_TransactionStatProfiler_Reserved_06 {
                    bits 32;
                    access rw;
                    hard_reset 'h0;
                }
            }
            register ccf_Probe_T_sip1_main_TransactionStatProfiler_Thresholds_0_0 @0x2C {
                bytes 4;
                field THRESHOLDS_0_0 @'h0 {
                    bits 8;
                    access rw;
                    hard_reset 'h0;
                    doc {
                        Register Thresholds_i_j contains the threshold index "0" that allows computation of threshold values.
                    }
                }
            }
            register ccf_Probe_T_sip1_main_TransactionStatProfiler_Reserved_07 @0x30 {
                bytes 4;
                field ccf_Probe_T_sip1_main_TransactionStatProfiler_Reserved_07 {
                    bits 32;
                    access rw;
                    hard_reset 'h0;
                }
            }
            register ccf_Probe_T_sip1_main_TransactionStatProfiler_Reserved_08 @0x34 {
                bytes 4;
                field ccf_Probe_T_sip1_main_TransactionStatProfiler_Reserved_08 {
                    bits 32;
                    access rw;
                    hard_reset 'h0;
                }
            }
            register ccf_Probe_T_sip1_main_TransactionStatProfiler_Reserved_09 @0x38 {
                bytes 4;
                field ccf_Probe_T_sip1_main_TransactionStatProfiler_Reserved_09 {
                    bits 32;
                    access rw;
                    hard_reset 'h0;
                }
            }
            register ccf_Probe_T_sip1_main_TransactionStatProfiler_Reserved_10 @0x3C {
                bytes 4;
                field ccf_Probe_T_sip1_main_TransactionStatProfiler_Reserved_10 {
                    bits 32;
                    access rw;
                    hard_reset 'h0;
                }
            }
            register ccf_Probe_T_sip1_main_TransactionStatProfiler_Reserved_11 @0x40 {
                bytes 4;
                field ccf_Probe_T_sip1_main_TransactionStatProfiler_Reserved_11 {
                    bits 32;
                    access rw;
                    hard_reset 'h0;
                }
            }
            register ccf_Probe_T_sip1_main_TransactionStatProfiler_Reserved_12 @0x44 {
                bytes 4;
                field ccf_Probe_T_sip1_main_TransactionStatProfiler_Reserved_12 {
                    bits 32;
                    access rw;
                    hard_reset 'h0;
                }
            }
            register ccf_Probe_T_sip1_main_TransactionStatProfiler_Reserved_13 @0x48 {
                bytes 4;
                field ccf_Probe_T_sip1_main_TransactionStatProfiler_Reserved_13 {
                    bits 32;
                    access rw;
                    hard_reset 'h0;
                }
            }
            register ccf_Probe_T_sip1_main_TransactionStatProfiler_Reserved_14 @0x4C {
                bytes 4;
                field ccf_Probe_T_sip1_main_TransactionStatProfiler_Reserved_14 {
                    bits 32;
                    access rw;
                    hard_reset 'h0;
                }
            }
            register ccf_Probe_T_sip1_main_TransactionStatProfiler_Reserved_15 @0x50 {
                bytes 4;
                field ccf_Probe_T_sip1_main_TransactionStatProfiler_Reserved_15 {
                    bits 32;
                    access rw;
                    hard_reset 'h0;
                }
            }
            register ccf_Probe_T_sip1_main_TransactionStatProfiler_Reserved_16 @0x54 {
                bytes 4;
                field ccf_Probe_T_sip1_main_TransactionStatProfiler_Reserved_16 {
                    bits 32;
                    access rw;
                    hard_reset 'h0;
                }
            }
            register ccf_Probe_T_sip1_main_TransactionStatProfiler_Reserved_17 @0x58 {
                bytes 4;
                field ccf_Probe_T_sip1_main_TransactionStatProfiler_Reserved_17 {
                    bits 32;
                    access rw;
                    hard_reset 'h0;
                }
            }
            register ccf_Probe_T_sip1_main_TransactionStatProfiler_Reserved_18 @0x5C {
                bytes 4;
                field ccf_Probe_T_sip1_main_TransactionStatProfiler_Reserved_18 {
                    bits 32;
                    access rw;
                    hard_reset 'h0;
                }
            }
            register ccf_Probe_T_sip1_main_TransactionStatProfiler_Reserved_19 @0x60 {
                bytes 4;
                field ccf_Probe_T_sip1_main_TransactionStatProfiler_Reserved_19 {
                    bits 32;
                    access rw;
                    hard_reset 'h0;
                }
            }
            register ccf_Probe_T_sip1_main_TransactionStatProfiler_Reserved_20 @0x64 {
                bytes 4;
                field ccf_Probe_T_sip1_main_TransactionStatProfiler_Reserved_20 {
                    bits 32;
                    access rw;
                    hard_reset 'h0;
                }
            }
            register ccf_Probe_T_sip1_main_TransactionStatProfiler_Reserved_21 @0x68 {
                bytes 4;
                field ccf_Probe_T_sip1_main_TransactionStatProfiler_Reserved_21 {
                    bits 32;
                    access rw;
                    hard_reset 'h0;
                }
            }
            register ccf_Probe_T_sip1_main_TransactionStatProfiler_OverflowStatus @0x6C {
                bytes 4;
                field OVERFLOWSTATUS @'h0 {
                    access ro;
                    hard_reset 'h0;
                    doc {
                        Bit n of register OverflowStatus is set to 1 if a start event occurs on observed port n and eitherof the following conditions occurs: All tenure counters allocated to the port are already in use. No tenure lines have been allocated to the port. The number of bits in this register is equal to the value set for parameter nObservable.
                    }
                }
            }
            register ccf_Probe_T_sip1_main_TransactionStatProfiler_OverflowReset @0x70 {
                bytes 4;
                field OVERFLOWRESET @'h0 {
                    access w1c;
                    hard_reset 'h0;
                    doc {
                        Register OverflowReset is a pulse register that clears overflow status bits per observed port on each write access. OverflowReset = nObservable. Writing 0x2  clears the overflow status of observed port 1.
                    }
                }
            }
            register ccf_Probe_T_sip1_main_TransactionStatProfiler_PendingEventMode @0x74 {
                bytes 4;
                field PENDINGEVENTMODE @'h0 {
                    access rw;
                    hard_reset 'h0;
                    doc {
                        Register pendingEventMode is a 1-bit register that configures the pending event mode. When set to 0 (CYCLE), and when register mode is set to PENDING, the pending event is generated on each cycle when the counter is greater than zero.When set to 1 (STOP) the pending event is generated on each stop event.
                    }
                }
            }
            register ccf_Probe_T_sip1_main_TransactionStatProfiler_PreScaler @0x78 {
                bytes 4;
                field PRESCALER @'h0 {
                    bits 8;
                    access rw;
                    hard_reset 'h0;
                    doc {
                        8Register Prescaler is an-bit pre-scaling register that accepts any pre-scaling value between 1 (default) and 256. If set to 0, pre-scaling is disabled. If set to any other supported value "n", the threshold counter value is divided by (n + 1).
                    }
                }
            }
            register ccf_Probe_T_sip1_main_TransactionStatProfiler_Reserved_22 @0x7C {
                bytes 4;
                field ccf_Probe_T_sip1_main_TransactionStatProfiler_Reserved_22 {
                    bits 32;
                    access rw;
                    hard_reset 'h0;
                }
            }
        }
        block ecf_ccf_axi_ccf_Probe_T_sip2_main_TransactionStatProfiler @0xDC300 {
            bytes 4;
            register ccf_Probe_T_sip2_main_TransactionStatProfiler_Id_CoreId @0x0 {
                bytes 4;
                field CORETYPEID @'h0 {
                    bits 8;
                    access ro;
                    hard_reset 'ha;
                    doc {
                        Field identifying the type of IP.
                    }
                }
                field CORECHECKSUM @'h8 {
                    bits 24;
                    access ro;
                    hard_reset 'h934a44;
                    doc {
                        Field containing a checksum of the parameters of the IP.
                    }
                }
            }
            register ccf_Probe_T_sip2_main_TransactionStatProfiler_Id_RevisionId @0x4 {
                bytes 4;
                field USERID @'h0 {
                    bits 8;
                    access ro;
                    hard_reset 'h0;
                    doc {
                        Field containing a user defined value, not used anywhere inside the IP itself.
                    }
                }
                field FLEXNOCID @'h8 {
                    bits 24;
                    access ro;
                    hard_reset 'h84f8c6;
                    doc {
                        Field containing the build revision of the software used to generate the IP HDL code.
                    }
                }
            }
            register ccf_Probe_T_sip2_main_TransactionStatProfiler_En @0x8 {
                bytes 4;
                field EN @'h0 {
                    access rw;
                    hard_reset 'h0;
                    doc {
                        Register En is a 1-bit register that enables the transaction probe counter unit.
                    }
                }
            }
            register ccf_Probe_T_sip2_main_TransactionStatProfiler_Mode @0xC {
                bytes 4;
                field MODE @'h0 {
                    access rw;
                    hard_reset 'h0;
                    doc {
                        Register Mode sets the counting mode per observed port. Each bit per observation port defines the incrementing mode. (Mode = 0 for Delay, Mode = 1 for Pending)
                    }
                }
            }
            register ccf_Probe_T_sip2_main_TransactionStatProfiler_Reserved_00 @0x10 {
                bytes 4;
                field ccf_Probe_T_sip2_main_TransactionStatProfiler_Reserved_00 {
                    bits 32;
                    access rw;
                    hard_reset 'h0;
                }
            }
            register ccf_Probe_T_sip2_main_TransactionStatProfiler_Reserved_01 @0x14 {
                bytes 4;
                field ccf_Probe_T_sip2_main_TransactionStatProfiler_Reserved_01 {
                    bits 32;
                    access rw;
                    hard_reset 'h0;
                }
            }
            register ccf_Probe_T_sip2_main_TransactionStatProfiler_Reserved_02 @0x18 {
                bytes 4;
                field ccf_Probe_T_sip2_main_TransactionStatProfiler_Reserved_02 {
                    bits 32;
                    access rw;
                    hard_reset 'h0;
                }
            }
            register ccf_Probe_T_sip2_main_TransactionStatProfiler_Reserved_03 @0x1C {
                bytes 4;
                field ccf_Probe_T_sip2_main_TransactionStatProfiler_Reserved_03 {
                    bits 32;
                    access rw;
                    hard_reset 'h0;
                }
            }
            register ccf_Probe_T_sip2_main_TransactionStatProfiler_Reserved_04 @0x20 {
                bytes 4;
                field ccf_Probe_T_sip2_main_TransactionStatProfiler_Reserved_04 {
                    bits 32;
                    access rw;
                    hard_reset 'h0;
                }
            }
            register ccf_Probe_T_sip2_main_TransactionStatProfiler_Reserved_05 @0x24 {
                bytes 4;
                field ccf_Probe_T_sip2_main_TransactionStatProfiler_Reserved_05 {
                    bits 32;
                    access rw;
                    hard_reset 'h0;
                }
            }
            register ccf_Probe_T_sip2_main_TransactionStatProfiler_Reserved_06 @0x28 {
                bytes 4;
                field ccf_Probe_T_sip2_main_TransactionStatProfiler_Reserved_06 {
                    bits 32;
                    access rw;
                    hard_reset 'h0;
                }
            }
            register ccf_Probe_T_sip2_main_TransactionStatProfiler_Thresholds_0_0 @0x2C {
                bytes 4;
                field THRESHOLDS_0_0 @'h0 {
                    bits 8;
                    access rw;
                    hard_reset 'h0;
                    doc {
                        Register Thresholds_i_j contains the threshold index "0" that allows computation of threshold values.
                    }
                }
            }
            register ccf_Probe_T_sip2_main_TransactionStatProfiler_Reserved_07 @0x30 {
                bytes 4;
                field ccf_Probe_T_sip2_main_TransactionStatProfiler_Reserved_07 {
                    bits 32;
                    access rw;
                    hard_reset 'h0;
                }
            }
            register ccf_Probe_T_sip2_main_TransactionStatProfiler_Reserved_08 @0x34 {
                bytes 4;
                field ccf_Probe_T_sip2_main_TransactionStatProfiler_Reserved_08 {
                    bits 32;
                    access rw;
                    hard_reset 'h0;
                }
            }
            register ccf_Probe_T_sip2_main_TransactionStatProfiler_Reserved_09 @0x38 {
                bytes 4;
                field ccf_Probe_T_sip2_main_TransactionStatProfiler_Reserved_09 {
                    bits 32;
                    access rw;
                    hard_reset 'h0;
                }
            }
            register ccf_Probe_T_sip2_main_TransactionStatProfiler_Reserved_10 @0x3C {
                bytes 4;
                field ccf_Probe_T_sip2_main_TransactionStatProfiler_Reserved_10 {
                    bits 32;
                    access rw;
                    hard_reset 'h0;
                }
            }
            register ccf_Probe_T_sip2_main_TransactionStatProfiler_Reserved_11 @0x40 {
                bytes 4;
                field ccf_Probe_T_sip2_main_TransactionStatProfiler_Reserved_11 {
                    bits 32;
                    access rw;
                    hard_reset 'h0;
                }
            }
            register ccf_Probe_T_sip2_main_TransactionStatProfiler_Reserved_12 @0x44 {
                bytes 4;
                field ccf_Probe_T_sip2_main_TransactionStatProfiler_Reserved_12 {
                    bits 32;
                    access rw;
                    hard_reset 'h0;
                }
            }
            register ccf_Probe_T_sip2_main_TransactionStatProfiler_Reserved_13 @0x48 {
                bytes 4;
                field ccf_Probe_T_sip2_main_TransactionStatProfiler_Reserved_13 {
                    bits 32;
                    access rw;
                    hard_reset 'h0;
                }
            }
            register ccf_Probe_T_sip2_main_TransactionStatProfiler_Reserved_14 @0x4C {
                bytes 4;
                field ccf_Probe_T_sip2_main_TransactionStatProfiler_Reserved_14 {
                    bits 32;
                    access rw;
                    hard_reset 'h0;
                }
            }
            register ccf_Probe_T_sip2_main_TransactionStatProfiler_Reserved_15 @0x50 {
                bytes 4;
                field ccf_Probe_T_sip2_main_TransactionStatProfiler_Reserved_15 {
                    bits 32;
                    access rw;
                    hard_reset 'h0;
                }
            }
            register ccf_Probe_T_sip2_main_TransactionStatProfiler_Reserved_16 @0x54 {
                bytes 4;
                field ccf_Probe_T_sip2_main_TransactionStatProfiler_Reserved_16 {
                    bits 32;
                    access rw;
                    hard_reset 'h0;
                }
            }
            register ccf_Probe_T_sip2_main_TransactionStatProfiler_Reserved_17 @0x58 {
                bytes 4;
                field ccf_Probe_T_sip2_main_TransactionStatProfiler_Reserved_17 {
                    bits 32;
                    access rw;
                    hard_reset 'h0;
                }
            }
            register ccf_Probe_T_sip2_main_TransactionStatProfiler_Reserved_18 @0x5C {
                bytes 4;
                field ccf_Probe_T_sip2_main_TransactionStatProfiler_Reserved_18 {
                    bits 32;
                    access rw;
                    hard_reset 'h0;
                }
            }
            register ccf_Probe_T_sip2_main_TransactionStatProfiler_Reserved_19 @0x60 {
                bytes 4;
                field ccf_Probe_T_sip2_main_TransactionStatProfiler_Reserved_19 {
                    bits 32;
                    access rw;
                    hard_reset 'h0;
                }
            }
            register ccf_Probe_T_sip2_main_TransactionStatProfiler_Reserved_20 @0x64 {
                bytes 4;
                field ccf_Probe_T_sip2_main_TransactionStatProfiler_Reserved_20 {
                    bits 32;
                    access rw;
                    hard_reset 'h0;
                }
            }
            register ccf_Probe_T_sip2_main_TransactionStatProfiler_Reserved_21 @0x68 {
                bytes 4;
                field ccf_Probe_T_sip2_main_TransactionStatProfiler_Reserved_21 {
                    bits 32;
                    access rw;
                    hard_reset 'h0;
                }
            }
            register ccf_Probe_T_sip2_main_TransactionStatProfiler_OverflowStatus @0x6C {
                bytes 4;
                field OVERFLOWSTATUS @'h0 {
                    access ro;
                    hard_reset 'h0;
                    doc {
                        Bit n of register OverflowStatus is set to 1 if a start event occurs on observed port n and eitherof the following conditions occurs: All tenure counters allocated to the port are already in use. No tenure lines have been allocated to the port. The number of bits in this register is equal to the value set for parameter nObservable.
                    }
                }
            }
            register ccf_Probe_T_sip2_main_TransactionStatProfiler_OverflowReset @0x70 {
                bytes 4;
                field OVERFLOWRESET @'h0 {
                    access w1c;
                    hard_reset 'h0;
                    doc {
                        Register OverflowReset is a pulse register that clears overflow status bits per observed port on each write access. OverflowReset = nObservable. Writing 0x2  clears the overflow status of observed port 1.
                    }
                }
            }
            register ccf_Probe_T_sip2_main_TransactionStatProfiler_PendingEventMode @0x74 {
                bytes 4;
                field PENDINGEVENTMODE @'h0 {
                    access rw;
                    hard_reset 'h0;
                    doc {
                        Register pendingEventMode is a 1-bit register that configures the pending event mode. When set to 0 (CYCLE), and when register mode is set to PENDING, the pending event is generated on each cycle when the counter is greater than zero.When set to 1 (STOP) the pending event is generated on each stop event.
                    }
                }
            }
            register ccf_Probe_T_sip2_main_TransactionStatProfiler_PreScaler @0x78 {
                bytes 4;
                field PRESCALER @'h0 {
                    bits 8;
                    access rw;
                    hard_reset 'h0;
                    doc {
                        8Register Prescaler is an-bit pre-scaling register that accepts any pre-scaling value between 1 (default) and 256. If set to 0, pre-scaling is disabled. If set to any other supported value "n", the threshold counter value is divided by (n + 1).
                    }
                }
            }
            register ccf_Probe_T_sip2_main_TransactionStatProfiler_Reserved_22 @0x7C {
                bytes 4;
                field ccf_Probe_T_sip2_main_TransactionStatProfiler_Reserved_22 {
                    bits 32;
                    access rw;
                    hard_reset 'h0;
                }
            }
        }
        block ecf_ccf_axi_ccf_Probe_T_sip3_main_TransactionStatProfiler @0xDC380 {
            bytes 4;
            register ccf_Probe_T_sip3_main_TransactionStatProfiler_Id_CoreId @0x0 {
                bytes 4;
                field CORETYPEID @'h0 {
                    bits 8;
                    access ro;
                    hard_reset 'ha;
                    doc {
                        Field identifying the type of IP.
                    }
                }
                field CORECHECKSUM @'h8 {
                    bits 24;
                    access ro;
                    hard_reset 'hd969b8;
                    doc {
                        Field containing a checksum of the parameters of the IP.
                    }
                }
            }
            register ccf_Probe_T_sip3_main_TransactionStatProfiler_Id_RevisionId @0x4 {
                bytes 4;
                field USERID @'h0 {
                    bits 8;
                    access ro;
                    hard_reset 'h0;
                    doc {
                        Field containing a user defined value, not used anywhere inside the IP itself.
                    }
                }
                field FLEXNOCID @'h8 {
                    bits 24;
                    access ro;
                    hard_reset 'h84f8c6;
                    doc {
                        Field containing the build revision of the software used to generate the IP HDL code.
                    }
                }
            }
            register ccf_Probe_T_sip3_main_TransactionStatProfiler_En @0x8 {
                bytes 4;
                field EN @'h0 {
                    access rw;
                    hard_reset 'h0;
                    doc {
                        Register En is a 1-bit register that enables the transaction probe counter unit.
                    }
                }
            }
            register ccf_Probe_T_sip3_main_TransactionStatProfiler_Mode @0xC {
                bytes 4;
                field MODE @'h0 {
                    access rw;
                    hard_reset 'h0;
                    doc {
                        Register Mode sets the counting mode per observed port. Each bit per observation port defines the incrementing mode. (Mode = 0 for Delay, Mode = 1 for Pending)
                    }
                }
            }
            register ccf_Probe_T_sip3_main_TransactionStatProfiler_Reserved_00 @0x10 {
                bytes 4;
                field ccf_Probe_T_sip3_main_TransactionStatProfiler_Reserved_00 {
                    bits 32;
                    access rw;
                    hard_reset 'h0;
                }
            }
            register ccf_Probe_T_sip3_main_TransactionStatProfiler_Reserved_01 @0x14 {
                bytes 4;
                field ccf_Probe_T_sip3_main_TransactionStatProfiler_Reserved_01 {
                    bits 32;
                    access rw;
                    hard_reset 'h0;
                }
            }
            register ccf_Probe_T_sip3_main_TransactionStatProfiler_Reserved_02 @0x18 {
                bytes 4;
                field ccf_Probe_T_sip3_main_TransactionStatProfiler_Reserved_02 {
                    bits 32;
                    access rw;
                    hard_reset 'h0;
                }
            }
            register ccf_Probe_T_sip3_main_TransactionStatProfiler_Reserved_03 @0x1C {
                bytes 4;
                field ccf_Probe_T_sip3_main_TransactionStatProfiler_Reserved_03 {
                    bits 32;
                    access rw;
                    hard_reset 'h0;
                }
            }
            register ccf_Probe_T_sip3_main_TransactionStatProfiler_Reserved_04 @0x20 {
                bytes 4;
                field ccf_Probe_T_sip3_main_TransactionStatProfiler_Reserved_04 {
                    bits 32;
                    access rw;
                    hard_reset 'h0;
                }
            }
            register ccf_Probe_T_sip3_main_TransactionStatProfiler_Reserved_05 @0x24 {
                bytes 4;
                field ccf_Probe_T_sip3_main_TransactionStatProfiler_Reserved_05 {
                    bits 32;
                    access rw;
                    hard_reset 'h0;
                }
            }
            register ccf_Probe_T_sip3_main_TransactionStatProfiler_Reserved_06 @0x28 {
                bytes 4;
                field ccf_Probe_T_sip3_main_TransactionStatProfiler_Reserved_06 {
                    bits 32;
                    access rw;
                    hard_reset 'h0;
                }
            }
            register ccf_Probe_T_sip3_main_TransactionStatProfiler_Thresholds_0_0 @0x2C {
                bytes 4;
                field THRESHOLDS_0_0 @'h0 {
                    bits 8;
                    access rw;
                    hard_reset 'h0;
                    doc {
                        Register Thresholds_i_j contains the threshold index "0" that allows computation of threshold values.
                    }
                }
            }
            register ccf_Probe_T_sip3_main_TransactionStatProfiler_Reserved_07 @0x30 {
                bytes 4;
                field ccf_Probe_T_sip3_main_TransactionStatProfiler_Reserved_07 {
                    bits 32;
                    access rw;
                    hard_reset 'h0;
                }
            }
            register ccf_Probe_T_sip3_main_TransactionStatProfiler_Reserved_08 @0x34 {
                bytes 4;
                field ccf_Probe_T_sip3_main_TransactionStatProfiler_Reserved_08 {
                    bits 32;
                    access rw;
                    hard_reset 'h0;
                }
            }
            register ccf_Probe_T_sip3_main_TransactionStatProfiler_Reserved_09 @0x38 {
                bytes 4;
                field ccf_Probe_T_sip3_main_TransactionStatProfiler_Reserved_09 {
                    bits 32;
                    access rw;
                    hard_reset 'h0;
                }
            }
            register ccf_Probe_T_sip3_main_TransactionStatProfiler_Reserved_10 @0x3C {
                bytes 4;
                field ccf_Probe_T_sip3_main_TransactionStatProfiler_Reserved_10 {
                    bits 32;
                    access rw;
                    hard_reset 'h0;
                }
            }
            register ccf_Probe_T_sip3_main_TransactionStatProfiler_Reserved_11 @0x40 {
                bytes 4;
                field ccf_Probe_T_sip3_main_TransactionStatProfiler_Reserved_11 {
                    bits 32;
                    access rw;
                    hard_reset 'h0;
                }
            }
            register ccf_Probe_T_sip3_main_TransactionStatProfiler_Reserved_12 @0x44 {
                bytes 4;
                field ccf_Probe_T_sip3_main_TransactionStatProfiler_Reserved_12 {
                    bits 32;
                    access rw;
                    hard_reset 'h0;
                }
            }
            register ccf_Probe_T_sip3_main_TransactionStatProfiler_Reserved_13 @0x48 {
                bytes 4;
                field ccf_Probe_T_sip3_main_TransactionStatProfiler_Reserved_13 {
                    bits 32;
                    access rw;
                    hard_reset 'h0;
                }
            }
            register ccf_Probe_T_sip3_main_TransactionStatProfiler_Reserved_14 @0x4C {
                bytes 4;
                field ccf_Probe_T_sip3_main_TransactionStatProfiler_Reserved_14 {
                    bits 32;
                    access rw;
                    hard_reset 'h0;
                }
            }
            register ccf_Probe_T_sip3_main_TransactionStatProfiler_Reserved_15 @0x50 {
                bytes 4;
                field ccf_Probe_T_sip3_main_TransactionStatProfiler_Reserved_15 {
                    bits 32;
                    access rw;
                    hard_reset 'h0;
                }
            }
            register ccf_Probe_T_sip3_main_TransactionStatProfiler_Reserved_16 @0x54 {
                bytes 4;
                field ccf_Probe_T_sip3_main_TransactionStatProfiler_Reserved_16 {
                    bits 32;
                    access rw;
                    hard_reset 'h0;
                }
            }
            register ccf_Probe_T_sip3_main_TransactionStatProfiler_Reserved_17 @0x58 {
                bytes 4;
                field ccf_Probe_T_sip3_main_TransactionStatProfiler_Reserved_17 {
                    bits 32;
                    access rw;
                    hard_reset 'h0;
                }
            }
            register ccf_Probe_T_sip3_main_TransactionStatProfiler_Reserved_18 @0x5C {
                bytes 4;
                field ccf_Probe_T_sip3_main_TransactionStatProfiler_Reserved_18 {
                    bits 32;
                    access rw;
                    hard_reset 'h0;
                }
            }
            register ccf_Probe_T_sip3_main_TransactionStatProfiler_Reserved_19 @0x60 {
                bytes 4;
                field ccf_Probe_T_sip3_main_TransactionStatProfiler_Reserved_19 {
                    bits 32;
                    access rw;
                    hard_reset 'h0;
                }
            }
            register ccf_Probe_T_sip3_main_TransactionStatProfiler_Reserved_20 @0x64 {
                bytes 4;
                field ccf_Probe_T_sip3_main_TransactionStatProfiler_Reserved_20 {
                    bits 32;
                    access rw;
                    hard_reset 'h0;
                }
            }
            register ccf_Probe_T_sip3_main_TransactionStatProfiler_Reserved_21 @0x68 {
                bytes 4;
                field ccf_Probe_T_sip3_main_TransactionStatProfiler_Reserved_21 {
                    bits 32;
                    access rw;
                    hard_reset 'h0;
                }
            }
            register ccf_Probe_T_sip3_main_TransactionStatProfiler_OverflowStatus @0x6C {
                bytes 4;
                field OVERFLOWSTATUS @'h0 {
                    access ro;
                    hard_reset 'h0;
                    doc {
                        Bit n of register OverflowStatus is set to 1 if a start event occurs on observed port n and eitherof the following conditions occurs: All tenure counters allocated to the port are already in use. No tenure lines have been allocated to the port. The number of bits in this register is equal to the value set for parameter nObservable.
                    }
                }
            }
            register ccf_Probe_T_sip3_main_TransactionStatProfiler_OverflowReset @0x70 {
                bytes 4;
                field OVERFLOWRESET @'h0 {
                    access w1c;
                    hard_reset 'h0;
                    doc {
                        Register OverflowReset is a pulse register that clears overflow status bits per observed port on each write access. OverflowReset = nObservable. Writing 0x2  clears the overflow status of observed port 1.
                    }
                }
            }
            register ccf_Probe_T_sip3_main_TransactionStatProfiler_PendingEventMode @0x74 {
                bytes 4;
                field PENDINGEVENTMODE @'h0 {
                    access rw;
                    hard_reset 'h0;
                    doc {
                        Register pendingEventMode is a 1-bit register that configures the pending event mode. When set to 0 (CYCLE), and when register mode is set to PENDING, the pending event is generated on each cycle when the counter is greater than zero.When set to 1 (STOP) the pending event is generated on each stop event.
                    }
                }
            }
            register ccf_Probe_T_sip3_main_TransactionStatProfiler_PreScaler @0x78 {
                bytes 4;
                field PRESCALER @'h0 {
                    bits 8;
                    access rw;
                    hard_reset 'h0;
                    doc {
                        8Register Prescaler is an-bit pre-scaling register that accepts any pre-scaling value between 1 (default) and 256. If set to 0, pre-scaling is disabled. If set to any other supported value "n", the threshold counter value is divided by (n + 1).
                    }
                }
            }
            register ccf_Probe_T_sip3_main_TransactionStatProfiler_Reserved_22 @0x7C {
                bytes 4;
                field ccf_Probe_T_sip3_main_TransactionStatProfiler_Reserved_22 {
                    bits 32;
                    access rw;
                    hard_reset 'h0;
                }
            }
        }
        block ecf_ccf_axi_ccf_Probe_T_sip4_main_TransactionStatProfiler @0xDC400 {
            bytes 4;
            register ccf_Probe_T_sip4_main_TransactionStatProfiler_Id_CoreId @0x0 {
                bytes 4;
                field CORETYPEID @'h0 {
                    bits 8;
                    access ro;
                    hard_reset 'ha;
                    doc {
                        Field identifying the type of IP.
                    }
                }
                field CORECHECKSUM @'h8 {
                    bits 24;
                    access ro;
                    hard_reset 'hefe375;
                    doc {
                        Field containing a checksum of the parameters of the IP.
                    }
                }
            }
            register ccf_Probe_T_sip4_main_TransactionStatProfiler_Id_RevisionId @0x4 {
                bytes 4;
                field USERID @'h0 {
                    bits 8;
                    access ro;
                    hard_reset 'h0;
                    doc {
                        Field containing a user defined value, not used anywhere inside the IP itself.
                    }
                }
                field FLEXNOCID @'h8 {
                    bits 24;
                    access ro;
                    hard_reset 'h84f8c6;
                    doc {
                        Field containing the build revision of the software used to generate the IP HDL code.
                    }
                }
            }
            register ccf_Probe_T_sip4_main_TransactionStatProfiler_En @0x8 {
                bytes 4;
                field EN @'h0 {
                    access rw;
                    hard_reset 'h0;
                    doc {
                        Register En is a 1-bit register that enables the transaction probe counter unit.
                    }
                }
            }
            register ccf_Probe_T_sip4_main_TransactionStatProfiler_Mode @0xC {
                bytes 4;
                field MODE @'h0 {
                    access rw;
                    hard_reset 'h0;
                    doc {
                        Register Mode sets the counting mode per observed port. Each bit per observation port defines the incrementing mode. (Mode = 0 for Delay, Mode = 1 for Pending)
                    }
                }
            }
            register ccf_Probe_T_sip4_main_TransactionStatProfiler_Reserved_00 @0x10 {
                bytes 4;
                field ccf_Probe_T_sip4_main_TransactionStatProfiler_Reserved_00 {
                    bits 32;
                    access rw;
                    hard_reset 'h0;
                }
            }
            register ccf_Probe_T_sip4_main_TransactionStatProfiler_Reserved_01 @0x14 {
                bytes 4;
                field ccf_Probe_T_sip4_main_TransactionStatProfiler_Reserved_01 {
                    bits 32;
                    access rw;
                    hard_reset 'h0;
                }
            }
            register ccf_Probe_T_sip4_main_TransactionStatProfiler_Reserved_02 @0x18 {
                bytes 4;
                field ccf_Probe_T_sip4_main_TransactionStatProfiler_Reserved_02 {
                    bits 32;
                    access rw;
                    hard_reset 'h0;
                }
            }
            register ccf_Probe_T_sip4_main_TransactionStatProfiler_Reserved_03 @0x1C {
                bytes 4;
                field ccf_Probe_T_sip4_main_TransactionStatProfiler_Reserved_03 {
                    bits 32;
                    access rw;
                    hard_reset 'h0;
                }
            }
            register ccf_Probe_T_sip4_main_TransactionStatProfiler_Reserved_04 @0x20 {
                bytes 4;
                field ccf_Probe_T_sip4_main_TransactionStatProfiler_Reserved_04 {
                    bits 32;
                    access rw;
                    hard_reset 'h0;
                }
            }
            register ccf_Probe_T_sip4_main_TransactionStatProfiler_Reserved_05 @0x24 {
                bytes 4;
                field ccf_Probe_T_sip4_main_TransactionStatProfiler_Reserved_05 {
                    bits 32;
                    access rw;
                    hard_reset 'h0;
                }
            }
            register ccf_Probe_T_sip4_main_TransactionStatProfiler_Reserved_06 @0x28 {
                bytes 4;
                field ccf_Probe_T_sip4_main_TransactionStatProfiler_Reserved_06 {
                    bits 32;
                    access rw;
                    hard_reset 'h0;
                }
            }
            register ccf_Probe_T_sip4_main_TransactionStatProfiler_Thresholds_0_0 @0x2C {
                bytes 4;
                field THRESHOLDS_0_0 @'h0 {
                    bits 8;
                    access rw;
                    hard_reset 'h0;
                    doc {
                        Register Thresholds_i_j contains the threshold index "0" that allows computation of threshold values.
                    }
                }
            }
            register ccf_Probe_T_sip4_main_TransactionStatProfiler_Reserved_07 @0x30 {
                bytes 4;
                field ccf_Probe_T_sip4_main_TransactionStatProfiler_Reserved_07 {
                    bits 32;
                    access rw;
                    hard_reset 'h0;
                }
            }
            register ccf_Probe_T_sip4_main_TransactionStatProfiler_Reserved_08 @0x34 {
                bytes 4;
                field ccf_Probe_T_sip4_main_TransactionStatProfiler_Reserved_08 {
                    bits 32;
                    access rw;
                    hard_reset 'h0;
                }
            }
            register ccf_Probe_T_sip4_main_TransactionStatProfiler_Reserved_09 @0x38 {
                bytes 4;
                field ccf_Probe_T_sip4_main_TransactionStatProfiler_Reserved_09 {
                    bits 32;
                    access rw;
                    hard_reset 'h0;
                }
            }
            register ccf_Probe_T_sip4_main_TransactionStatProfiler_Reserved_10 @0x3C {
                bytes 4;
                field ccf_Probe_T_sip4_main_TransactionStatProfiler_Reserved_10 {
                    bits 32;
                    access rw;
                    hard_reset 'h0;
                }
            }
            register ccf_Probe_T_sip4_main_TransactionStatProfiler_Reserved_11 @0x40 {
                bytes 4;
                field ccf_Probe_T_sip4_main_TransactionStatProfiler_Reserved_11 {
                    bits 32;
                    access rw;
                    hard_reset 'h0;
                }
            }
            register ccf_Probe_T_sip4_main_TransactionStatProfiler_Reserved_12 @0x44 {
                bytes 4;
                field ccf_Probe_T_sip4_main_TransactionStatProfiler_Reserved_12 {
                    bits 32;
                    access rw;
                    hard_reset 'h0;
                }
            }
            register ccf_Probe_T_sip4_main_TransactionStatProfiler_Reserved_13 @0x48 {
                bytes 4;
                field ccf_Probe_T_sip4_main_TransactionStatProfiler_Reserved_13 {
                    bits 32;
                    access rw;
                    hard_reset 'h0;
                }
            }
            register ccf_Probe_T_sip4_main_TransactionStatProfiler_Reserved_14 @0x4C {
                bytes 4;
                field ccf_Probe_T_sip4_main_TransactionStatProfiler_Reserved_14 {
                    bits 32;
                    access rw;
                    hard_reset 'h0;
                }
            }
            register ccf_Probe_T_sip4_main_TransactionStatProfiler_Reserved_15 @0x50 {
                bytes 4;
                field ccf_Probe_T_sip4_main_TransactionStatProfiler_Reserved_15 {
                    bits 32;
                    access rw;
                    hard_reset 'h0;
                }
            }
            register ccf_Probe_T_sip4_main_TransactionStatProfiler_Reserved_16 @0x54 {
                bytes 4;
                field ccf_Probe_T_sip4_main_TransactionStatProfiler_Reserved_16 {
                    bits 32;
                    access rw;
                    hard_reset 'h0;
                }
            }
            register ccf_Probe_T_sip4_main_TransactionStatProfiler_Reserved_17 @0x58 {
                bytes 4;
                field ccf_Probe_T_sip4_main_TransactionStatProfiler_Reserved_17 {
                    bits 32;
                    access rw;
                    hard_reset 'h0;
                }
            }
            register ccf_Probe_T_sip4_main_TransactionStatProfiler_Reserved_18 @0x5C {
                bytes 4;
                field ccf_Probe_T_sip4_main_TransactionStatProfiler_Reserved_18 {
                    bits 32;
                    access rw;
                    hard_reset 'h0;
                }
            }
            register ccf_Probe_T_sip4_main_TransactionStatProfiler_Reserved_19 @0x60 {
                bytes 4;
                field ccf_Probe_T_sip4_main_TransactionStatProfiler_Reserved_19 {
                    bits 32;
                    access rw;
                    hard_reset 'h0;
                }
            }
            register ccf_Probe_T_sip4_main_TransactionStatProfiler_Reserved_20 @0x64 {
                bytes 4;
                field ccf_Probe_T_sip4_main_TransactionStatProfiler_Reserved_20 {
                    bits 32;
                    access rw;
                    hard_reset 'h0;
                }
            }
            register ccf_Probe_T_sip4_main_TransactionStatProfiler_Reserved_21 @0x68 {
                bytes 4;
                field ccf_Probe_T_sip4_main_TransactionStatProfiler_Reserved_21 {
                    bits 32;
                    access rw;
                    hard_reset 'h0;
                }
            }
            register ccf_Probe_T_sip4_main_TransactionStatProfiler_OverflowStatus @0x6C {
                bytes 4;
                field OVERFLOWSTATUS @'h0 {
                    access ro;
                    hard_reset 'h0;
                    doc {
                        Bit n of register OverflowStatus is set to 1 if a start event occurs on observed port n and eitherof the following conditions occurs: All tenure counters allocated to the port are already in use. No tenure lines have been allocated to the port. The number of bits in this register is equal to the value set for parameter nObservable.
                    }
                }
            }
            register ccf_Probe_T_sip4_main_TransactionStatProfiler_OverflowReset @0x70 {
                bytes 4;
                field OVERFLOWRESET @'h0 {
                    access w1c;
                    hard_reset 'h0;
                    doc {
                        Register OverflowReset is a pulse register that clears overflow status bits per observed port on each write access. OverflowReset = nObservable. Writing 0x2  clears the overflow status of observed port 1.
                    }
                }
            }
            register ccf_Probe_T_sip4_main_TransactionStatProfiler_PendingEventMode @0x74 {
                bytes 4;
                field PENDINGEVENTMODE @'h0 {
                    access rw;
                    hard_reset 'h0;
                    doc {
                        Register pendingEventMode is a 1-bit register that configures the pending event mode. When set to 0 (CYCLE), and when register mode is set to PENDING, the pending event is generated on each cycle when the counter is greater than zero.When set to 1 (STOP) the pending event is generated on each stop event.
                    }
                }
            }
            register ccf_Probe_T_sip4_main_TransactionStatProfiler_PreScaler @0x78 {
                bytes 4;
                field PRESCALER @'h0 {
                    bits 8;
                    access rw;
                    hard_reset 'h0;
                    doc {
                        8Register Prescaler is an-bit pre-scaling register that accepts any pre-scaling value between 1 (default) and 256. If set to 0, pre-scaling is disabled. If set to any other supported value "n", the threshold counter value is divided by (n + 1).
                    }
                }
            }
            register ccf_Probe_T_sip4_main_TransactionStatProfiler_Reserved_22 @0x7C {
                bytes 4;
                field ccf_Probe_T_sip4_main_TransactionStatProfiler_Reserved_22 {
                    bits 32;
                    access rw;
                    hard_reset 'h0;
                }
            }
        }
        block ecf_ccf_axi_ccf_Probe_T_sip5_main_TransactionStatProfiler @0xDC480 {
            bytes 4;
            register ccf_Probe_T_sip5_main_TransactionStatProfiler_Id_CoreId @0x0 {
                bytes 4;
                field CORETYPEID @'h0 {
                    bits 8;
                    access ro;
                    hard_reset 'ha;
                    doc {
                        Field identifying the type of IP.
                    }
                }
                field CORECHECKSUM @'h8 {
                    bits 24;
                    access ro;
                    hard_reset 'hb49672;
                    doc {
                        Field containing a checksum of the parameters of the IP.
                    }
                }
            }
            register ccf_Probe_T_sip5_main_TransactionStatProfiler_Id_RevisionId @0x4 {
                bytes 4;
                field USERID @'h0 {
                    bits 8;
                    access ro;
                    hard_reset 'h0;
                    doc {
                        Field containing a user defined value, not used anywhere inside the IP itself.
                    }
                }
                field FLEXNOCID @'h8 {
                    bits 24;
                    access ro;
                    hard_reset 'h84f8c6;
                    doc {
                        Field containing the build revision of the software used to generate the IP HDL code.
                    }
                }
            }
            register ccf_Probe_T_sip5_main_TransactionStatProfiler_En @0x8 {
                bytes 4;
                field EN @'h0 {
                    access rw;
                    hard_reset 'h0;
                    doc {
                        Register En is a 1-bit register that enables the transaction probe counter unit.
                    }
                }
            }
            register ccf_Probe_T_sip5_main_TransactionStatProfiler_Mode @0xC {
                bytes 4;
                field MODE @'h0 {
                    access rw;
                    hard_reset 'h0;
                    doc {
                        Register Mode sets the counting mode per observed port. Each bit per observation port defines the incrementing mode. (Mode = 0 for Delay, Mode = 1 for Pending)
                    }
                }
            }
            register ccf_Probe_T_sip5_main_TransactionStatProfiler_Reserved_00 @0x10 {
                bytes 4;
                field ccf_Probe_T_sip5_main_TransactionStatProfiler_Reserved_00 {
                    bits 32;
                    access rw;
                    hard_reset 'h0;
                }
            }
            register ccf_Probe_T_sip5_main_TransactionStatProfiler_Reserved_01 @0x14 {
                bytes 4;
                field ccf_Probe_T_sip5_main_TransactionStatProfiler_Reserved_01 {
                    bits 32;
                    access rw;
                    hard_reset 'h0;
                }
            }
            register ccf_Probe_T_sip5_main_TransactionStatProfiler_Reserved_02 @0x18 {
                bytes 4;
                field ccf_Probe_T_sip5_main_TransactionStatProfiler_Reserved_02 {
                    bits 32;
                    access rw;
                    hard_reset 'h0;
                }
            }
            register ccf_Probe_T_sip5_main_TransactionStatProfiler_Reserved_03 @0x1C {
                bytes 4;
                field ccf_Probe_T_sip5_main_TransactionStatProfiler_Reserved_03 {
                    bits 32;
                    access rw;
                    hard_reset 'h0;
                }
            }
            register ccf_Probe_T_sip5_main_TransactionStatProfiler_Reserved_04 @0x20 {
                bytes 4;
                field ccf_Probe_T_sip5_main_TransactionStatProfiler_Reserved_04 {
                    bits 32;
                    access rw;
                    hard_reset 'h0;
                }
            }
            register ccf_Probe_T_sip5_main_TransactionStatProfiler_Reserved_05 @0x24 {
                bytes 4;
                field ccf_Probe_T_sip5_main_TransactionStatProfiler_Reserved_05 {
                    bits 32;
                    access rw;
                    hard_reset 'h0;
                }
            }
            register ccf_Probe_T_sip5_main_TransactionStatProfiler_Reserved_06 @0x28 {
                bytes 4;
                field ccf_Probe_T_sip5_main_TransactionStatProfiler_Reserved_06 {
                    bits 32;
                    access rw;
                    hard_reset 'h0;
                }
            }
            register ccf_Probe_T_sip5_main_TransactionStatProfiler_Thresholds_0_0 @0x2C {
                bytes 4;
                field THRESHOLDS_0_0 @'h0 {
                    bits 8;
                    access rw;
                    hard_reset 'h0;
                    doc {
                        Register Thresholds_i_j contains the threshold index "0" that allows computation of threshold values.
                    }
                }
            }
            register ccf_Probe_T_sip5_main_TransactionStatProfiler_Reserved_07 @0x30 {
                bytes 4;
                field ccf_Probe_T_sip5_main_TransactionStatProfiler_Reserved_07 {
                    bits 32;
                    access rw;
                    hard_reset 'h0;
                }
            }
            register ccf_Probe_T_sip5_main_TransactionStatProfiler_Reserved_08 @0x34 {
                bytes 4;
                field ccf_Probe_T_sip5_main_TransactionStatProfiler_Reserved_08 {
                    bits 32;
                    access rw;
                    hard_reset 'h0;
                }
            }
            register ccf_Probe_T_sip5_main_TransactionStatProfiler_Reserved_09 @0x38 {
                bytes 4;
                field ccf_Probe_T_sip5_main_TransactionStatProfiler_Reserved_09 {
                    bits 32;
                    access rw;
                    hard_reset 'h0;
                }
            }
            register ccf_Probe_T_sip5_main_TransactionStatProfiler_Reserved_10 @0x3C {
                bytes 4;
                field ccf_Probe_T_sip5_main_TransactionStatProfiler_Reserved_10 {
                    bits 32;
                    access rw;
                    hard_reset 'h0;
                }
            }
            register ccf_Probe_T_sip5_main_TransactionStatProfiler_Reserved_11 @0x40 {
                bytes 4;
                field ccf_Probe_T_sip5_main_TransactionStatProfiler_Reserved_11 {
                    bits 32;
                    access rw;
                    hard_reset 'h0;
                }
            }
            register ccf_Probe_T_sip5_main_TransactionStatProfiler_Reserved_12 @0x44 {
                bytes 4;
                field ccf_Probe_T_sip5_main_TransactionStatProfiler_Reserved_12 {
                    bits 32;
                    access rw;
                    hard_reset 'h0;
                }
            }
            register ccf_Probe_T_sip5_main_TransactionStatProfiler_Reserved_13 @0x48 {
                bytes 4;
                field ccf_Probe_T_sip5_main_TransactionStatProfiler_Reserved_13 {
                    bits 32;
                    access rw;
                    hard_reset 'h0;
                }
            }
            register ccf_Probe_T_sip5_main_TransactionStatProfiler_Reserved_14 @0x4C {
                bytes 4;
                field ccf_Probe_T_sip5_main_TransactionStatProfiler_Reserved_14 {
                    bits 32;
                    access rw;
                    hard_reset 'h0;
                }
            }
            register ccf_Probe_T_sip5_main_TransactionStatProfiler_Reserved_15 @0x50 {
                bytes 4;
                field ccf_Probe_T_sip5_main_TransactionStatProfiler_Reserved_15 {
                    bits 32;
                    access rw;
                    hard_reset 'h0;
                }
            }
            register ccf_Probe_T_sip5_main_TransactionStatProfiler_Reserved_16 @0x54 {
                bytes 4;
                field ccf_Probe_T_sip5_main_TransactionStatProfiler_Reserved_16 {
                    bits 32;
                    access rw;
                    hard_reset 'h0;
                }
            }
            register ccf_Probe_T_sip5_main_TransactionStatProfiler_Reserved_17 @0x58 {
                bytes 4;
                field ccf_Probe_T_sip5_main_TransactionStatProfiler_Reserved_17 {
                    bits 32;
                    access rw;
                    hard_reset 'h0;
                }
            }
            register ccf_Probe_T_sip5_main_TransactionStatProfiler_Reserved_18 @0x5C {
                bytes 4;
                field ccf_Probe_T_sip5_main_TransactionStatProfiler_Reserved_18 {
                    bits 32;
                    access rw;
                    hard_reset 'h0;
                }
            }
            register ccf_Probe_T_sip5_main_TransactionStatProfiler_Reserved_19 @0x60 {
                bytes 4;
                field ccf_Probe_T_sip5_main_TransactionStatProfiler_Reserved_19 {
                    bits 32;
                    access rw;
                    hard_reset 'h0;
                }
            }
            register ccf_Probe_T_sip5_main_TransactionStatProfiler_Reserved_20 @0x64 {
                bytes 4;
                field ccf_Probe_T_sip5_main_TransactionStatProfiler_Reserved_20 {
                    bits 32;
                    access rw;
                    hard_reset 'h0;
                }
            }
            register ccf_Probe_T_sip5_main_TransactionStatProfiler_Reserved_21 @0x68 {
                bytes 4;
                field ccf_Probe_T_sip5_main_TransactionStatProfiler_Reserved_21 {
                    bits 32;
                    access rw;
                    hard_reset 'h0;
                }
            }
            register ccf_Probe_T_sip5_main_TransactionStatProfiler_OverflowStatus @0x6C {
                bytes 4;
                field OVERFLOWSTATUS @'h0 {
                    access ro;
                    hard_reset 'h0;
                    doc {
                        Bit n of register OverflowStatus is set to 1 if a start event occurs on observed port n and eitherof the following conditions occurs: All tenure counters allocated to the port are already in use. No tenure lines have been allocated to the port. The number of bits in this register is equal to the value set for parameter nObservable.
                    }
                }
            }
            register ccf_Probe_T_sip5_main_TransactionStatProfiler_OverflowReset @0x70 {
                bytes 4;
                field OVERFLOWRESET @'h0 {
                    access w1c;
                    hard_reset 'h0;
                    doc {
                        Register OverflowReset is a pulse register that clears overflow status bits per observed port on each write access. OverflowReset = nObservable. Writing 0x2  clears the overflow status of observed port 1.
                    }
                }
            }
            register ccf_Probe_T_sip5_main_TransactionStatProfiler_PendingEventMode @0x74 {
                bytes 4;
                field PENDINGEVENTMODE @'h0 {
                    access rw;
                    hard_reset 'h0;
                    doc {
                        Register pendingEventMode is a 1-bit register that configures the pending event mode. When set to 0 (CYCLE), and when register mode is set to PENDING, the pending event is generated on each cycle when the counter is greater than zero.When set to 1 (STOP) the pending event is generated on each stop event.
                    }
                }
            }
            register ccf_Probe_T_sip5_main_TransactionStatProfiler_PreScaler @0x78 {
                bytes 4;
                field PRESCALER @'h0 {
                    bits 8;
                    access rw;
                    hard_reset 'h0;
                    doc {
                        8Register Prescaler is an-bit pre-scaling register that accepts any pre-scaling value between 1 (default) and 256. If set to 0, pre-scaling is disabled. If set to any other supported value "n", the threshold counter value is divided by (n + 1).
                    }
                }
            }
            register ccf_Probe_T_sip5_main_TransactionStatProfiler_Reserved_22 @0x7C {
                bytes 4;
                field ccf_Probe_T_sip5_main_TransactionStatProfiler_Reserved_22 {
                    bits 32;
                    access rw;
                    hard_reset 'h0;
                }
            }
        }
        block ecf_ccf_axi_ccf_Probe_T_sip6_main_TransactionStatProfiler @0xDC500 {
            bytes 4;
            register ccf_Probe_T_sip6_main_TransactionStatProfiler_Id_CoreId @0x0 {
                bytes 4;
                field CORETYPEID @'h0 {
                    bits 8;
                    access ro;
                    hard_reset 'ha;
                    doc {
                        Field identifying the type of IP.
                    }
                }
                field CORECHECKSUM @'h8 {
                    bits 24;
                    access ro;
                    hard_reset 'hb612f5;
                    doc {
                        Field containing a checksum of the parameters of the IP.
                    }
                }
            }
            register ccf_Probe_T_sip6_main_TransactionStatProfiler_Id_RevisionId @0x4 {
                bytes 4;
                field USERID @'h0 {
                    bits 8;
                    access ro;
                    hard_reset 'h0;
                    doc {
                        Field containing a user defined value, not used anywhere inside the IP itself.
                    }
                }
                field FLEXNOCID @'h8 {
                    bits 24;
                    access ro;
                    hard_reset 'h84f8c6;
                    doc {
                        Field containing the build revision of the software used to generate the IP HDL code.
                    }
                }
            }
            register ccf_Probe_T_sip6_main_TransactionStatProfiler_En @0x8 {
                bytes 4;
                field EN @'h0 {
                    access rw;
                    hard_reset 'h0;
                    doc {
                        Register En is a 1-bit register that enables the transaction probe counter unit.
                    }
                }
            }
            register ccf_Probe_T_sip6_main_TransactionStatProfiler_Mode @0xC {
                bytes 4;
                field MODE @'h0 {
                    access rw;
                    hard_reset 'h0;
                    doc {
                        Register Mode sets the counting mode per observed port. Each bit per observation port defines the incrementing mode. (Mode = 0 for Delay, Mode = 1 for Pending)
                    }
                }
            }
            register ccf_Probe_T_sip6_main_TransactionStatProfiler_Reserved_00 @0x10 {
                bytes 4;
                field ccf_Probe_T_sip6_main_TransactionStatProfiler_Reserved_00 {
                    bits 32;
                    access rw;
                    hard_reset 'h0;
                }
            }
            register ccf_Probe_T_sip6_main_TransactionStatProfiler_Reserved_01 @0x14 {
                bytes 4;
                field ccf_Probe_T_sip6_main_TransactionStatProfiler_Reserved_01 {
                    bits 32;
                    access rw;
                    hard_reset 'h0;
                }
            }
            register ccf_Probe_T_sip6_main_TransactionStatProfiler_Reserved_02 @0x18 {
                bytes 4;
                field ccf_Probe_T_sip6_main_TransactionStatProfiler_Reserved_02 {
                    bits 32;
                    access rw;
                    hard_reset 'h0;
                }
            }
            register ccf_Probe_T_sip6_main_TransactionStatProfiler_Reserved_03 @0x1C {
                bytes 4;
                field ccf_Probe_T_sip6_main_TransactionStatProfiler_Reserved_03 {
                    bits 32;
                    access rw;
                    hard_reset 'h0;
                }
            }
            register ccf_Probe_T_sip6_main_TransactionStatProfiler_Reserved_04 @0x20 {
                bytes 4;
                field ccf_Probe_T_sip6_main_TransactionStatProfiler_Reserved_04 {
                    bits 32;
                    access rw;
                    hard_reset 'h0;
                }
            }
            register ccf_Probe_T_sip6_main_TransactionStatProfiler_Reserved_05 @0x24 {
                bytes 4;
                field ccf_Probe_T_sip6_main_TransactionStatProfiler_Reserved_05 {
                    bits 32;
                    access rw;
                    hard_reset 'h0;
                }
            }
            register ccf_Probe_T_sip6_main_TransactionStatProfiler_Reserved_06 @0x28 {
                bytes 4;
                field ccf_Probe_T_sip6_main_TransactionStatProfiler_Reserved_06 {
                    bits 32;
                    access rw;
                    hard_reset 'h0;
                }
            }
            register ccf_Probe_T_sip6_main_TransactionStatProfiler_Thresholds_0_0 @0x2C {
                bytes 4;
                field THRESHOLDS_0_0 @'h0 {
                    bits 8;
                    access rw;
                    hard_reset 'h0;
                    doc {
                        Register Thresholds_i_j contains the threshold index "0" that allows computation of threshold values.
                    }
                }
            }
            register ccf_Probe_T_sip6_main_TransactionStatProfiler_Reserved_07 @0x30 {
                bytes 4;
                field ccf_Probe_T_sip6_main_TransactionStatProfiler_Reserved_07 {
                    bits 32;
                    access rw;
                    hard_reset 'h0;
                }
            }
            register ccf_Probe_T_sip6_main_TransactionStatProfiler_Reserved_08 @0x34 {
                bytes 4;
                field ccf_Probe_T_sip6_main_TransactionStatProfiler_Reserved_08 {
                    bits 32;
                    access rw;
                    hard_reset 'h0;
                }
            }
            register ccf_Probe_T_sip6_main_TransactionStatProfiler_Reserved_09 @0x38 {
                bytes 4;
                field ccf_Probe_T_sip6_main_TransactionStatProfiler_Reserved_09 {
                    bits 32;
                    access rw;
                    hard_reset 'h0;
                }
            }
            register ccf_Probe_T_sip6_main_TransactionStatProfiler_Reserved_10 @0x3C {
                bytes 4;
                field ccf_Probe_T_sip6_main_TransactionStatProfiler_Reserved_10 {
                    bits 32;
                    access rw;
                    hard_reset 'h0;
                }
            }
            register ccf_Probe_T_sip6_main_TransactionStatProfiler_Reserved_11 @0x40 {
                bytes 4;
                field ccf_Probe_T_sip6_main_TransactionStatProfiler_Reserved_11 {
                    bits 32;
                    access rw;
                    hard_reset 'h0;
                }
            }
            register ccf_Probe_T_sip6_main_TransactionStatProfiler_Reserved_12 @0x44 {
                bytes 4;
                field ccf_Probe_T_sip6_main_TransactionStatProfiler_Reserved_12 {
                    bits 32;
                    access rw;
                    hard_reset 'h0;
                }
            }
            register ccf_Probe_T_sip6_main_TransactionStatProfiler_Reserved_13 @0x48 {
                bytes 4;
                field ccf_Probe_T_sip6_main_TransactionStatProfiler_Reserved_13 {
                    bits 32;
                    access rw;
                    hard_reset 'h0;
                }
            }
            register ccf_Probe_T_sip6_main_TransactionStatProfiler_Reserved_14 @0x4C {
                bytes 4;
                field ccf_Probe_T_sip6_main_TransactionStatProfiler_Reserved_14 {
                    bits 32;
                    access rw;
                    hard_reset 'h0;
                }
            }
            register ccf_Probe_T_sip6_main_TransactionStatProfiler_Reserved_15 @0x50 {
                bytes 4;
                field ccf_Probe_T_sip6_main_TransactionStatProfiler_Reserved_15 {
                    bits 32;
                    access rw;
                    hard_reset 'h0;
                }
            }
            register ccf_Probe_T_sip6_main_TransactionStatProfiler_Reserved_16 @0x54 {
                bytes 4;
                field ccf_Probe_T_sip6_main_TransactionStatProfiler_Reserved_16 {
                    bits 32;
                    access rw;
                    hard_reset 'h0;
                }
            }
            register ccf_Probe_T_sip6_main_TransactionStatProfiler_Reserved_17 @0x58 {
                bytes 4;
                field ccf_Probe_T_sip6_main_TransactionStatProfiler_Reserved_17 {
                    bits 32;
                    access rw;
                    hard_reset 'h0;
                }
            }
            register ccf_Probe_T_sip6_main_TransactionStatProfiler_Reserved_18 @0x5C {
                bytes 4;
                field ccf_Probe_T_sip6_main_TransactionStatProfiler_Reserved_18 {
                    bits 32;
                    access rw;
                    hard_reset 'h0;
                }
            }
            register ccf_Probe_T_sip6_main_TransactionStatProfiler_Reserved_19 @0x60 {
                bytes 4;
                field ccf_Probe_T_sip6_main_TransactionStatProfiler_Reserved_19 {
                    bits 32;
                    access rw;
                    hard_reset 'h0;
                }
            }
            register ccf_Probe_T_sip6_main_TransactionStatProfiler_Reserved_20 @0x64 {
                bytes 4;
                field ccf_Probe_T_sip6_main_TransactionStatProfiler_Reserved_20 {
                    bits 32;
                    access rw;
                    hard_reset 'h0;
                }
            }
            register ccf_Probe_T_sip6_main_TransactionStatProfiler_Reserved_21 @0x68 {
                bytes 4;
                field ccf_Probe_T_sip6_main_TransactionStatProfiler_Reserved_21 {
                    bits 32;
                    access rw;
                    hard_reset 'h0;
                }
            }
            register ccf_Probe_T_sip6_main_TransactionStatProfiler_OverflowStatus @0x6C {
                bytes 4;
                field OVERFLOWSTATUS @'h0 {
                    access ro;
                    hard_reset 'h0;
                    doc {
                        Bit n of register OverflowStatus is set to 1 if a start event occurs on observed port n and eitherof the following conditions occurs: All tenure counters allocated to the port are already in use. No tenure lines have been allocated to the port. The number of bits in this register is equal to the value set for parameter nObservable.
                    }
                }
            }
            register ccf_Probe_T_sip6_main_TransactionStatProfiler_OverflowReset @0x70 {
                bytes 4;
                field OVERFLOWRESET @'h0 {
                    access w1c;
                    hard_reset 'h0;
                    doc {
                        Register OverflowReset is a pulse register that clears overflow status bits per observed port on each write access. OverflowReset = nObservable. Writing 0x2  clears the overflow status of observed port 1.
                    }
                }
            }
            register ccf_Probe_T_sip6_main_TransactionStatProfiler_PendingEventMode @0x74 {
                bytes 4;
                field PENDINGEVENTMODE @'h0 {
                    access rw;
                    hard_reset 'h0;
                    doc {
                        Register pendingEventMode is a 1-bit register that configures the pending event mode. When set to 0 (CYCLE), and when register mode is set to PENDING, the pending event is generated on each cycle when the counter is greater than zero.When set to 1 (STOP) the pending event is generated on each stop event.
                    }
                }
            }
            register ccf_Probe_T_sip6_main_TransactionStatProfiler_PreScaler @0x78 {
                bytes 4;
                field PRESCALER @'h0 {
                    bits 8;
                    access rw;
                    hard_reset 'h0;
                    doc {
                        8Register Prescaler is an-bit pre-scaling register that accepts any pre-scaling value between 1 (default) and 256. If set to 0, pre-scaling is disabled. If set to any other supported value "n", the threshold counter value is divided by (n + 1).
                    }
                }
            }
            register ccf_Probe_T_sip6_main_TransactionStatProfiler_Reserved_22 @0x7C {
                bytes 4;
                field ccf_Probe_T_sip6_main_TransactionStatProfiler_Reserved_22 {
                    bits 32;
                    access rw;
                    hard_reset 'h0;
                }
            }
        }
        block ecf_ccf_axi_ccf_Probe_T_sip7_main_TransactionStatProfiler @0xDC580 {
            bytes 4;
            register ccf_Probe_T_sip7_main_TransactionStatProfiler_Id_CoreId @0x0 {
                bytes 4;
                field CORETYPEID @'h0 {
                    bits 8;
                    access ro;
                    hard_reset 'ha;
                    doc {
                        Field identifying the type of IP.
                    }
                }
                field CORECHECKSUM @'h8 {
                    bits 24;
                    access ro;
                    hard_reset 'h1c80a6;
                    doc {
                        Field containing a checksum of the parameters of the IP.
                    }
                }
            }
            register ccf_Probe_T_sip7_main_TransactionStatProfiler_Id_RevisionId @0x4 {
                bytes 4;
                field USERID @'h0 {
                    bits 8;
                    access ro;
                    hard_reset 'h0;
                    doc {
                        Field containing a user defined value, not used anywhere inside the IP itself.
                    }
                }
                field FLEXNOCID @'h8 {
                    bits 24;
                    access ro;
                    hard_reset 'h84f8c6;
                    doc {
                        Field containing the build revision of the software used to generate the IP HDL code.
                    }
                }
            }
            register ccf_Probe_T_sip7_main_TransactionStatProfiler_En @0x8 {
                bytes 4;
                field EN @'h0 {
                    access rw;
                    hard_reset 'h0;
                    doc {
                        Register En is a 1-bit register that enables the transaction probe counter unit.
                    }
                }
            }
            register ccf_Probe_T_sip7_main_TransactionStatProfiler_Mode @0xC {
                bytes 4;
                field MODE @'h0 {
                    access rw;
                    hard_reset 'h0;
                    doc {
                        Register Mode sets the counting mode per observed port. Each bit per observation port defines the incrementing mode. (Mode = 0 for Delay, Mode = 1 for Pending)
                    }
                }
            }
            register ccf_Probe_T_sip7_main_TransactionStatProfiler_Reserved_00 @0x10 {
                bytes 4;
                field ccf_Probe_T_sip7_main_TransactionStatProfiler_Reserved_00 {
                    bits 32;
                    access rw;
                    hard_reset 'h0;
                }
            }
            register ccf_Probe_T_sip7_main_TransactionStatProfiler_Reserved_01 @0x14 {
                bytes 4;
                field ccf_Probe_T_sip7_main_TransactionStatProfiler_Reserved_01 {
                    bits 32;
                    access rw;
                    hard_reset 'h0;
                }
            }
            register ccf_Probe_T_sip7_main_TransactionStatProfiler_Reserved_02 @0x18 {
                bytes 4;
                field ccf_Probe_T_sip7_main_TransactionStatProfiler_Reserved_02 {
                    bits 32;
                    access rw;
                    hard_reset 'h0;
                }
            }
            register ccf_Probe_T_sip7_main_TransactionStatProfiler_Reserved_03 @0x1C {
                bytes 4;
                field ccf_Probe_T_sip7_main_TransactionStatProfiler_Reserved_03 {
                    bits 32;
                    access rw;
                    hard_reset 'h0;
                }
            }
            register ccf_Probe_T_sip7_main_TransactionStatProfiler_Reserved_04 @0x20 {
                bytes 4;
                field ccf_Probe_T_sip7_main_TransactionStatProfiler_Reserved_04 {
                    bits 32;
                    access rw;
                    hard_reset 'h0;
                }
            }
            register ccf_Probe_T_sip7_main_TransactionStatProfiler_Reserved_05 @0x24 {
                bytes 4;
                field ccf_Probe_T_sip7_main_TransactionStatProfiler_Reserved_05 {
                    bits 32;
                    access rw;
                    hard_reset 'h0;
                }
            }
            register ccf_Probe_T_sip7_main_TransactionStatProfiler_Reserved_06 @0x28 {
                bytes 4;
                field ccf_Probe_T_sip7_main_TransactionStatProfiler_Reserved_06 {
                    bits 32;
                    access rw;
                    hard_reset 'h0;
                }
            }
            register ccf_Probe_T_sip7_main_TransactionStatProfiler_Thresholds_0_0 @0x2C {
                bytes 4;
                field THRESHOLDS_0_0 @'h0 {
                    bits 8;
                    access rw;
                    hard_reset 'h0;
                    doc {
                        Register Thresholds_i_j contains the threshold index "0" that allows computation of threshold values.
                    }
                }
            }
            register ccf_Probe_T_sip7_main_TransactionStatProfiler_Reserved_07 @0x30 {
                bytes 4;
                field ccf_Probe_T_sip7_main_TransactionStatProfiler_Reserved_07 {
                    bits 32;
                    access rw;
                    hard_reset 'h0;
                }
            }
            register ccf_Probe_T_sip7_main_TransactionStatProfiler_Reserved_08 @0x34 {
                bytes 4;
                field ccf_Probe_T_sip7_main_TransactionStatProfiler_Reserved_08 {
                    bits 32;
                    access rw;
                    hard_reset 'h0;
                }
            }
            register ccf_Probe_T_sip7_main_TransactionStatProfiler_Reserved_09 @0x38 {
                bytes 4;
                field ccf_Probe_T_sip7_main_TransactionStatProfiler_Reserved_09 {
                    bits 32;
                    access rw;
                    hard_reset 'h0;
                }
            }
            register ccf_Probe_T_sip7_main_TransactionStatProfiler_Reserved_10 @0x3C {
                bytes 4;
                field ccf_Probe_T_sip7_main_TransactionStatProfiler_Reserved_10 {
                    bits 32;
                    access rw;
                    hard_reset 'h0;
                }
            }
            register ccf_Probe_T_sip7_main_TransactionStatProfiler_Reserved_11 @0x40 {
                bytes 4;
                field ccf_Probe_T_sip7_main_TransactionStatProfiler_Reserved_11 {
                    bits 32;
                    access rw;
                    hard_reset 'h0;
                }
            }
            register ccf_Probe_T_sip7_main_TransactionStatProfiler_Reserved_12 @0x44 {
                bytes 4;
                field ccf_Probe_T_sip7_main_TransactionStatProfiler_Reserved_12 {
                    bits 32;
                    access rw;
                    hard_reset 'h0;
                }
            }
            register ccf_Probe_T_sip7_main_TransactionStatProfiler_Reserved_13 @0x48 {
                bytes 4;
                field ccf_Probe_T_sip7_main_TransactionStatProfiler_Reserved_13 {
                    bits 32;
                    access rw;
                    hard_reset 'h0;
                }
            }
            register ccf_Probe_T_sip7_main_TransactionStatProfiler_Reserved_14 @0x4C {
                bytes 4;
                field ccf_Probe_T_sip7_main_TransactionStatProfiler_Reserved_14 {
                    bits 32;
                    access rw;
                    hard_reset 'h0;
                }
            }
            register ccf_Probe_T_sip7_main_TransactionStatProfiler_Reserved_15 @0x50 {
                bytes 4;
                field ccf_Probe_T_sip7_main_TransactionStatProfiler_Reserved_15 {
                    bits 32;
                    access rw;
                    hard_reset 'h0;
                }
            }
            register ccf_Probe_T_sip7_main_TransactionStatProfiler_Reserved_16 @0x54 {
                bytes 4;
                field ccf_Probe_T_sip7_main_TransactionStatProfiler_Reserved_16 {
                    bits 32;
                    access rw;
                    hard_reset 'h0;
                }
            }
            register ccf_Probe_T_sip7_main_TransactionStatProfiler_Reserved_17 @0x58 {
                bytes 4;
                field ccf_Probe_T_sip7_main_TransactionStatProfiler_Reserved_17 {
                    bits 32;
                    access rw;
                    hard_reset 'h0;
                }
            }
            register ccf_Probe_T_sip7_main_TransactionStatProfiler_Reserved_18 @0x5C {
                bytes 4;
                field ccf_Probe_T_sip7_main_TransactionStatProfiler_Reserved_18 {
                    bits 32;
                    access rw;
                    hard_reset 'h0;
                }
            }
            register ccf_Probe_T_sip7_main_TransactionStatProfiler_Reserved_19 @0x60 {
                bytes 4;
                field ccf_Probe_T_sip7_main_TransactionStatProfiler_Reserved_19 {
                    bits 32;
                    access rw;
                    hard_reset 'h0;
                }
            }
            register ccf_Probe_T_sip7_main_TransactionStatProfiler_Reserved_20 @0x64 {
                bytes 4;
                field ccf_Probe_T_sip7_main_TransactionStatProfiler_Reserved_20 {
                    bits 32;
                    access rw;
                    hard_reset 'h0;
                }
            }
            register ccf_Probe_T_sip7_main_TransactionStatProfiler_Reserved_21 @0x68 {
                bytes 4;
                field ccf_Probe_T_sip7_main_TransactionStatProfiler_Reserved_21 {
                    bits 32;
                    access rw;
                    hard_reset 'h0;
                }
            }
            register ccf_Probe_T_sip7_main_TransactionStatProfiler_OverflowStatus @0x6C {
                bytes 4;
                field OVERFLOWSTATUS @'h0 {
                    access ro;
                    hard_reset 'h0;
                    doc {
                        Bit n of register OverflowStatus is set to 1 if a start event occurs on observed port n and eitherof the following conditions occurs: All tenure counters allocated to the port are already in use. No tenure lines have been allocated to the port. The number of bits in this register is equal to the value set for parameter nObservable.
                    }
                }
            }
            register ccf_Probe_T_sip7_main_TransactionStatProfiler_OverflowReset @0x70 {
                bytes 4;
                field OVERFLOWRESET @'h0 {
                    access w1c;
                    hard_reset 'h0;
                    doc {
                        Register OverflowReset is a pulse register that clears overflow status bits per observed port on each write access. OverflowReset = nObservable. Writing 0x2  clears the overflow status of observed port 1.
                    }
                }
            }
            register ccf_Probe_T_sip7_main_TransactionStatProfiler_PendingEventMode @0x74 {
                bytes 4;
                field PENDINGEVENTMODE @'h0 {
                    access rw;
                    hard_reset 'h0;
                    doc {
                        Register pendingEventMode is a 1-bit register that configures the pending event mode. When set to 0 (CYCLE), and when register mode is set to PENDING, the pending event is generated on each cycle when the counter is greater than zero.When set to 1 (STOP) the pending event is generated on each stop event.
                    }
                }
            }
            register ccf_Probe_T_sip7_main_TransactionStatProfiler_PreScaler @0x78 {
                bytes 4;
                field PRESCALER @'h0 {
                    bits 8;
                    access rw;
                    hard_reset 'h0;
                    doc {
                        8Register Prescaler is an-bit pre-scaling register that accepts any pre-scaling value between 1 (default) and 256. If set to 0, pre-scaling is disabled. If set to any other supported value "n", the threshold counter value is divided by (n + 1).
                    }
                }
            }
            register ccf_Probe_T_sip7_main_TransactionStatProfiler_Reserved_22 @0x7C {
                bytes 4;
                field ccf_Probe_T_sip7_main_TransactionStatProfiler_Reserved_22 {
                    bits 32;
                    access rw;
                    hard_reset 'h0;
                }
            }
        }
        block ecf_ccf_axi_cdma0_ccf_axi_I_main_TransactionStatFilter @0xDD000 {
            bytes 4;
            register cdma0_ccf_axi_I_main_TransactionStatFilter_Id_CoreId @0x0 {
                bytes 4;
                field CORETYPEID @'h0 {
                    bits 8;
                    access ro;
                    hard_reset 'h9;
                    doc {
                        Field identifying the type of IP.
                    }
                }
                field CORECHECKSUM @'h8 {
                    bits 24;
                    access ro;
                    hard_reset 'h5b728f;
                    doc {
                        Field containing a checksum of the parameters of the IP.
                    }
                }
            }
            register cdma0_ccf_axi_I_main_TransactionStatFilter_Id_RevisionId @0x4 {
                bytes 4;
                field USERID @'h0 {
                    bits 8;
                    access ro;
                    hard_reset 'h0;
                    doc {
                        Field containing a user defined value, not used anywhere inside the IP itself.
                    }
                }
                field FLEXNOCID @'h8 {
                    bits 24;
                    access ro;
                    hard_reset 'h84f8c6;
                    doc {
                        Field containing the build revision of the software used to generate the IP HDL code.
                    }
                }
            }
            register cdma0_ccf_axi_I_main_TransactionStatFilter_Mode @0x8 {
                bytes 4;
                field MODE @'h0 {
                    access rw;
                    hard_reset 'h0;
                    doc {
                        Register Mode is a 1-bit register that sets the filtering mode as follows: handshake Mode = 0 or latency Mode = 1.
                    }
                }
            }
            register cdma0_ccf_axi_I_main_TransactionStatFilter_AddrBase_Low @0xC {
                bytes 4;
                field ADDRBASE_LOW @'h0 {
                    bits 30;
                    access rw;
                    hard_reset 'h0;
                    doc {
                        Address base LSB register.
                    }
                }
            }
            register cdma0_ccf_axi_I_main_TransactionStatFilter_Reserved_00 @0x10 {
                bytes 4;
                field cdma0_ccf_axi_I_main_TransactionStatFilter_Reserved_00 {
                    bits 32;
                    access rw;
                    hard_reset 'h0;
                }
            }
            register cdma0_ccf_axi_I_main_TransactionStatFilter_AddrWindowSize @0x14 {
                bytes 4;
                field ADDRWINDOWSIZE @'h0 {
                    bits 5;
                    access rw;
                    hard_reset 'h0;
                    doc {
                        Register AddrWindowSize contains the encoded address mask used to filter packets: the effective Mask value is equal to ~(2**AddrWindowSize - 1). A packet is a candidate when ReqInfo.Addr & AddrMask = AddrBase & AddrMask.
                    }
                }
            }
            register cdma0_ccf_axi_I_main_TransactionStatFilter_Reserved_01 @0x18 {
                bytes 4;
                field cdma0_ccf_axi_I_main_TransactionStatFilter_Reserved_01 {
                    bits 32;
                    access rw;
                    hard_reset 'h0;
                }
            }
            register cdma0_ccf_axi_I_main_TransactionStatFilter_Reserved_02 @0x1C {
                bytes 4;
                field cdma0_ccf_axi_I_main_TransactionStatFilter_Reserved_02 {
                    bits 32;
                    access rw;
                    hard_reset 'h0;
                }
            }
            register cdma0_ccf_axi_I_main_TransactionStatFilter_Opcode @0x20 {
                bytes 4;
                field RDEN @'h0 {
                    access rw;
                    hard_reset 'h0;
                    doc {
                        When set to 1, selects RD requests.
                    }
                }
                field WREN @'h1 {
                    access rw;
                    hard_reset 'h0;
                    doc {
                        When set to 1, selects WR requests.
                    }
                }
                doc {
                    This register selects candidate packets based on packet opcodes. (0 disables the filter):
	This register selects candidate packets based on packet opcodes. (0 disables the filter):
	
                }
            }
            register cdma0_ccf_axi_I_main_TransactionStatFilter_UserBase @0x24 {
                bytes 4;
                field USERBASE @'h0 {
                    bits 27;
                    access rw;
                    hard_reset 'h0;
                    doc {
                        This register contains the User base used to filter requests.
                    }
                }
            }
            register cdma0_ccf_axi_I_main_TransactionStatFilter_UserMask @0x28 {
                bytes 4;
                field USERMASK @'h0 {
                    bits 27;
                    access rw;
                    hard_reset 'h0;
                    doc {
                        This register contains the User mask used to filter requests.
                    }
                }
            }
            register cdma0_ccf_axi_I_main_TransactionStatFilter_Reserved_03 @0x2C {
                bytes 4;
                field cdma0_ccf_axi_I_main_TransactionStatFilter_Reserved_03 {
                    bits 32;
                    access rw;
                    hard_reset 'h0;
                }
            }
            register cdma0_ccf_axi_I_main_TransactionStatFilter_Reserved_04 @0x30 {
                bytes 4;
                field cdma0_ccf_axi_I_main_TransactionStatFilter_Reserved_04 {
                    bits 32;
                    access rw;
                    hard_reset 'h0;
                }
            }
            register cdma0_ccf_axi_I_main_TransactionStatFilter_Reserved_05 @0x34 {
                bytes 4;
                field cdma0_ccf_axi_I_main_TransactionStatFilter_Reserved_05 {
                    bits 32;
                    access rw;
                    hard_reset 'h0;
                }
            }
            register cdma0_ccf_axi_I_main_TransactionStatFilter_Reserved_06 @0x38 {
                bytes 4;
                field cdma0_ccf_axi_I_main_TransactionStatFilter_Reserved_06 {
                    bits 32;
                    access rw;
                    hard_reset 'h0;
                }
            }
            register cdma0_ccf_axi_I_main_TransactionStatFilter_Reserved_07 @0x3C {
                bytes 4;
                field cdma0_ccf_axi_I_main_TransactionStatFilter_Reserved_07 {
                    bits 32;
                    access rw;
                    hard_reset 'h0;
                }
            }
            register cdma0_ccf_axi_I_main_TransactionStatFilter_Reserved_08 @0x40 {
                bytes 4;
                field cdma0_ccf_axi_I_main_TransactionStatFilter_Reserved_08 {
                    bits 32;
                    access rw;
                    hard_reset 'h0;
                }
            }
            register cdma0_ccf_axi_I_main_TransactionStatFilter_Reserved_09 @0x44 {
                bytes 4;
                field cdma0_ccf_axi_I_main_TransactionStatFilter_Reserved_09 {
                    bits 32;
                    access rw;
                    hard_reset 'h0;
                }
            }
            register cdma0_ccf_axi_I_main_TransactionStatFilter_Reserved_10 @0x48 {
                bytes 4;
                field cdma0_ccf_axi_I_main_TransactionStatFilter_Reserved_10 {
                    bits 32;
                    access rw;
                    hard_reset 'h0;
                }
            }
            register cdma0_ccf_axi_I_main_TransactionStatFilter_Reserved_11 @0x4C {
                bytes 4;
                field cdma0_ccf_axi_I_main_TransactionStatFilter_Reserved_11 {
                    bits 32;
                    access rw;
                    hard_reset 'h0;
                }
            }
            register cdma0_ccf_axi_I_main_TransactionStatFilter_Reserved_12 @0x50 {
                bytes 4;
                field cdma0_ccf_axi_I_main_TransactionStatFilter_Reserved_12 {
                    bits 32;
                    access rw;
                    hard_reset 'h0;
                }
            }
            register cdma0_ccf_axi_I_main_TransactionStatFilter_Reserved_13 @0x54 {
                bytes 4;
                field cdma0_ccf_axi_I_main_TransactionStatFilter_Reserved_13 {
                    bits 32;
                    access rw;
                    hard_reset 'h0;
                }
            }
            register cdma0_ccf_axi_I_main_TransactionStatFilter_Reserved_14 @0x58 {
                bytes 4;
                field cdma0_ccf_axi_I_main_TransactionStatFilter_Reserved_14 {
                    bits 32;
                    access rw;
                    hard_reset 'h0;
                }
            }
            register cdma0_ccf_axi_I_main_TransactionStatFilter_Reserved_15 @0x5C {
                bytes 4;
                field cdma0_ccf_axi_I_main_TransactionStatFilter_Reserved_15 {
                    bits 32;
                    access rw;
                    hard_reset 'h0;
                }
            }
            register cdma0_ccf_axi_I_main_TransactionStatFilter_Reserved_16 @0x60 {
                bytes 4;
                field cdma0_ccf_axi_I_main_TransactionStatFilter_Reserved_16 {
                    bits 32;
                    access rw;
                    hard_reset 'h0;
                }
            }
            register cdma0_ccf_axi_I_main_TransactionStatFilter_Reserved_17 @0x64 {
                bytes 4;
                field cdma0_ccf_axi_I_main_TransactionStatFilter_Reserved_17 {
                    bits 32;
                    access rw;
                    hard_reset 'h0;
                }
            }
            register cdma0_ccf_axi_I_main_TransactionStatFilter_Reserved_18 @0x68 {
                bytes 4;
                field cdma0_ccf_axi_I_main_TransactionStatFilter_Reserved_18 {
                    bits 32;
                    access rw;
                    hard_reset 'h0;
                }
            }
            register cdma0_ccf_axi_I_main_TransactionStatFilter_Reserved_19 @0x6C {
                bytes 4;
                field cdma0_ccf_axi_I_main_TransactionStatFilter_Reserved_19 {
                    bits 32;
                    access rw;
                    hard_reset 'h0;
                }
            }
            register cdma0_ccf_axi_I_main_TransactionStatFilter_Reserved_20 @0x70 {
                bytes 4;
                field cdma0_ccf_axi_I_main_TransactionStatFilter_Reserved_20 {
                    bits 32;
                    access rw;
                    hard_reset 'h0;
                }
            }
            register cdma0_ccf_axi_I_main_TransactionStatFilter_Reserved_21 @0x74 {
                bytes 4;
                field cdma0_ccf_axi_I_main_TransactionStatFilter_Reserved_21 {
                    bits 32;
                    access rw;
                    hard_reset 'h0;
                }
            }
            register cdma0_ccf_axi_I_main_TransactionStatFilter_Reserved_22 @0x78 {
                bytes 4;
                field cdma0_ccf_axi_I_main_TransactionStatFilter_Reserved_22 {
                    bits 32;
                    access rw;
                    hard_reset 'h0;
                }
            }
            register cdma0_ccf_axi_I_main_TransactionStatFilter_Reserved_23 @0x7C {
                bytes 4;
                field cdma0_ccf_axi_I_main_TransactionStatFilter_Reserved_23 {
                    bits 32;
                    access rw;
                    hard_reset 'h0;
                }
            }
        }
        block ecf_ccf_axi_cdma1_ccf_axi_I_main_TransactionStatFilter @0xDD080 {
            bytes 4;
            register cdma1_ccf_axi_I_main_TransactionStatFilter_Id_CoreId @0x0 {
                bytes 4;
                field CORETYPEID @'h0 {
                    bits 8;
                    access ro;
                    hard_reset 'h9;
                    doc {
                        Field identifying the type of IP.
                    }
                }
                field CORECHECKSUM @'h8 {
                    bits 24;
                    access ro;
                    hard_reset 'hdc35f0;
                    doc {
                        Field containing a checksum of the parameters of the IP.
                    }
                }
            }
            register cdma1_ccf_axi_I_main_TransactionStatFilter_Id_RevisionId @0x4 {
                bytes 4;
                field USERID @'h0 {
                    bits 8;
                    access ro;
                    hard_reset 'h0;
                    doc {
                        Field containing a user defined value, not used anywhere inside the IP itself.
                    }
                }
                field FLEXNOCID @'h8 {
                    bits 24;
                    access ro;
                    hard_reset 'h84f8c6;
                    doc {
                        Field containing the build revision of the software used to generate the IP HDL code.
                    }
                }
            }
            register cdma1_ccf_axi_I_main_TransactionStatFilter_Mode @0x8 {
                bytes 4;
                field MODE @'h0 {
                    access rw;
                    hard_reset 'h0;
                    doc {
                        Register Mode is a 1-bit register that sets the filtering mode as follows: handshake Mode = 0 or latency Mode = 1.
                    }
                }
            }
            register cdma1_ccf_axi_I_main_TransactionStatFilter_AddrBase_Low @0xC {
                bytes 4;
                field ADDRBASE_LOW @'h0 {
                    bits 30;
                    access rw;
                    hard_reset 'h0;
                    doc {
                        Address base LSB register.
                    }
                }
            }
            register cdma1_ccf_axi_I_main_TransactionStatFilter_Reserved_00 @0x10 {
                bytes 4;
                field cdma1_ccf_axi_I_main_TransactionStatFilter_Reserved_00 {
                    bits 32;
                    access rw;
                    hard_reset 'h0;
                }
            }
            register cdma1_ccf_axi_I_main_TransactionStatFilter_AddrWindowSize @0x14 {
                bytes 4;
                field ADDRWINDOWSIZE @'h0 {
                    bits 5;
                    access rw;
                    hard_reset 'h0;
                    doc {
                        Register AddrWindowSize contains the encoded address mask used to filter packets: the effective Mask value is equal to ~(2**AddrWindowSize - 1). A packet is a candidate when ReqInfo.Addr & AddrMask = AddrBase & AddrMask.
                    }
                }
            }
            register cdma1_ccf_axi_I_main_TransactionStatFilter_Reserved_01 @0x18 {
                bytes 4;
                field cdma1_ccf_axi_I_main_TransactionStatFilter_Reserved_01 {
                    bits 32;
                    access rw;
                    hard_reset 'h0;
                }
            }
            register cdma1_ccf_axi_I_main_TransactionStatFilter_Reserved_02 @0x1C {
                bytes 4;
                field cdma1_ccf_axi_I_main_TransactionStatFilter_Reserved_02 {
                    bits 32;
                    access rw;
                    hard_reset 'h0;
                }
            }
            register cdma1_ccf_axi_I_main_TransactionStatFilter_Opcode @0x20 {
                bytes 4;
                field RDEN @'h0 {
                    access rw;
                    hard_reset 'h0;
                    doc {
                        When set to 1, selects RD requests.
                    }
                }
                field WREN @'h1 {
                    access rw;
                    hard_reset 'h0;
                    doc {
                        When set to 1, selects WR requests.
                    }
                }
                doc {
                    This register selects candidate packets based on packet opcodes. (0 disables the filter):
	This register selects candidate packets based on packet opcodes. (0 disables the filter):
	
                }
            }
            register cdma1_ccf_axi_I_main_TransactionStatFilter_UserBase @0x24 {
                bytes 4;
                field USERBASE @'h0 {
                    bits 27;
                    access rw;
                    hard_reset 'h0;
                    doc {
                        This register contains the User base used to filter requests.
                    }
                }
            }
            register cdma1_ccf_axi_I_main_TransactionStatFilter_UserMask @0x28 {
                bytes 4;
                field USERMASK @'h0 {
                    bits 27;
                    access rw;
                    hard_reset 'h0;
                    doc {
                        This register contains the User mask used to filter requests.
                    }
                }
            }
            register cdma1_ccf_axi_I_main_TransactionStatFilter_Reserved_03 @0x2C {
                bytes 4;
                field cdma1_ccf_axi_I_main_TransactionStatFilter_Reserved_03 {
                    bits 32;
                    access rw;
                    hard_reset 'h0;
                }
            }
            register cdma1_ccf_axi_I_main_TransactionStatFilter_Reserved_04 @0x30 {
                bytes 4;
                field cdma1_ccf_axi_I_main_TransactionStatFilter_Reserved_04 {
                    bits 32;
                    access rw;
                    hard_reset 'h0;
                }
            }
            register cdma1_ccf_axi_I_main_TransactionStatFilter_Reserved_05 @0x34 {
                bytes 4;
                field cdma1_ccf_axi_I_main_TransactionStatFilter_Reserved_05 {
                    bits 32;
                    access rw;
                    hard_reset 'h0;
                }
            }
            register cdma1_ccf_axi_I_main_TransactionStatFilter_Reserved_06 @0x38 {
                bytes 4;
                field cdma1_ccf_axi_I_main_TransactionStatFilter_Reserved_06 {
                    bits 32;
                    access rw;
                    hard_reset 'h0;
                }
            }
            register cdma1_ccf_axi_I_main_TransactionStatFilter_Reserved_07 @0x3C {
                bytes 4;
                field cdma1_ccf_axi_I_main_TransactionStatFilter_Reserved_07 {
                    bits 32;
                    access rw;
                    hard_reset 'h0;
                }
            }
            register cdma1_ccf_axi_I_main_TransactionStatFilter_Reserved_08 @0x40 {
                bytes 4;
                field cdma1_ccf_axi_I_main_TransactionStatFilter_Reserved_08 {
                    bits 32;
                    access rw;
                    hard_reset 'h0;
                }
            }
            register cdma1_ccf_axi_I_main_TransactionStatFilter_Reserved_09 @0x44 {
                bytes 4;
                field cdma1_ccf_axi_I_main_TransactionStatFilter_Reserved_09 {
                    bits 32;
                    access rw;
                    hard_reset 'h0;
                }
            }
            register cdma1_ccf_axi_I_main_TransactionStatFilter_Reserved_10 @0x48 {
                bytes 4;
                field cdma1_ccf_axi_I_main_TransactionStatFilter_Reserved_10 {
                    bits 32;
                    access rw;
                    hard_reset 'h0;
                }
            }
            register cdma1_ccf_axi_I_main_TransactionStatFilter_Reserved_11 @0x4C {
                bytes 4;
                field cdma1_ccf_axi_I_main_TransactionStatFilter_Reserved_11 {
                    bits 32;
                    access rw;
                    hard_reset 'h0;
                }
            }
            register cdma1_ccf_axi_I_main_TransactionStatFilter_Reserved_12 @0x50 {
                bytes 4;
                field cdma1_ccf_axi_I_main_TransactionStatFilter_Reserved_12 {
                    bits 32;
                    access rw;
                    hard_reset 'h0;
                }
            }
            register cdma1_ccf_axi_I_main_TransactionStatFilter_Reserved_13 @0x54 {
                bytes 4;
                field cdma1_ccf_axi_I_main_TransactionStatFilter_Reserved_13 {
                    bits 32;
                    access rw;
                    hard_reset 'h0;
                }
            }
            register cdma1_ccf_axi_I_main_TransactionStatFilter_Reserved_14 @0x58 {
                bytes 4;
                field cdma1_ccf_axi_I_main_TransactionStatFilter_Reserved_14 {
                    bits 32;
                    access rw;
                    hard_reset 'h0;
                }
            }
            register cdma1_ccf_axi_I_main_TransactionStatFilter_Reserved_15 @0x5C {
                bytes 4;
                field cdma1_ccf_axi_I_main_TransactionStatFilter_Reserved_15 {
                    bits 32;
                    access rw;
                    hard_reset 'h0;
                }
            }
            register cdma1_ccf_axi_I_main_TransactionStatFilter_Reserved_16 @0x60 {
                bytes 4;
                field cdma1_ccf_axi_I_main_TransactionStatFilter_Reserved_16 {
                    bits 32;
                    access rw;
                    hard_reset 'h0;
                }
            }
            register cdma1_ccf_axi_I_main_TransactionStatFilter_Reserved_17 @0x64 {
                bytes 4;
                field cdma1_ccf_axi_I_main_TransactionStatFilter_Reserved_17 {
                    bits 32;
                    access rw;
                    hard_reset 'h0;
                }
            }
            register cdma1_ccf_axi_I_main_TransactionStatFilter_Reserved_18 @0x68 {
                bytes 4;
                field cdma1_ccf_axi_I_main_TransactionStatFilter_Reserved_18 {
                    bits 32;
                    access rw;
                    hard_reset 'h0;
                }
            }
            register cdma1_ccf_axi_I_main_TransactionStatFilter_Reserved_19 @0x6C {
                bytes 4;
                field cdma1_ccf_axi_I_main_TransactionStatFilter_Reserved_19 {
                    bits 32;
                    access rw;
                    hard_reset 'h0;
                }
            }
            register cdma1_ccf_axi_I_main_TransactionStatFilter_Reserved_20 @0x70 {
                bytes 4;
                field cdma1_ccf_axi_I_main_TransactionStatFilter_Reserved_20 {
                    bits 32;
                    access rw;
                    hard_reset 'h0;
                }
            }
            register cdma1_ccf_axi_I_main_TransactionStatFilter_Reserved_21 @0x74 {
                bytes 4;
                field cdma1_ccf_axi_I_main_TransactionStatFilter_Reserved_21 {
                    bits 32;
                    access rw;
                    hard_reset 'h0;
                }
            }
            register cdma1_ccf_axi_I_main_TransactionStatFilter_Reserved_22 @0x78 {
                bytes 4;
                field cdma1_ccf_axi_I_main_TransactionStatFilter_Reserved_22 {
                    bits 32;
                    access rw;
                    hard_reset 'h0;
                }
            }
            register cdma1_ccf_axi_I_main_TransactionStatFilter_Reserved_23 @0x7C {
                bytes 4;
                field cdma1_ccf_axi_I_main_TransactionStatFilter_Reserved_23 {
                    bits 32;
                    access rw;
                    hard_reset 'h0;
                }
            }
        }
        block ecf_ccf_axi_ecf_ccf_axi_I_main_TransactionStatFilter @0xDD100 {
            bytes 4;
            register ecf_ccf_axi_I_main_TransactionStatFilter_Id_CoreId @0x0 {
                bytes 4;
                field CORETYPEID @'h0 {
                    bits 8;
                    access ro;
                    hard_reset 'h9;
                    doc {
                        Field identifying the type of IP.
                    }
                }
                field CORECHECKSUM @'h8 {
                    bits 24;
                    access ro;
                    hard_reset 'h580ff5;
                    doc {
                        Field containing a checksum of the parameters of the IP.
                    }
                }
            }
            register ecf_ccf_axi_I_main_TransactionStatFilter_Id_RevisionId @0x4 {
                bytes 4;
                field USERID @'h0 {
                    bits 8;
                    access ro;
                    hard_reset 'h0;
                    doc {
                        Field containing a user defined value, not used anywhere inside the IP itself.
                    }
                }
                field FLEXNOCID @'h8 {
                    bits 24;
                    access ro;
                    hard_reset 'h84f8c6;
                    doc {
                        Field containing the build revision of the software used to generate the IP HDL code.
                    }
                }
            }
            register ecf_ccf_axi_I_main_TransactionStatFilter_Mode @0x8 {
                bytes 4;
                field MODE @'h0 {
                    access rw;
                    hard_reset 'h0;
                    doc {
                        Register Mode is a 1-bit register that sets the filtering mode as follows: handshake Mode = 0 or latency Mode = 1.
                    }
                }
            }
            register ecf_ccf_axi_I_main_TransactionStatFilter_AddrBase_Low @0xC {
                bytes 4;
                field ADDRBASE_LOW @'h0 {
                    bits 30;
                    access rw;
                    hard_reset 'h0;
                    doc {
                        Address base LSB register.
                    }
                }
            }
            register ecf_ccf_axi_I_main_TransactionStatFilter_Reserved_00 @0x10 {
                bytes 4;
                field ecf_ccf_axi_I_main_TransactionStatFilter_Reserved_00 {
                    bits 32;
                    access rw;
                    hard_reset 'h0;
                }
            }
            register ecf_ccf_axi_I_main_TransactionStatFilter_AddrWindowSize @0x14 {
                bytes 4;
                field ADDRWINDOWSIZE @'h0 {
                    bits 5;
                    access rw;
                    hard_reset 'h0;
                    doc {
                        Register AddrWindowSize contains the encoded address mask used to filter packets: the effective Mask value is equal to ~(2**AddrWindowSize - 1). A packet is a candidate when ReqInfo.Addr & AddrMask = AddrBase & AddrMask.
                    }
                }
            }
            register ecf_ccf_axi_I_main_TransactionStatFilter_Reserved_01 @0x18 {
                bytes 4;
                field ecf_ccf_axi_I_main_TransactionStatFilter_Reserved_01 {
                    bits 32;
                    access rw;
                    hard_reset 'h0;
                }
            }
            register ecf_ccf_axi_I_main_TransactionStatFilter_Reserved_02 @0x1C {
                bytes 4;
                field ecf_ccf_axi_I_main_TransactionStatFilter_Reserved_02 {
                    bits 32;
                    access rw;
                    hard_reset 'h0;
                }
            }
            register ecf_ccf_axi_I_main_TransactionStatFilter_Opcode @0x20 {
                bytes 4;
                field RDEN @'h0 {
                    access rw;
                    hard_reset 'h0;
                    doc {
                        When set to 1, selects RD requests.
                    }
                }
                field WREN @'h1 {
                    access rw;
                    hard_reset 'h0;
                    doc {
                        When set to 1, selects WR requests.
                    }
                }
                doc {
                    This register selects candidate packets based on packet opcodes. (0 disables the filter):
	This register selects candidate packets based on packet opcodes. (0 disables the filter):
	
                }
            }
            register ecf_ccf_axi_I_main_TransactionStatFilter_UserBase @0x24 {
                bytes 4;
                field USERBASE @'h0 {
                    bits 27;
                    access rw;
                    hard_reset 'h0;
                    doc {
                        This register contains the User base used to filter requests.
                    }
                }
            }
            register ecf_ccf_axi_I_main_TransactionStatFilter_UserMask @0x28 {
                bytes 4;
                field USERMASK @'h0 {
                    bits 27;
                    access rw;
                    hard_reset 'h0;
                    doc {
                        This register contains the User mask used to filter requests.
                    }
                }
            }
            register ecf_ccf_axi_I_main_TransactionStatFilter_Reserved_03 @0x2C {
                bytes 4;
                field ecf_ccf_axi_I_main_TransactionStatFilter_Reserved_03 {
                    bits 32;
                    access rw;
                    hard_reset 'h0;
                }
            }
            register ecf_ccf_axi_I_main_TransactionStatFilter_Reserved_04 @0x30 {
                bytes 4;
                field ecf_ccf_axi_I_main_TransactionStatFilter_Reserved_04 {
                    bits 32;
                    access rw;
                    hard_reset 'h0;
                }
            }
            register ecf_ccf_axi_I_main_TransactionStatFilter_Reserved_05 @0x34 {
                bytes 4;
                field ecf_ccf_axi_I_main_TransactionStatFilter_Reserved_05 {
                    bits 32;
                    access rw;
                    hard_reset 'h0;
                }
            }
            register ecf_ccf_axi_I_main_TransactionStatFilter_Reserved_06 @0x38 {
                bytes 4;
                field ecf_ccf_axi_I_main_TransactionStatFilter_Reserved_06 {
                    bits 32;
                    access rw;
                    hard_reset 'h0;
                }
            }
            register ecf_ccf_axi_I_main_TransactionStatFilter_Reserved_07 @0x3C {
                bytes 4;
                field ecf_ccf_axi_I_main_TransactionStatFilter_Reserved_07 {
                    bits 32;
                    access rw;
                    hard_reset 'h0;
                }
            }
            register ecf_ccf_axi_I_main_TransactionStatFilter_Reserved_08 @0x40 {
                bytes 4;
                field ecf_ccf_axi_I_main_TransactionStatFilter_Reserved_08 {
                    bits 32;
                    access rw;
                    hard_reset 'h0;
                }
            }
            register ecf_ccf_axi_I_main_TransactionStatFilter_Reserved_09 @0x44 {
                bytes 4;
                field ecf_ccf_axi_I_main_TransactionStatFilter_Reserved_09 {
                    bits 32;
                    access rw;
                    hard_reset 'h0;
                }
            }
            register ecf_ccf_axi_I_main_TransactionStatFilter_Reserved_10 @0x48 {
                bytes 4;
                field ecf_ccf_axi_I_main_TransactionStatFilter_Reserved_10 {
                    bits 32;
                    access rw;
                    hard_reset 'h0;
                }
            }
            register ecf_ccf_axi_I_main_TransactionStatFilter_Reserved_11 @0x4C {
                bytes 4;
                field ecf_ccf_axi_I_main_TransactionStatFilter_Reserved_11 {
                    bits 32;
                    access rw;
                    hard_reset 'h0;
                }
            }
            register ecf_ccf_axi_I_main_TransactionStatFilter_Reserved_12 @0x50 {
                bytes 4;
                field ecf_ccf_axi_I_main_TransactionStatFilter_Reserved_12 {
                    bits 32;
                    access rw;
                    hard_reset 'h0;
                }
            }
            register ecf_ccf_axi_I_main_TransactionStatFilter_Reserved_13 @0x54 {
                bytes 4;
                field ecf_ccf_axi_I_main_TransactionStatFilter_Reserved_13 {
                    bits 32;
                    access rw;
                    hard_reset 'h0;
                }
            }
            register ecf_ccf_axi_I_main_TransactionStatFilter_Reserved_14 @0x58 {
                bytes 4;
                field ecf_ccf_axi_I_main_TransactionStatFilter_Reserved_14 {
                    bits 32;
                    access rw;
                    hard_reset 'h0;
                }
            }
            register ecf_ccf_axi_I_main_TransactionStatFilter_Reserved_15 @0x5C {
                bytes 4;
                field ecf_ccf_axi_I_main_TransactionStatFilter_Reserved_15 {
                    bits 32;
                    access rw;
                    hard_reset 'h0;
                }
            }
            register ecf_ccf_axi_I_main_TransactionStatFilter_Reserved_16 @0x60 {
                bytes 4;
                field ecf_ccf_axi_I_main_TransactionStatFilter_Reserved_16 {
                    bits 32;
                    access rw;
                    hard_reset 'h0;
                }
            }
            register ecf_ccf_axi_I_main_TransactionStatFilter_Reserved_17 @0x64 {
                bytes 4;
                field ecf_ccf_axi_I_main_TransactionStatFilter_Reserved_17 {
                    bits 32;
                    access rw;
                    hard_reset 'h0;
                }
            }
            register ecf_ccf_axi_I_main_TransactionStatFilter_Reserved_18 @0x68 {
                bytes 4;
                field ecf_ccf_axi_I_main_TransactionStatFilter_Reserved_18 {
                    bits 32;
                    access rw;
                    hard_reset 'h0;
                }
            }
            register ecf_ccf_axi_I_main_TransactionStatFilter_Reserved_19 @0x6C {
                bytes 4;
                field ecf_ccf_axi_I_main_TransactionStatFilter_Reserved_19 {
                    bits 32;
                    access rw;
                    hard_reset 'h0;
                }
            }
            register ecf_ccf_axi_I_main_TransactionStatFilter_Reserved_20 @0x70 {
                bytes 4;
                field ecf_ccf_axi_I_main_TransactionStatFilter_Reserved_20 {
                    bits 32;
                    access rw;
                    hard_reset 'h0;
                }
            }
            register ecf_ccf_axi_I_main_TransactionStatFilter_Reserved_21 @0x74 {
                bytes 4;
                field ecf_ccf_axi_I_main_TransactionStatFilter_Reserved_21 {
                    bits 32;
                    access rw;
                    hard_reset 'h0;
                }
            }
            register ecf_ccf_axi_I_main_TransactionStatFilter_Reserved_22 @0x78 {
                bytes 4;
                field ecf_ccf_axi_I_main_TransactionStatFilter_Reserved_22 {
                    bits 32;
                    access rw;
                    hard_reset 'h0;
                }
            }
            register ecf_ccf_axi_I_main_TransactionStatFilter_Reserved_23 @0x7C {
                bytes 4;
                field ecf_ccf_axi_I_main_TransactionStatFilter_Reserved_23 {
                    bits 32;
                    access rw;
                    hard_reset 'h0;
                }
            }
        }
        block ecf_ccf_axi_jtag_ccf_axi_I_main_TransactionStatFilter @0xDD180 {
            bytes 4;
            register jtag_ccf_axi_I_main_TransactionStatFilter_Id_CoreId @0x0 {
                bytes 4;
                field CORETYPEID @'h0 {
                    bits 8;
                    access ro;
                    hard_reset 'h9;
                    doc {
                        Field identifying the type of IP.
                    }
                }
                field CORECHECKSUM @'h8 {
                    bits 24;
                    access ro;
                    hard_reset 'hb16c1d;
                    doc {
                        Field containing a checksum of the parameters of the IP.
                    }
                }
            }
            register jtag_ccf_axi_I_main_TransactionStatFilter_Id_RevisionId @0x4 {
                bytes 4;
                field USERID @'h0 {
                    bits 8;
                    access ro;
                    hard_reset 'h0;
                    doc {
                        Field containing a user defined value, not used anywhere inside the IP itself.
                    }
                }
                field FLEXNOCID @'h8 {
                    bits 24;
                    access ro;
                    hard_reset 'h84f8c6;
                    doc {
                        Field containing the build revision of the software used to generate the IP HDL code.
                    }
                }
            }
            register jtag_ccf_axi_I_main_TransactionStatFilter_Mode @0x8 {
                bytes 4;
                field MODE @'h0 {
                    access rw;
                    hard_reset 'h0;
                    doc {
                        Register Mode is a 1-bit register that sets the filtering mode as follows: handshake Mode = 0 or latency Mode = 1.
                    }
                }
            }
            register jtag_ccf_axi_I_main_TransactionStatFilter_AddrBase_Low @0xC {
                bytes 4;
                field ADDRBASE_LOW @'h0 {
                    bits 30;
                    access rw;
                    hard_reset 'h0;
                    doc {
                        Address base LSB register.
                    }
                }
            }
            register jtag_ccf_axi_I_main_TransactionStatFilter_Reserved_00 @0x10 {
                bytes 4;
                field jtag_ccf_axi_I_main_TransactionStatFilter_Reserved_00 {
                    bits 32;
                    access rw;
                    hard_reset 'h0;
                }
            }
            register jtag_ccf_axi_I_main_TransactionStatFilter_AddrWindowSize @0x14 {
                bytes 4;
                field ADDRWINDOWSIZE @'h0 {
                    bits 5;
                    access rw;
                    hard_reset 'h0;
                    doc {
                        Register AddrWindowSize contains the encoded address mask used to filter packets: the effective Mask value is equal to ~(2**AddrWindowSize - 1). A packet is a candidate when ReqInfo.Addr & AddrMask = AddrBase & AddrMask.
                    }
                }
            }
            register jtag_ccf_axi_I_main_TransactionStatFilter_Reserved_01 @0x18 {
                bytes 4;
                field jtag_ccf_axi_I_main_TransactionStatFilter_Reserved_01 {
                    bits 32;
                    access rw;
                    hard_reset 'h0;
                }
            }
            register jtag_ccf_axi_I_main_TransactionStatFilter_Reserved_02 @0x1C {
                bytes 4;
                field jtag_ccf_axi_I_main_TransactionStatFilter_Reserved_02 {
                    bits 32;
                    access rw;
                    hard_reset 'h0;
                }
            }
            register jtag_ccf_axi_I_main_TransactionStatFilter_Opcode @0x20 {
                bytes 4;
                field RDEN @'h0 {
                    access rw;
                    hard_reset 'h0;
                    doc {
                        When set to 1, selects RD requests.
                    }
                }
                field WREN @'h1 {
                    access rw;
                    hard_reset 'h0;
                    doc {
                        When set to 1, selects WR requests.
                    }
                }
                doc {
                    This register selects candidate packets based on packet opcodes. (0 disables the filter):
	This register selects candidate packets based on packet opcodes. (0 disables the filter):
	
                }
            }
            register jtag_ccf_axi_I_main_TransactionStatFilter_UserBase @0x24 {
                bytes 4;
                field USERBASE @'h0 {
                    bits 27;
                    access rw;
                    hard_reset 'h0;
                    doc {
                        This register contains the User base used to filter requests.
                    }
                }
            }
            register jtag_ccf_axi_I_main_TransactionStatFilter_UserMask @0x28 {
                bytes 4;
                field USERMASK @'h0 {
                    bits 27;
                    access rw;
                    hard_reset 'h0;
                    doc {
                        This register contains the User mask used to filter requests.
                    }
                }
            }
            register jtag_ccf_axi_I_main_TransactionStatFilter_Reserved_03 @0x2C {
                bytes 4;
                field jtag_ccf_axi_I_main_TransactionStatFilter_Reserved_03 {
                    bits 32;
                    access rw;
                    hard_reset 'h0;
                }
            }
            register jtag_ccf_axi_I_main_TransactionStatFilter_Reserved_04 @0x30 {
                bytes 4;
                field jtag_ccf_axi_I_main_TransactionStatFilter_Reserved_04 {
                    bits 32;
                    access rw;
                    hard_reset 'h0;
                }
            }
            register jtag_ccf_axi_I_main_TransactionStatFilter_Reserved_05 @0x34 {
                bytes 4;
                field jtag_ccf_axi_I_main_TransactionStatFilter_Reserved_05 {
                    bits 32;
                    access rw;
                    hard_reset 'h0;
                }
            }
            register jtag_ccf_axi_I_main_TransactionStatFilter_Reserved_06 @0x38 {
                bytes 4;
                field jtag_ccf_axi_I_main_TransactionStatFilter_Reserved_06 {
                    bits 32;
                    access rw;
                    hard_reset 'h0;
                }
            }
            register jtag_ccf_axi_I_main_TransactionStatFilter_Reserved_07 @0x3C {
                bytes 4;
                field jtag_ccf_axi_I_main_TransactionStatFilter_Reserved_07 {
                    bits 32;
                    access rw;
                    hard_reset 'h0;
                }
            }
            register jtag_ccf_axi_I_main_TransactionStatFilter_Reserved_08 @0x40 {
                bytes 4;
                field jtag_ccf_axi_I_main_TransactionStatFilter_Reserved_08 {
                    bits 32;
                    access rw;
                    hard_reset 'h0;
                }
            }
            register jtag_ccf_axi_I_main_TransactionStatFilter_Reserved_09 @0x44 {
                bytes 4;
                field jtag_ccf_axi_I_main_TransactionStatFilter_Reserved_09 {
                    bits 32;
                    access rw;
                    hard_reset 'h0;
                }
            }
            register jtag_ccf_axi_I_main_TransactionStatFilter_Reserved_10 @0x48 {
                bytes 4;
                field jtag_ccf_axi_I_main_TransactionStatFilter_Reserved_10 {
                    bits 32;
                    access rw;
                    hard_reset 'h0;
                }
            }
            register jtag_ccf_axi_I_main_TransactionStatFilter_Reserved_11 @0x4C {
                bytes 4;
                field jtag_ccf_axi_I_main_TransactionStatFilter_Reserved_11 {
                    bits 32;
                    access rw;
                    hard_reset 'h0;
                }
            }
            register jtag_ccf_axi_I_main_TransactionStatFilter_Reserved_12 @0x50 {
                bytes 4;
                field jtag_ccf_axi_I_main_TransactionStatFilter_Reserved_12 {
                    bits 32;
                    access rw;
                    hard_reset 'h0;
                }
            }
            register jtag_ccf_axi_I_main_TransactionStatFilter_Reserved_13 @0x54 {
                bytes 4;
                field jtag_ccf_axi_I_main_TransactionStatFilter_Reserved_13 {
                    bits 32;
                    access rw;
                    hard_reset 'h0;
                }
            }
            register jtag_ccf_axi_I_main_TransactionStatFilter_Reserved_14 @0x58 {
                bytes 4;
                field jtag_ccf_axi_I_main_TransactionStatFilter_Reserved_14 {
                    bits 32;
                    access rw;
                    hard_reset 'h0;
                }
            }
            register jtag_ccf_axi_I_main_TransactionStatFilter_Reserved_15 @0x5C {
                bytes 4;
                field jtag_ccf_axi_I_main_TransactionStatFilter_Reserved_15 {
                    bits 32;
                    access rw;
                    hard_reset 'h0;
                }
            }
            register jtag_ccf_axi_I_main_TransactionStatFilter_Reserved_16 @0x60 {
                bytes 4;
                field jtag_ccf_axi_I_main_TransactionStatFilter_Reserved_16 {
                    bits 32;
                    access rw;
                    hard_reset 'h0;
                }
            }
            register jtag_ccf_axi_I_main_TransactionStatFilter_Reserved_17 @0x64 {
                bytes 4;
                field jtag_ccf_axi_I_main_TransactionStatFilter_Reserved_17 {
                    bits 32;
                    access rw;
                    hard_reset 'h0;
                }
            }
            register jtag_ccf_axi_I_main_TransactionStatFilter_Reserved_18 @0x68 {
                bytes 4;
                field jtag_ccf_axi_I_main_TransactionStatFilter_Reserved_18 {
                    bits 32;
                    access rw;
                    hard_reset 'h0;
                }
            }
            register jtag_ccf_axi_I_main_TransactionStatFilter_Reserved_19 @0x6C {
                bytes 4;
                field jtag_ccf_axi_I_main_TransactionStatFilter_Reserved_19 {
                    bits 32;
                    access rw;
                    hard_reset 'h0;
                }
            }
            register jtag_ccf_axi_I_main_TransactionStatFilter_Reserved_20 @0x70 {
                bytes 4;
                field jtag_ccf_axi_I_main_TransactionStatFilter_Reserved_20 {
                    bits 32;
                    access rw;
                    hard_reset 'h0;
                }
            }
            register jtag_ccf_axi_I_main_TransactionStatFilter_Reserved_21 @0x74 {
                bytes 4;
                field jtag_ccf_axi_I_main_TransactionStatFilter_Reserved_21 {
                    bits 32;
                    access rw;
                    hard_reset 'h0;
                }
            }
            register jtag_ccf_axi_I_main_TransactionStatFilter_Reserved_22 @0x78 {
                bytes 4;
                field jtag_ccf_axi_I_main_TransactionStatFilter_Reserved_22 {
                    bits 32;
                    access rw;
                    hard_reset 'h0;
                }
            }
            register jtag_ccf_axi_I_main_TransactionStatFilter_Reserved_23 @0x7C {
                bytes 4;
                field jtag_ccf_axi_I_main_TransactionStatFilter_Reserved_23 {
                    bits 32;
                    access rw;
                    hard_reset 'h0;
                }
            }
        }
        block ecf_ccf_axi_sip0_ccf_axi_I_main_TransactionStatFilter @0xDD200 {
            bytes 4;
            register sip0_ccf_axi_I_main_TransactionStatFilter_Id_CoreId @0x0 {
                bytes 4;
                field CORETYPEID @'h0 {
                    bits 8;
                    access ro;
                    hard_reset 'h9;
                    doc {
                        Field identifying the type of IP.
                    }
                }
                field CORECHECKSUM @'h8 {
                    bits 24;
                    access ro;
                    hard_reset 'h84b883;
                    doc {
                        Field containing a checksum of the parameters of the IP.
                    }
                }
            }
            register sip0_ccf_axi_I_main_TransactionStatFilter_Id_RevisionId @0x4 {
                bytes 4;
                field USERID @'h0 {
                    bits 8;
                    access ro;
                    hard_reset 'h0;
                    doc {
                        Field containing a user defined value, not used anywhere inside the IP itself.
                    }
                }
                field FLEXNOCID @'h8 {
                    bits 24;
                    access ro;
                    hard_reset 'h84f8c6;
                    doc {
                        Field containing the build revision of the software used to generate the IP HDL code.
                    }
                }
            }
            register sip0_ccf_axi_I_main_TransactionStatFilter_Mode @0x8 {
                bytes 4;
                field MODE @'h0 {
                    access rw;
                    hard_reset 'h0;
                    doc {
                        Register Mode is a 1-bit register that sets the filtering mode as follows: handshake Mode = 0 or latency Mode = 1.
                    }
                }
            }
            register sip0_ccf_axi_I_main_TransactionStatFilter_AddrBase_Low @0xC {
                bytes 4;
                field ADDRBASE_LOW @'h0 {
                    bits 30;
                    access rw;
                    hard_reset 'h0;
                    doc {
                        Address base LSB register.
                    }
                }
            }
            register sip0_ccf_axi_I_main_TransactionStatFilter_Reserved_00 @0x10 {
                bytes 4;
                field sip0_ccf_axi_I_main_TransactionStatFilter_Reserved_00 {
                    bits 32;
                    access rw;
                    hard_reset 'h0;
                }
            }
            register sip0_ccf_axi_I_main_TransactionStatFilter_AddrWindowSize @0x14 {
                bytes 4;
                field ADDRWINDOWSIZE @'h0 {
                    bits 5;
                    access rw;
                    hard_reset 'h0;
                    doc {
                        Register AddrWindowSize contains the encoded address mask used to filter packets: the effective Mask value is equal to ~(2**AddrWindowSize - 1). A packet is a candidate when ReqInfo.Addr & AddrMask = AddrBase & AddrMask.
                    }
                }
            }
            register sip0_ccf_axi_I_main_TransactionStatFilter_Reserved_01 @0x18 {
                bytes 4;
                field sip0_ccf_axi_I_main_TransactionStatFilter_Reserved_01 {
                    bits 32;
                    access rw;
                    hard_reset 'h0;
                }
            }
            register sip0_ccf_axi_I_main_TransactionStatFilter_Reserved_02 @0x1C {
                bytes 4;
                field sip0_ccf_axi_I_main_TransactionStatFilter_Reserved_02 {
                    bits 32;
                    access rw;
                    hard_reset 'h0;
                }
            }
            register sip0_ccf_axi_I_main_TransactionStatFilter_Opcode @0x20 {
                bytes 4;
                field RDEN @'h0 {
                    access rw;
                    hard_reset 'h0;
                    doc {
                        When set to 1, selects RD requests.
                    }
                }
                field WREN @'h1 {
                    access rw;
                    hard_reset 'h0;
                    doc {
                        When set to 1, selects WR requests.
                    }
                }
                doc {
                    This register selects candidate packets based on packet opcodes. (0 disables the filter):
	This register selects candidate packets based on packet opcodes. (0 disables the filter):
	
                }
            }
            register sip0_ccf_axi_I_main_TransactionStatFilter_UserBase @0x24 {
                bytes 4;
                field USERBASE @'h0 {
                    bits 27;
                    access rw;
                    hard_reset 'h0;
                    doc {
                        This register contains the User base used to filter requests.
                    }
                }
            }
            register sip0_ccf_axi_I_main_TransactionStatFilter_UserMask @0x28 {
                bytes 4;
                field USERMASK @'h0 {
                    bits 27;
                    access rw;
                    hard_reset 'h0;
                    doc {
                        This register contains the User mask used to filter requests.
                    }
                }
            }
            register sip0_ccf_axi_I_main_TransactionStatFilter_Reserved_03 @0x2C {
                bytes 4;
                field sip0_ccf_axi_I_main_TransactionStatFilter_Reserved_03 {
                    bits 32;
                    access rw;
                    hard_reset 'h0;
                }
            }
            register sip0_ccf_axi_I_main_TransactionStatFilter_Reserved_04 @0x30 {
                bytes 4;
                field sip0_ccf_axi_I_main_TransactionStatFilter_Reserved_04 {
                    bits 32;
                    access rw;
                    hard_reset 'h0;
                }
            }
            register sip0_ccf_axi_I_main_TransactionStatFilter_Reserved_05 @0x34 {
                bytes 4;
                field sip0_ccf_axi_I_main_TransactionStatFilter_Reserved_05 {
                    bits 32;
                    access rw;
                    hard_reset 'h0;
                }
            }
            register sip0_ccf_axi_I_main_TransactionStatFilter_Reserved_06 @0x38 {
                bytes 4;
                field sip0_ccf_axi_I_main_TransactionStatFilter_Reserved_06 {
                    bits 32;
                    access rw;
                    hard_reset 'h0;
                }
            }
            register sip0_ccf_axi_I_main_TransactionStatFilter_Reserved_07 @0x3C {
                bytes 4;
                field sip0_ccf_axi_I_main_TransactionStatFilter_Reserved_07 {
                    bits 32;
                    access rw;
                    hard_reset 'h0;
                }
            }
            register sip0_ccf_axi_I_main_TransactionStatFilter_Reserved_08 @0x40 {
                bytes 4;
                field sip0_ccf_axi_I_main_TransactionStatFilter_Reserved_08 {
                    bits 32;
                    access rw;
                    hard_reset 'h0;
                }
            }
            register sip0_ccf_axi_I_main_TransactionStatFilter_Reserved_09 @0x44 {
                bytes 4;
                field sip0_ccf_axi_I_main_TransactionStatFilter_Reserved_09 {
                    bits 32;
                    access rw;
                    hard_reset 'h0;
                }
            }
            register sip0_ccf_axi_I_main_TransactionStatFilter_Reserved_10 @0x48 {
                bytes 4;
                field sip0_ccf_axi_I_main_TransactionStatFilter_Reserved_10 {
                    bits 32;
                    access rw;
                    hard_reset 'h0;
                }
            }
            register sip0_ccf_axi_I_main_TransactionStatFilter_Reserved_11 @0x4C {
                bytes 4;
                field sip0_ccf_axi_I_main_TransactionStatFilter_Reserved_11 {
                    bits 32;
                    access rw;
                    hard_reset 'h0;
                }
            }
            register sip0_ccf_axi_I_main_TransactionStatFilter_Reserved_12 @0x50 {
                bytes 4;
                field sip0_ccf_axi_I_main_TransactionStatFilter_Reserved_12 {
                    bits 32;
                    access rw;
                    hard_reset 'h0;
                }
            }
            register sip0_ccf_axi_I_main_TransactionStatFilter_Reserved_13 @0x54 {
                bytes 4;
                field sip0_ccf_axi_I_main_TransactionStatFilter_Reserved_13 {
                    bits 32;
                    access rw;
                    hard_reset 'h0;
                }
            }
            register sip0_ccf_axi_I_main_TransactionStatFilter_Reserved_14 @0x58 {
                bytes 4;
                field sip0_ccf_axi_I_main_TransactionStatFilter_Reserved_14 {
                    bits 32;
                    access rw;
                    hard_reset 'h0;
                }
            }
            register sip0_ccf_axi_I_main_TransactionStatFilter_Reserved_15 @0x5C {
                bytes 4;
                field sip0_ccf_axi_I_main_TransactionStatFilter_Reserved_15 {
                    bits 32;
                    access rw;
                    hard_reset 'h0;
                }
            }
            register sip0_ccf_axi_I_main_TransactionStatFilter_Reserved_16 @0x60 {
                bytes 4;
                field sip0_ccf_axi_I_main_TransactionStatFilter_Reserved_16 {
                    bits 32;
                    access rw;
                    hard_reset 'h0;
                }
            }
            register sip0_ccf_axi_I_main_TransactionStatFilter_Reserved_17 @0x64 {
                bytes 4;
                field sip0_ccf_axi_I_main_TransactionStatFilter_Reserved_17 {
                    bits 32;
                    access rw;
                    hard_reset 'h0;
                }
            }
            register sip0_ccf_axi_I_main_TransactionStatFilter_Reserved_18 @0x68 {
                bytes 4;
                field sip0_ccf_axi_I_main_TransactionStatFilter_Reserved_18 {
                    bits 32;
                    access rw;
                    hard_reset 'h0;
                }
            }
            register sip0_ccf_axi_I_main_TransactionStatFilter_Reserved_19 @0x6C {
                bytes 4;
                field sip0_ccf_axi_I_main_TransactionStatFilter_Reserved_19 {
                    bits 32;
                    access rw;
                    hard_reset 'h0;
                }
            }
            register sip0_ccf_axi_I_main_TransactionStatFilter_Reserved_20 @0x70 {
                bytes 4;
                field sip0_ccf_axi_I_main_TransactionStatFilter_Reserved_20 {
                    bits 32;
                    access rw;
                    hard_reset 'h0;
                }
            }
            register sip0_ccf_axi_I_main_TransactionStatFilter_Reserved_21 @0x74 {
                bytes 4;
                field sip0_ccf_axi_I_main_TransactionStatFilter_Reserved_21 {
                    bits 32;
                    access rw;
                    hard_reset 'h0;
                }
            }
            register sip0_ccf_axi_I_main_TransactionStatFilter_Reserved_22 @0x78 {
                bytes 4;
                field sip0_ccf_axi_I_main_TransactionStatFilter_Reserved_22 {
                    bits 32;
                    access rw;
                    hard_reset 'h0;
                }
            }
            register sip0_ccf_axi_I_main_TransactionStatFilter_Reserved_23 @0x7C {
                bytes 4;
                field sip0_ccf_axi_I_main_TransactionStatFilter_Reserved_23 {
                    bits 32;
                    access rw;
                    hard_reset 'h0;
                }
            }
        }
        block ecf_ccf_axi_sip1_ccf_axi_I_main_TransactionStatFilter @0xDD280 {
            bytes 4;
            register sip1_ccf_axi_I_main_TransactionStatFilter_Id_CoreId @0x0 {
                bytes 4;
                field CORETYPEID @'h0 {
                    bits 8;
                    access ro;
                    hard_reset 'h9;
                    doc {
                        Field identifying the type of IP.
                    }
                }
                field CORECHECKSUM @'h8 {
                    bits 24;
                    access ro;
                    hard_reset 'hca1f68;
                    doc {
                        Field containing a checksum of the parameters of the IP.
                    }
                }
            }
            register sip1_ccf_axi_I_main_TransactionStatFilter_Id_RevisionId @0x4 {
                bytes 4;
                field USERID @'h0 {
                    bits 8;
                    access ro;
                    hard_reset 'h0;
                    doc {
                        Field containing a user defined value, not used anywhere inside the IP itself.
                    }
                }
                field FLEXNOCID @'h8 {
                    bits 24;
                    access ro;
                    hard_reset 'h84f8c6;
                    doc {
                        Field containing the build revision of the software used to generate the IP HDL code.
                    }
                }
            }
            register sip1_ccf_axi_I_main_TransactionStatFilter_Mode @0x8 {
                bytes 4;
                field MODE @'h0 {
                    access rw;
                    hard_reset 'h0;
                    doc {
                        Register Mode is a 1-bit register that sets the filtering mode as follows: handshake Mode = 0 or latency Mode = 1.
                    }
                }
            }
            register sip1_ccf_axi_I_main_TransactionStatFilter_AddrBase_Low @0xC {
                bytes 4;
                field ADDRBASE_LOW @'h0 {
                    bits 30;
                    access rw;
                    hard_reset 'h0;
                    doc {
                        Address base LSB register.
                    }
                }
            }
            register sip1_ccf_axi_I_main_TransactionStatFilter_Reserved_00 @0x10 {
                bytes 4;
                field sip1_ccf_axi_I_main_TransactionStatFilter_Reserved_00 {
                    bits 32;
                    access rw;
                    hard_reset 'h0;
                }
            }
            register sip1_ccf_axi_I_main_TransactionStatFilter_AddrWindowSize @0x14 {
                bytes 4;
                field ADDRWINDOWSIZE @'h0 {
                    bits 5;
                    access rw;
                    hard_reset 'h0;
                    doc {
                        Register AddrWindowSize contains the encoded address mask used to filter packets: the effective Mask value is equal to ~(2**AddrWindowSize - 1). A packet is a candidate when ReqInfo.Addr & AddrMask = AddrBase & AddrMask.
                    }
                }
            }
            register sip1_ccf_axi_I_main_TransactionStatFilter_Reserved_01 @0x18 {
                bytes 4;
                field sip1_ccf_axi_I_main_TransactionStatFilter_Reserved_01 {
                    bits 32;
                    access rw;
                    hard_reset 'h0;
                }
            }
            register sip1_ccf_axi_I_main_TransactionStatFilter_Reserved_02 @0x1C {
                bytes 4;
                field sip1_ccf_axi_I_main_TransactionStatFilter_Reserved_02 {
                    bits 32;
                    access rw;
                    hard_reset 'h0;
                }
            }
            register sip1_ccf_axi_I_main_TransactionStatFilter_Opcode @0x20 {
                bytes 4;
                field RDEN @'h0 {
                    access rw;
                    hard_reset 'h0;
                    doc {
                        When set to 1, selects RD requests.
                    }
                }
                field WREN @'h1 {
                    access rw;
                    hard_reset 'h0;
                    doc {
                        When set to 1, selects WR requests.
                    }
                }
                doc {
                    This register selects candidate packets based on packet opcodes. (0 disables the filter):
	This register selects candidate packets based on packet opcodes. (0 disables the filter):
	
                }
            }
            register sip1_ccf_axi_I_main_TransactionStatFilter_UserBase @0x24 {
                bytes 4;
                field USERBASE @'h0 {
                    bits 27;
                    access rw;
                    hard_reset 'h0;
                    doc {
                        This register contains the User base used to filter requests.
                    }
                }
            }
            register sip1_ccf_axi_I_main_TransactionStatFilter_UserMask @0x28 {
                bytes 4;
                field USERMASK @'h0 {
                    bits 27;
                    access rw;
                    hard_reset 'h0;
                    doc {
                        This register contains the User mask used to filter requests.
                    }
                }
            }
            register sip1_ccf_axi_I_main_TransactionStatFilter_Reserved_03 @0x2C {
                bytes 4;
                field sip1_ccf_axi_I_main_TransactionStatFilter_Reserved_03 {
                    bits 32;
                    access rw;
                    hard_reset 'h0;
                }
            }
            register sip1_ccf_axi_I_main_TransactionStatFilter_Reserved_04 @0x30 {
                bytes 4;
                field sip1_ccf_axi_I_main_TransactionStatFilter_Reserved_04 {
                    bits 32;
                    access rw;
                    hard_reset 'h0;
                }
            }
            register sip1_ccf_axi_I_main_TransactionStatFilter_Reserved_05 @0x34 {
                bytes 4;
                field sip1_ccf_axi_I_main_TransactionStatFilter_Reserved_05 {
                    bits 32;
                    access rw;
                    hard_reset 'h0;
                }
            }
            register sip1_ccf_axi_I_main_TransactionStatFilter_Reserved_06 @0x38 {
                bytes 4;
                field sip1_ccf_axi_I_main_TransactionStatFilter_Reserved_06 {
                    bits 32;
                    access rw;
                    hard_reset 'h0;
                }
            }
            register sip1_ccf_axi_I_main_TransactionStatFilter_Reserved_07 @0x3C {
                bytes 4;
                field sip1_ccf_axi_I_main_TransactionStatFilter_Reserved_07 {
                    bits 32;
                    access rw;
                    hard_reset 'h0;
                }
            }
            register sip1_ccf_axi_I_main_TransactionStatFilter_Reserved_08 @0x40 {
                bytes 4;
                field sip1_ccf_axi_I_main_TransactionStatFilter_Reserved_08 {
                    bits 32;
                    access rw;
                    hard_reset 'h0;
                }
            }
            register sip1_ccf_axi_I_main_TransactionStatFilter_Reserved_09 @0x44 {
                bytes 4;
                field sip1_ccf_axi_I_main_TransactionStatFilter_Reserved_09 {
                    bits 32;
                    access rw;
                    hard_reset 'h0;
                }
            }
            register sip1_ccf_axi_I_main_TransactionStatFilter_Reserved_10 @0x48 {
                bytes 4;
                field sip1_ccf_axi_I_main_TransactionStatFilter_Reserved_10 {
                    bits 32;
                    access rw;
                    hard_reset 'h0;
                }
            }
            register sip1_ccf_axi_I_main_TransactionStatFilter_Reserved_11 @0x4C {
                bytes 4;
                field sip1_ccf_axi_I_main_TransactionStatFilter_Reserved_11 {
                    bits 32;
                    access rw;
                    hard_reset 'h0;
                }
            }
            register sip1_ccf_axi_I_main_TransactionStatFilter_Reserved_12 @0x50 {
                bytes 4;
                field sip1_ccf_axi_I_main_TransactionStatFilter_Reserved_12 {
                    bits 32;
                    access rw;
                    hard_reset 'h0;
                }
            }
            register sip1_ccf_axi_I_main_TransactionStatFilter_Reserved_13 @0x54 {
                bytes 4;
                field sip1_ccf_axi_I_main_TransactionStatFilter_Reserved_13 {
                    bits 32;
                    access rw;
                    hard_reset 'h0;
                }
            }
            register sip1_ccf_axi_I_main_TransactionStatFilter_Reserved_14 @0x58 {
                bytes 4;
                field sip1_ccf_axi_I_main_TransactionStatFilter_Reserved_14 {
                    bits 32;
                    access rw;
                    hard_reset 'h0;
                }
            }
            register sip1_ccf_axi_I_main_TransactionStatFilter_Reserved_15 @0x5C {
                bytes 4;
                field sip1_ccf_axi_I_main_TransactionStatFilter_Reserved_15 {
                    bits 32;
                    access rw;
                    hard_reset 'h0;
                }
            }
            register sip1_ccf_axi_I_main_TransactionStatFilter_Reserved_16 @0x60 {
                bytes 4;
                field sip1_ccf_axi_I_main_TransactionStatFilter_Reserved_16 {
                    bits 32;
                    access rw;
                    hard_reset 'h0;
                }
            }
            register sip1_ccf_axi_I_main_TransactionStatFilter_Reserved_17 @0x64 {
                bytes 4;
                field sip1_ccf_axi_I_main_TransactionStatFilter_Reserved_17 {
                    bits 32;
                    access rw;
                    hard_reset 'h0;
                }
            }
            register sip1_ccf_axi_I_main_TransactionStatFilter_Reserved_18 @0x68 {
                bytes 4;
                field sip1_ccf_axi_I_main_TransactionStatFilter_Reserved_18 {
                    bits 32;
                    access rw;
                    hard_reset 'h0;
                }
            }
            register sip1_ccf_axi_I_main_TransactionStatFilter_Reserved_19 @0x6C {
                bytes 4;
                field sip1_ccf_axi_I_main_TransactionStatFilter_Reserved_19 {
                    bits 32;
                    access rw;
                    hard_reset 'h0;
                }
            }
            register sip1_ccf_axi_I_main_TransactionStatFilter_Reserved_20 @0x70 {
                bytes 4;
                field sip1_ccf_axi_I_main_TransactionStatFilter_Reserved_20 {
                    bits 32;
                    access rw;
                    hard_reset 'h0;
                }
            }
            register sip1_ccf_axi_I_main_TransactionStatFilter_Reserved_21 @0x74 {
                bytes 4;
                field sip1_ccf_axi_I_main_TransactionStatFilter_Reserved_21 {
                    bits 32;
                    access rw;
                    hard_reset 'h0;
                }
            }
            register sip1_ccf_axi_I_main_TransactionStatFilter_Reserved_22 @0x78 {
                bytes 4;
                field sip1_ccf_axi_I_main_TransactionStatFilter_Reserved_22 {
                    bits 32;
                    access rw;
                    hard_reset 'h0;
                }
            }
            register sip1_ccf_axi_I_main_TransactionStatFilter_Reserved_23 @0x7C {
                bytes 4;
                field sip1_ccf_axi_I_main_TransactionStatFilter_Reserved_23 {
                    bits 32;
                    access rw;
                    hard_reset 'h0;
                }
            }
        }
        block ecf_ccf_axi_sip2_ccf_axi_I_main_TransactionStatFilter @0xDD300 {
            bytes 4;
            register sip2_ccf_axi_I_main_TransactionStatFilter_Id_CoreId @0x0 {
                bytes 4;
                field CORETYPEID @'h0 {
                    bits 8;
                    access ro;
                    hard_reset 'h9;
                    doc {
                        Field identifying the type of IP.
                    }
                }
                field CORECHECKSUM @'h8 {
                    bits 24;
                    access ro;
                    hard_reset 'he44de9;
                    doc {
                        Field containing a checksum of the parameters of the IP.
                    }
                }
            }
            register sip2_ccf_axi_I_main_TransactionStatFilter_Id_RevisionId @0x4 {
                bytes 4;
                field USERID @'h0 {
                    bits 8;
                    access ro;
                    hard_reset 'h0;
                    doc {
                        Field containing a user defined value, not used anywhere inside the IP itself.
                    }
                }
                field FLEXNOCID @'h8 {
                    bits 24;
                    access ro;
                    hard_reset 'h84f8c6;
                    doc {
                        Field containing the build revision of the software used to generate the IP HDL code.
                    }
                }
            }
            register sip2_ccf_axi_I_main_TransactionStatFilter_Mode @0x8 {
                bytes 4;
                field MODE @'h0 {
                    access rw;
                    hard_reset 'h0;
                    doc {
                        Register Mode is a 1-bit register that sets the filtering mode as follows: handshake Mode = 0 or latency Mode = 1.
                    }
                }
            }
            register sip2_ccf_axi_I_main_TransactionStatFilter_AddrBase_Low @0xC {
                bytes 4;
                field ADDRBASE_LOW @'h0 {
                    bits 30;
                    access rw;
                    hard_reset 'h0;
                    doc {
                        Address base LSB register.
                    }
                }
            }
            register sip2_ccf_axi_I_main_TransactionStatFilter_Reserved_00 @0x10 {
                bytes 4;
                field sip2_ccf_axi_I_main_TransactionStatFilter_Reserved_00 {
                    bits 32;
                    access rw;
                    hard_reset 'h0;
                }
            }
            register sip2_ccf_axi_I_main_TransactionStatFilter_AddrWindowSize @0x14 {
                bytes 4;
                field ADDRWINDOWSIZE @'h0 {
                    bits 5;
                    access rw;
                    hard_reset 'h0;
                    doc {
                        Register AddrWindowSize contains the encoded address mask used to filter packets: the effective Mask value is equal to ~(2**AddrWindowSize - 1). A packet is a candidate when ReqInfo.Addr & AddrMask = AddrBase & AddrMask.
                    }
                }
            }
            register sip2_ccf_axi_I_main_TransactionStatFilter_Reserved_01 @0x18 {
                bytes 4;
                field sip2_ccf_axi_I_main_TransactionStatFilter_Reserved_01 {
                    bits 32;
                    access rw;
                    hard_reset 'h0;
                }
            }
            register sip2_ccf_axi_I_main_TransactionStatFilter_Reserved_02 @0x1C {
                bytes 4;
                field sip2_ccf_axi_I_main_TransactionStatFilter_Reserved_02 {
                    bits 32;
                    access rw;
                    hard_reset 'h0;
                }
            }
            register sip2_ccf_axi_I_main_TransactionStatFilter_Opcode @0x20 {
                bytes 4;
                field RDEN @'h0 {
                    access rw;
                    hard_reset 'h0;
                    doc {
                        When set to 1, selects RD requests.
                    }
                }
                field WREN @'h1 {
                    access rw;
                    hard_reset 'h0;
                    doc {
                        When set to 1, selects WR requests.
                    }
                }
                doc {
                    This register selects candidate packets based on packet opcodes. (0 disables the filter):
	This register selects candidate packets based on packet opcodes. (0 disables the filter):
	
                }
            }
            register sip2_ccf_axi_I_main_TransactionStatFilter_UserBase @0x24 {
                bytes 4;
                field USERBASE @'h0 {
                    bits 27;
                    access rw;
                    hard_reset 'h0;
                    doc {
                        This register contains the User base used to filter requests.
                    }
                }
            }
            register sip2_ccf_axi_I_main_TransactionStatFilter_UserMask @0x28 {
                bytes 4;
                field USERMASK @'h0 {
                    bits 27;
                    access rw;
                    hard_reset 'h0;
                    doc {
                        This register contains the User mask used to filter requests.
                    }
                }
            }
            register sip2_ccf_axi_I_main_TransactionStatFilter_Reserved_03 @0x2C {
                bytes 4;
                field sip2_ccf_axi_I_main_TransactionStatFilter_Reserved_03 {
                    bits 32;
                    access rw;
                    hard_reset 'h0;
                }
            }
            register sip2_ccf_axi_I_main_TransactionStatFilter_Reserved_04 @0x30 {
                bytes 4;
                field sip2_ccf_axi_I_main_TransactionStatFilter_Reserved_04 {
                    bits 32;
                    access rw;
                    hard_reset 'h0;
                }
            }
            register sip2_ccf_axi_I_main_TransactionStatFilter_Reserved_05 @0x34 {
                bytes 4;
                field sip2_ccf_axi_I_main_TransactionStatFilter_Reserved_05 {
                    bits 32;
                    access rw;
                    hard_reset 'h0;
                }
            }
            register sip2_ccf_axi_I_main_TransactionStatFilter_Reserved_06 @0x38 {
                bytes 4;
                field sip2_ccf_axi_I_main_TransactionStatFilter_Reserved_06 {
                    bits 32;
                    access rw;
                    hard_reset 'h0;
                }
            }
            register sip2_ccf_axi_I_main_TransactionStatFilter_Reserved_07 @0x3C {
                bytes 4;
                field sip2_ccf_axi_I_main_TransactionStatFilter_Reserved_07 {
                    bits 32;
                    access rw;
                    hard_reset 'h0;
                }
            }
            register sip2_ccf_axi_I_main_TransactionStatFilter_Reserved_08 @0x40 {
                bytes 4;
                field sip2_ccf_axi_I_main_TransactionStatFilter_Reserved_08 {
                    bits 32;
                    access rw;
                    hard_reset 'h0;
                }
            }
            register sip2_ccf_axi_I_main_TransactionStatFilter_Reserved_09 @0x44 {
                bytes 4;
                field sip2_ccf_axi_I_main_TransactionStatFilter_Reserved_09 {
                    bits 32;
                    access rw;
                    hard_reset 'h0;
                }
            }
            register sip2_ccf_axi_I_main_TransactionStatFilter_Reserved_10 @0x48 {
                bytes 4;
                field sip2_ccf_axi_I_main_TransactionStatFilter_Reserved_10 {
                    bits 32;
                    access rw;
                    hard_reset 'h0;
                }
            }
            register sip2_ccf_axi_I_main_TransactionStatFilter_Reserved_11 @0x4C {
                bytes 4;
                field sip2_ccf_axi_I_main_TransactionStatFilter_Reserved_11 {
                    bits 32;
                    access rw;
                    hard_reset 'h0;
                }
            }
            register sip2_ccf_axi_I_main_TransactionStatFilter_Reserved_12 @0x50 {
                bytes 4;
                field sip2_ccf_axi_I_main_TransactionStatFilter_Reserved_12 {
                    bits 32;
                    access rw;
                    hard_reset 'h0;
                }
            }
            register sip2_ccf_axi_I_main_TransactionStatFilter_Reserved_13 @0x54 {
                bytes 4;
                field sip2_ccf_axi_I_main_TransactionStatFilter_Reserved_13 {
                    bits 32;
                    access rw;
                    hard_reset 'h0;
                }
            }
            register sip2_ccf_axi_I_main_TransactionStatFilter_Reserved_14 @0x58 {
                bytes 4;
                field sip2_ccf_axi_I_main_TransactionStatFilter_Reserved_14 {
                    bits 32;
                    access rw;
                    hard_reset 'h0;
                }
            }
            register sip2_ccf_axi_I_main_TransactionStatFilter_Reserved_15 @0x5C {
                bytes 4;
                field sip2_ccf_axi_I_main_TransactionStatFilter_Reserved_15 {
                    bits 32;
                    access rw;
                    hard_reset 'h0;
                }
            }
            register sip2_ccf_axi_I_main_TransactionStatFilter_Reserved_16 @0x60 {
                bytes 4;
                field sip2_ccf_axi_I_main_TransactionStatFilter_Reserved_16 {
                    bits 32;
                    access rw;
                    hard_reset 'h0;
                }
            }
            register sip2_ccf_axi_I_main_TransactionStatFilter_Reserved_17 @0x64 {
                bytes 4;
                field sip2_ccf_axi_I_main_TransactionStatFilter_Reserved_17 {
                    bits 32;
                    access rw;
                    hard_reset 'h0;
                }
            }
            register sip2_ccf_axi_I_main_TransactionStatFilter_Reserved_18 @0x68 {
                bytes 4;
                field sip2_ccf_axi_I_main_TransactionStatFilter_Reserved_18 {
                    bits 32;
                    access rw;
                    hard_reset 'h0;
                }
            }
            register sip2_ccf_axi_I_main_TransactionStatFilter_Reserved_19 @0x6C {
                bytes 4;
                field sip2_ccf_axi_I_main_TransactionStatFilter_Reserved_19 {
                    bits 32;
                    access rw;
                    hard_reset 'h0;
                }
            }
            register sip2_ccf_axi_I_main_TransactionStatFilter_Reserved_20 @0x70 {
                bytes 4;
                field sip2_ccf_axi_I_main_TransactionStatFilter_Reserved_20 {
                    bits 32;
                    access rw;
                    hard_reset 'h0;
                }
            }
            register sip2_ccf_axi_I_main_TransactionStatFilter_Reserved_21 @0x74 {
                bytes 4;
                field sip2_ccf_axi_I_main_TransactionStatFilter_Reserved_21 {
                    bits 32;
                    access rw;
                    hard_reset 'h0;
                }
            }
            register sip2_ccf_axi_I_main_TransactionStatFilter_Reserved_22 @0x78 {
                bytes 4;
                field sip2_ccf_axi_I_main_TransactionStatFilter_Reserved_22 {
                    bits 32;
                    access rw;
                    hard_reset 'h0;
                }
            }
            register sip2_ccf_axi_I_main_TransactionStatFilter_Reserved_23 @0x7C {
                bytes 4;
                field sip2_ccf_axi_I_main_TransactionStatFilter_Reserved_23 {
                    bits 32;
                    access rw;
                    hard_reset 'h0;
                }
            }
        }
        block ecf_ccf_axi_sip3_ccf_axi_I_main_TransactionStatFilter @0xDD380 {
            bytes 4;
            register sip3_ccf_axi_I_main_TransactionStatFilter_Id_CoreId @0x0 {
                bytes 4;
                field CORETYPEID @'h0 {
                    bits 8;
                    access ro;
                    hard_reset 'h9;
                    doc {
                        Field identifying the type of IP.
                    }
                }
                field CORECHECKSUM @'h8 {
                    bits 24;
                    access ro;
                    hard_reset 'hac8c75;
                    doc {
                        Field containing a checksum of the parameters of the IP.
                    }
                }
            }
            register sip3_ccf_axi_I_main_TransactionStatFilter_Id_RevisionId @0x4 {
                bytes 4;
                field USERID @'h0 {
                    bits 8;
                    access ro;
                    hard_reset 'h0;
                    doc {
                        Field containing a user defined value, not used anywhere inside the IP itself.
                    }
                }
                field FLEXNOCID @'h8 {
                    bits 24;
                    access ro;
                    hard_reset 'h84f8c6;
                    doc {
                        Field containing the build revision of the software used to generate the IP HDL code.
                    }
                }
            }
            register sip3_ccf_axi_I_main_TransactionStatFilter_Mode @0x8 {
                bytes 4;
                field MODE @'h0 {
                    access rw;
                    hard_reset 'h0;
                    doc {
                        Register Mode is a 1-bit register that sets the filtering mode as follows: handshake Mode = 0 or latency Mode = 1.
                    }
                }
            }
            register sip3_ccf_axi_I_main_TransactionStatFilter_AddrBase_Low @0xC {
                bytes 4;
                field ADDRBASE_LOW @'h0 {
                    bits 30;
                    access rw;
                    hard_reset 'h0;
                    doc {
                        Address base LSB register.
                    }
                }
            }
            register sip3_ccf_axi_I_main_TransactionStatFilter_Reserved_00 @0x10 {
                bytes 4;
                field sip3_ccf_axi_I_main_TransactionStatFilter_Reserved_00 {
                    bits 32;
                    access rw;
                    hard_reset 'h0;
                }
            }
            register sip3_ccf_axi_I_main_TransactionStatFilter_AddrWindowSize @0x14 {
                bytes 4;
                field ADDRWINDOWSIZE @'h0 {
                    bits 5;
                    access rw;
                    hard_reset 'h0;
                    doc {
                        Register AddrWindowSize contains the encoded address mask used to filter packets: the effective Mask value is equal to ~(2**AddrWindowSize - 1). A packet is a candidate when ReqInfo.Addr & AddrMask = AddrBase & AddrMask.
                    }
                }
            }
            register sip3_ccf_axi_I_main_TransactionStatFilter_Reserved_01 @0x18 {
                bytes 4;
                field sip3_ccf_axi_I_main_TransactionStatFilter_Reserved_01 {
                    bits 32;
                    access rw;
                    hard_reset 'h0;
                }
            }
            register sip3_ccf_axi_I_main_TransactionStatFilter_Reserved_02 @0x1C {
                bytes 4;
                field sip3_ccf_axi_I_main_TransactionStatFilter_Reserved_02 {
                    bits 32;
                    access rw;
                    hard_reset 'h0;
                }
            }
            register sip3_ccf_axi_I_main_TransactionStatFilter_Opcode @0x20 {
                bytes 4;
                field RDEN @'h0 {
                    access rw;
                    hard_reset 'h0;
                    doc {
                        When set to 1, selects RD requests.
                    }
                }
                field WREN @'h1 {
                    access rw;
                    hard_reset 'h0;
                    doc {
                        When set to 1, selects WR requests.
                    }
                }
                doc {
                    This register selects candidate packets based on packet opcodes. (0 disables the filter):
	This register selects candidate packets based on packet opcodes. (0 disables the filter):
	
                }
            }
            register sip3_ccf_axi_I_main_TransactionStatFilter_UserBase @0x24 {
                bytes 4;
                field USERBASE @'h0 {
                    bits 27;
                    access rw;
                    hard_reset 'h0;
                    doc {
                        This register contains the User base used to filter requests.
                    }
                }
            }
            register sip3_ccf_axi_I_main_TransactionStatFilter_UserMask @0x28 {
                bytes 4;
                field USERMASK @'h0 {
                    bits 27;
                    access rw;
                    hard_reset 'h0;
                    doc {
                        This register contains the User mask used to filter requests.
                    }
                }
            }
            register sip3_ccf_axi_I_main_TransactionStatFilter_Reserved_03 @0x2C {
                bytes 4;
                field sip3_ccf_axi_I_main_TransactionStatFilter_Reserved_03 {
                    bits 32;
                    access rw;
                    hard_reset 'h0;
                }
            }
            register sip3_ccf_axi_I_main_TransactionStatFilter_Reserved_04 @0x30 {
                bytes 4;
                field sip3_ccf_axi_I_main_TransactionStatFilter_Reserved_04 {
                    bits 32;
                    access rw;
                    hard_reset 'h0;
                }
            }
            register sip3_ccf_axi_I_main_TransactionStatFilter_Reserved_05 @0x34 {
                bytes 4;
                field sip3_ccf_axi_I_main_TransactionStatFilter_Reserved_05 {
                    bits 32;
                    access rw;
                    hard_reset 'h0;
                }
            }
            register sip3_ccf_axi_I_main_TransactionStatFilter_Reserved_06 @0x38 {
                bytes 4;
                field sip3_ccf_axi_I_main_TransactionStatFilter_Reserved_06 {
                    bits 32;
                    access rw;
                    hard_reset 'h0;
                }
            }
            register sip3_ccf_axi_I_main_TransactionStatFilter_Reserved_07 @0x3C {
                bytes 4;
                field sip3_ccf_axi_I_main_TransactionStatFilter_Reserved_07 {
                    bits 32;
                    access rw;
                    hard_reset 'h0;
                }
            }
            register sip3_ccf_axi_I_main_TransactionStatFilter_Reserved_08 @0x40 {
                bytes 4;
                field sip3_ccf_axi_I_main_TransactionStatFilter_Reserved_08 {
                    bits 32;
                    access rw;
                    hard_reset 'h0;
                }
            }
            register sip3_ccf_axi_I_main_TransactionStatFilter_Reserved_09 @0x44 {
                bytes 4;
                field sip3_ccf_axi_I_main_TransactionStatFilter_Reserved_09 {
                    bits 32;
                    access rw;
                    hard_reset 'h0;
                }
            }
            register sip3_ccf_axi_I_main_TransactionStatFilter_Reserved_10 @0x48 {
                bytes 4;
                field sip3_ccf_axi_I_main_TransactionStatFilter_Reserved_10 {
                    bits 32;
                    access rw;
                    hard_reset 'h0;
                }
            }
            register sip3_ccf_axi_I_main_TransactionStatFilter_Reserved_11 @0x4C {
                bytes 4;
                field sip3_ccf_axi_I_main_TransactionStatFilter_Reserved_11 {
                    bits 32;
                    access rw;
                    hard_reset 'h0;
                }
            }
            register sip3_ccf_axi_I_main_TransactionStatFilter_Reserved_12 @0x50 {
                bytes 4;
                field sip3_ccf_axi_I_main_TransactionStatFilter_Reserved_12 {
                    bits 32;
                    access rw;
                    hard_reset 'h0;
                }
            }
            register sip3_ccf_axi_I_main_TransactionStatFilter_Reserved_13 @0x54 {
                bytes 4;
                field sip3_ccf_axi_I_main_TransactionStatFilter_Reserved_13 {
                    bits 32;
                    access rw;
                    hard_reset 'h0;
                }
            }
            register sip3_ccf_axi_I_main_TransactionStatFilter_Reserved_14 @0x58 {
                bytes 4;
                field sip3_ccf_axi_I_main_TransactionStatFilter_Reserved_14 {
                    bits 32;
                    access rw;
                    hard_reset 'h0;
                }
            }
            register sip3_ccf_axi_I_main_TransactionStatFilter_Reserved_15 @0x5C {
                bytes 4;
                field sip3_ccf_axi_I_main_TransactionStatFilter_Reserved_15 {
                    bits 32;
                    access rw;
                    hard_reset 'h0;
                }
            }
            register sip3_ccf_axi_I_main_TransactionStatFilter_Reserved_16 @0x60 {
                bytes 4;
                field sip3_ccf_axi_I_main_TransactionStatFilter_Reserved_16 {
                    bits 32;
                    access rw;
                    hard_reset 'h0;
                }
            }
            register sip3_ccf_axi_I_main_TransactionStatFilter_Reserved_17 @0x64 {
                bytes 4;
                field sip3_ccf_axi_I_main_TransactionStatFilter_Reserved_17 {
                    bits 32;
                    access rw;
                    hard_reset 'h0;
                }
            }
            register sip3_ccf_axi_I_main_TransactionStatFilter_Reserved_18 @0x68 {
                bytes 4;
                field sip3_ccf_axi_I_main_TransactionStatFilter_Reserved_18 {
                    bits 32;
                    access rw;
                    hard_reset 'h0;
                }
            }
            register sip3_ccf_axi_I_main_TransactionStatFilter_Reserved_19 @0x6C {
                bytes 4;
                field sip3_ccf_axi_I_main_TransactionStatFilter_Reserved_19 {
                    bits 32;
                    access rw;
                    hard_reset 'h0;
                }
            }
            register sip3_ccf_axi_I_main_TransactionStatFilter_Reserved_20 @0x70 {
                bytes 4;
                field sip3_ccf_axi_I_main_TransactionStatFilter_Reserved_20 {
                    bits 32;
                    access rw;
                    hard_reset 'h0;
                }
            }
            register sip3_ccf_axi_I_main_TransactionStatFilter_Reserved_21 @0x74 {
                bytes 4;
                field sip3_ccf_axi_I_main_TransactionStatFilter_Reserved_21 {
                    bits 32;
                    access rw;
                    hard_reset 'h0;
                }
            }
            register sip3_ccf_axi_I_main_TransactionStatFilter_Reserved_22 @0x78 {
                bytes 4;
                field sip3_ccf_axi_I_main_TransactionStatFilter_Reserved_22 {
                    bits 32;
                    access rw;
                    hard_reset 'h0;
                }
            }
            register sip3_ccf_axi_I_main_TransactionStatFilter_Reserved_23 @0x7C {
                bytes 4;
                field sip3_ccf_axi_I_main_TransactionStatFilter_Reserved_23 {
                    bits 32;
                    access rw;
                    hard_reset 'h0;
                }
            }
        }
        block ecf_ccf_axi_sip4_ccf_axi_I_main_TransactionStatFilter @0xDD400 {
            bytes 4;
            register sip4_ccf_axi_I_main_TransactionStatFilter_Id_CoreId @0x0 {
                bytes 4;
                field CORETYPEID @'h0 {
                    bits 8;
                    access ro;
                    hard_reset 'h9;
                    doc {
                        Field identifying the type of IP.
                    }
                }
                field CORECHECKSUM @'h8 {
                    bits 24;
                    access ro;
                    hard_reset 'h8c92a0;
                    doc {
                        Field containing a checksum of the parameters of the IP.
                    }
                }
            }
            register sip4_ccf_axi_I_main_TransactionStatFilter_Id_RevisionId @0x4 {
                bytes 4;
                field USERID @'h0 {
                    bits 8;
                    access ro;
                    hard_reset 'h0;
                    doc {
                        Field containing a user defined value, not used anywhere inside the IP itself.
                    }
                }
                field FLEXNOCID @'h8 {
                    bits 24;
                    access ro;
                    hard_reset 'h84f8c6;
                    doc {
                        Field containing the build revision of the software used to generate the IP HDL code.
                    }
                }
            }
            register sip4_ccf_axi_I_main_TransactionStatFilter_Mode @0x8 {
                bytes 4;
                field MODE @'h0 {
                    access rw;
                    hard_reset 'h0;
                    doc {
                        Register Mode is a 1-bit register that sets the filtering mode as follows: handshake Mode = 0 or latency Mode = 1.
                    }
                }
            }
            register sip4_ccf_axi_I_main_TransactionStatFilter_AddrBase_Low @0xC {
                bytes 4;
                field ADDRBASE_LOW @'h0 {
                    bits 30;
                    access rw;
                    hard_reset 'h0;
                    doc {
                        Address base LSB register.
                    }
                }
            }
            register sip4_ccf_axi_I_main_TransactionStatFilter_Reserved_00 @0x10 {
                bytes 4;
                field sip4_ccf_axi_I_main_TransactionStatFilter_Reserved_00 {
                    bits 32;
                    access rw;
                    hard_reset 'h0;
                }
            }
            register sip4_ccf_axi_I_main_TransactionStatFilter_AddrWindowSize @0x14 {
                bytes 4;
                field ADDRWINDOWSIZE @'h0 {
                    bits 5;
                    access rw;
                    hard_reset 'h0;
                    doc {
                        Register AddrWindowSize contains the encoded address mask used to filter packets: the effective Mask value is equal to ~(2**AddrWindowSize - 1). A packet is a candidate when ReqInfo.Addr & AddrMask = AddrBase & AddrMask.
                    }
                }
            }
            register sip4_ccf_axi_I_main_TransactionStatFilter_Reserved_01 @0x18 {
                bytes 4;
                field sip4_ccf_axi_I_main_TransactionStatFilter_Reserved_01 {
                    bits 32;
                    access rw;
                    hard_reset 'h0;
                }
            }
            register sip4_ccf_axi_I_main_TransactionStatFilter_Reserved_02 @0x1C {
                bytes 4;
                field sip4_ccf_axi_I_main_TransactionStatFilter_Reserved_02 {
                    bits 32;
                    access rw;
                    hard_reset 'h0;
                }
            }
            register sip4_ccf_axi_I_main_TransactionStatFilter_Opcode @0x20 {
                bytes 4;
                field RDEN @'h0 {
                    access rw;
                    hard_reset 'h0;
                    doc {
                        When set to 1, selects RD requests.
                    }
                }
                field WREN @'h1 {
                    access rw;
                    hard_reset 'h0;
                    doc {
                        When set to 1, selects WR requests.
                    }
                }
                doc {
                    This register selects candidate packets based on packet opcodes. (0 disables the filter):
	This register selects candidate packets based on packet opcodes. (0 disables the filter):
	
                }
            }
            register sip4_ccf_axi_I_main_TransactionStatFilter_UserBase @0x24 {
                bytes 4;
                field USERBASE @'h0 {
                    bits 27;
                    access rw;
                    hard_reset 'h0;
                    doc {
                        This register contains the User base used to filter requests.
                    }
                }
            }
            register sip4_ccf_axi_I_main_TransactionStatFilter_UserMask @0x28 {
                bytes 4;
                field USERMASK @'h0 {
                    bits 27;
                    access rw;
                    hard_reset 'h0;
                    doc {
                        This register contains the User mask used to filter requests.
                    }
                }
            }
            register sip4_ccf_axi_I_main_TransactionStatFilter_Reserved_03 @0x2C {
                bytes 4;
                field sip4_ccf_axi_I_main_TransactionStatFilter_Reserved_03 {
                    bits 32;
                    access rw;
                    hard_reset 'h0;
                }
            }
            register sip4_ccf_axi_I_main_TransactionStatFilter_Reserved_04 @0x30 {
                bytes 4;
                field sip4_ccf_axi_I_main_TransactionStatFilter_Reserved_04 {
                    bits 32;
                    access rw;
                    hard_reset 'h0;
                }
            }
            register sip4_ccf_axi_I_main_TransactionStatFilter_Reserved_05 @0x34 {
                bytes 4;
                field sip4_ccf_axi_I_main_TransactionStatFilter_Reserved_05 {
                    bits 32;
                    access rw;
                    hard_reset 'h0;
                }
            }
            register sip4_ccf_axi_I_main_TransactionStatFilter_Reserved_06 @0x38 {
                bytes 4;
                field sip4_ccf_axi_I_main_TransactionStatFilter_Reserved_06 {
                    bits 32;
                    access rw;
                    hard_reset 'h0;
                }
            }
            register sip4_ccf_axi_I_main_TransactionStatFilter_Reserved_07 @0x3C {
                bytes 4;
                field sip4_ccf_axi_I_main_TransactionStatFilter_Reserved_07 {
                    bits 32;
                    access rw;
                    hard_reset 'h0;
                }
            }
            register sip4_ccf_axi_I_main_TransactionStatFilter_Reserved_08 @0x40 {
                bytes 4;
                field sip4_ccf_axi_I_main_TransactionStatFilter_Reserved_08 {
                    bits 32;
                    access rw;
                    hard_reset 'h0;
                }
            }
            register sip4_ccf_axi_I_main_TransactionStatFilter_Reserved_09 @0x44 {
                bytes 4;
                field sip4_ccf_axi_I_main_TransactionStatFilter_Reserved_09 {
                    bits 32;
                    access rw;
                    hard_reset 'h0;
                }
            }
            register sip4_ccf_axi_I_main_TransactionStatFilter_Reserved_10 @0x48 {
                bytes 4;
                field sip4_ccf_axi_I_main_TransactionStatFilter_Reserved_10 {
                    bits 32;
                    access rw;
                    hard_reset 'h0;
                }
            }
            register sip4_ccf_axi_I_main_TransactionStatFilter_Reserved_11 @0x4C {
                bytes 4;
                field sip4_ccf_axi_I_main_TransactionStatFilter_Reserved_11 {
                    bits 32;
                    access rw;
                    hard_reset 'h0;
                }
            }
            register sip4_ccf_axi_I_main_TransactionStatFilter_Reserved_12 @0x50 {
                bytes 4;
                field sip4_ccf_axi_I_main_TransactionStatFilter_Reserved_12 {
                    bits 32;
                    access rw;
                    hard_reset 'h0;
                }
            }
            register sip4_ccf_axi_I_main_TransactionStatFilter_Reserved_13 @0x54 {
                bytes 4;
                field sip4_ccf_axi_I_main_TransactionStatFilter_Reserved_13 {
                    bits 32;
                    access rw;
                    hard_reset 'h0;
                }
            }
            register sip4_ccf_axi_I_main_TransactionStatFilter_Reserved_14 @0x58 {
                bytes 4;
                field sip4_ccf_axi_I_main_TransactionStatFilter_Reserved_14 {
                    bits 32;
                    access rw;
                    hard_reset 'h0;
                }
            }
            register sip4_ccf_axi_I_main_TransactionStatFilter_Reserved_15 @0x5C {
                bytes 4;
                field sip4_ccf_axi_I_main_TransactionStatFilter_Reserved_15 {
                    bits 32;
                    access rw;
                    hard_reset 'h0;
                }
            }
            register sip4_ccf_axi_I_main_TransactionStatFilter_Reserved_16 @0x60 {
                bytes 4;
                field sip4_ccf_axi_I_main_TransactionStatFilter_Reserved_16 {
                    bits 32;
                    access rw;
                    hard_reset 'h0;
                }
            }
            register sip4_ccf_axi_I_main_TransactionStatFilter_Reserved_17 @0x64 {
                bytes 4;
                field sip4_ccf_axi_I_main_TransactionStatFilter_Reserved_17 {
                    bits 32;
                    access rw;
                    hard_reset 'h0;
                }
            }
            register sip4_ccf_axi_I_main_TransactionStatFilter_Reserved_18 @0x68 {
                bytes 4;
                field sip4_ccf_axi_I_main_TransactionStatFilter_Reserved_18 {
                    bits 32;
                    access rw;
                    hard_reset 'h0;
                }
            }
            register sip4_ccf_axi_I_main_TransactionStatFilter_Reserved_19 @0x6C {
                bytes 4;
                field sip4_ccf_axi_I_main_TransactionStatFilter_Reserved_19 {
                    bits 32;
                    access rw;
                    hard_reset 'h0;
                }
            }
            register sip4_ccf_axi_I_main_TransactionStatFilter_Reserved_20 @0x70 {
                bytes 4;
                field sip4_ccf_axi_I_main_TransactionStatFilter_Reserved_20 {
                    bits 32;
                    access rw;
                    hard_reset 'h0;
                }
            }
            register sip4_ccf_axi_I_main_TransactionStatFilter_Reserved_21 @0x74 {
                bytes 4;
                field sip4_ccf_axi_I_main_TransactionStatFilter_Reserved_21 {
                    bits 32;
                    access rw;
                    hard_reset 'h0;
                }
            }
            register sip4_ccf_axi_I_main_TransactionStatFilter_Reserved_22 @0x78 {
                bytes 4;
                field sip4_ccf_axi_I_main_TransactionStatFilter_Reserved_22 {
                    bits 32;
                    access rw;
                    hard_reset 'h0;
                }
            }
            register sip4_ccf_axi_I_main_TransactionStatFilter_Reserved_23 @0x7C {
                bytes 4;
                field sip4_ccf_axi_I_main_TransactionStatFilter_Reserved_23 {
                    bits 32;
                    access rw;
                    hard_reset 'h0;
                }
            }
        }
        block ecf_ccf_axi_sip5_ccf_axi_I_main_TransactionStatFilter @0xDD480 {
            bytes 4;
            register sip5_ccf_axi_I_main_TransactionStatFilter_Id_CoreId @0x0 {
                bytes 4;
                field CORETYPEID @'h0 {
                    bits 8;
                    access ro;
                    hard_reset 'h9;
                    doc {
                        Field identifying the type of IP.
                    }
                }
                field CORECHECKSUM @'h8 {
                    bits 24;
                    access ro;
                    hard_reset 'hd43ca8;
                    doc {
                        Field containing a checksum of the parameters of the IP.
                    }
                }
            }
            register sip5_ccf_axi_I_main_TransactionStatFilter_Id_RevisionId @0x4 {
                bytes 4;
                field USERID @'h0 {
                    bits 8;
                    access ro;
                    hard_reset 'h0;
                    doc {
                        Field containing a user defined value, not used anywhere inside the IP itself.
                    }
                }
                field FLEXNOCID @'h8 {
                    bits 24;
                    access ro;
                    hard_reset 'h84f8c6;
                    doc {
                        Field containing the build revision of the software used to generate the IP HDL code.
                    }
                }
            }
            register sip5_ccf_axi_I_main_TransactionStatFilter_Mode @0x8 {
                bytes 4;
                field MODE @'h0 {
                    access rw;
                    hard_reset 'h0;
                    doc {
                        Register Mode is a 1-bit register that sets the filtering mode as follows: handshake Mode = 0 or latency Mode = 1.
                    }
                }
            }
            register sip5_ccf_axi_I_main_TransactionStatFilter_AddrBase_Low @0xC {
                bytes 4;
                field ADDRBASE_LOW @'h0 {
                    bits 30;
                    access rw;
                    hard_reset 'h0;
                    doc {
                        Address base LSB register.
                    }
                }
            }
            register sip5_ccf_axi_I_main_TransactionStatFilter_Reserved_00 @0x10 {
                bytes 4;
                field sip5_ccf_axi_I_main_TransactionStatFilter_Reserved_00 {
                    bits 32;
                    access rw;
                    hard_reset 'h0;
                }
            }
            register sip5_ccf_axi_I_main_TransactionStatFilter_AddrWindowSize @0x14 {
                bytes 4;
                field ADDRWINDOWSIZE @'h0 {
                    bits 5;
                    access rw;
                    hard_reset 'h0;
                    doc {
                        Register AddrWindowSize contains the encoded address mask used to filter packets: the effective Mask value is equal to ~(2**AddrWindowSize - 1). A packet is a candidate when ReqInfo.Addr & AddrMask = AddrBase & AddrMask.
                    }
                }
            }
            register sip5_ccf_axi_I_main_TransactionStatFilter_Reserved_01 @0x18 {
                bytes 4;
                field sip5_ccf_axi_I_main_TransactionStatFilter_Reserved_01 {
                    bits 32;
                    access rw;
                    hard_reset 'h0;
                }
            }
            register sip5_ccf_axi_I_main_TransactionStatFilter_Reserved_02 @0x1C {
                bytes 4;
                field sip5_ccf_axi_I_main_TransactionStatFilter_Reserved_02 {
                    bits 32;
                    access rw;
                    hard_reset 'h0;
                }
            }
            register sip5_ccf_axi_I_main_TransactionStatFilter_Opcode @0x20 {
                bytes 4;
                field RDEN @'h0 {
                    access rw;
                    hard_reset 'h0;
                    doc {
                        When set to 1, selects RD requests.
                    }
                }
                field WREN @'h1 {
                    access rw;
                    hard_reset 'h0;
                    doc {
                        When set to 1, selects WR requests.
                    }
                }
                doc {
                    This register selects candidate packets based on packet opcodes. (0 disables the filter):
	This register selects candidate packets based on packet opcodes. (0 disables the filter):
	
                }
            }
            register sip5_ccf_axi_I_main_TransactionStatFilter_UserBase @0x24 {
                bytes 4;
                field USERBASE @'h0 {
                    bits 27;
                    access rw;
                    hard_reset 'h0;
                    doc {
                        This register contains the User base used to filter requests.
                    }
                }
            }
            register sip5_ccf_axi_I_main_TransactionStatFilter_UserMask @0x28 {
                bytes 4;
                field USERMASK @'h0 {
                    bits 27;
                    access rw;
                    hard_reset 'h0;
                    doc {
                        This register contains the User mask used to filter requests.
                    }
                }
            }
            register sip5_ccf_axi_I_main_TransactionStatFilter_Reserved_03 @0x2C {
                bytes 4;
                field sip5_ccf_axi_I_main_TransactionStatFilter_Reserved_03 {
                    bits 32;
                    access rw;
                    hard_reset 'h0;
                }
            }
            register sip5_ccf_axi_I_main_TransactionStatFilter_Reserved_04 @0x30 {
                bytes 4;
                field sip5_ccf_axi_I_main_TransactionStatFilter_Reserved_04 {
                    bits 32;
                    access rw;
                    hard_reset 'h0;
                }
            }
            register sip5_ccf_axi_I_main_TransactionStatFilter_Reserved_05 @0x34 {
                bytes 4;
                field sip5_ccf_axi_I_main_TransactionStatFilter_Reserved_05 {
                    bits 32;
                    access rw;
                    hard_reset 'h0;
                }
            }
            register sip5_ccf_axi_I_main_TransactionStatFilter_Reserved_06 @0x38 {
                bytes 4;
                field sip5_ccf_axi_I_main_TransactionStatFilter_Reserved_06 {
                    bits 32;
                    access rw;
                    hard_reset 'h0;
                }
            }
            register sip5_ccf_axi_I_main_TransactionStatFilter_Reserved_07 @0x3C {
                bytes 4;
                field sip5_ccf_axi_I_main_TransactionStatFilter_Reserved_07 {
                    bits 32;
                    access rw;
                    hard_reset 'h0;
                }
            }
            register sip5_ccf_axi_I_main_TransactionStatFilter_Reserved_08 @0x40 {
                bytes 4;
                field sip5_ccf_axi_I_main_TransactionStatFilter_Reserved_08 {
                    bits 32;
                    access rw;
                    hard_reset 'h0;
                }
            }
            register sip5_ccf_axi_I_main_TransactionStatFilter_Reserved_09 @0x44 {
                bytes 4;
                field sip5_ccf_axi_I_main_TransactionStatFilter_Reserved_09 {
                    bits 32;
                    access rw;
                    hard_reset 'h0;
                }
            }
            register sip5_ccf_axi_I_main_TransactionStatFilter_Reserved_10 @0x48 {
                bytes 4;
                field sip5_ccf_axi_I_main_TransactionStatFilter_Reserved_10 {
                    bits 32;
                    access rw;
                    hard_reset 'h0;
                }
            }
            register sip5_ccf_axi_I_main_TransactionStatFilter_Reserved_11 @0x4C {
                bytes 4;
                field sip5_ccf_axi_I_main_TransactionStatFilter_Reserved_11 {
                    bits 32;
                    access rw;
                    hard_reset 'h0;
                }
            }
            register sip5_ccf_axi_I_main_TransactionStatFilter_Reserved_12 @0x50 {
                bytes 4;
                field sip5_ccf_axi_I_main_TransactionStatFilter_Reserved_12 {
                    bits 32;
                    access rw;
                    hard_reset 'h0;
                }
            }
            register sip5_ccf_axi_I_main_TransactionStatFilter_Reserved_13 @0x54 {
                bytes 4;
                field sip5_ccf_axi_I_main_TransactionStatFilter_Reserved_13 {
                    bits 32;
                    access rw;
                    hard_reset 'h0;
                }
            }
            register sip5_ccf_axi_I_main_TransactionStatFilter_Reserved_14 @0x58 {
                bytes 4;
                field sip5_ccf_axi_I_main_TransactionStatFilter_Reserved_14 {
                    bits 32;
                    access rw;
                    hard_reset 'h0;
                }
            }
            register sip5_ccf_axi_I_main_TransactionStatFilter_Reserved_15 @0x5C {
                bytes 4;
                field sip5_ccf_axi_I_main_TransactionStatFilter_Reserved_15 {
                    bits 32;
                    access rw;
                    hard_reset 'h0;
                }
            }
            register sip5_ccf_axi_I_main_TransactionStatFilter_Reserved_16 @0x60 {
                bytes 4;
                field sip5_ccf_axi_I_main_TransactionStatFilter_Reserved_16 {
                    bits 32;
                    access rw;
                    hard_reset 'h0;
                }
            }
            register sip5_ccf_axi_I_main_TransactionStatFilter_Reserved_17 @0x64 {
                bytes 4;
                field sip5_ccf_axi_I_main_TransactionStatFilter_Reserved_17 {
                    bits 32;
                    access rw;
                    hard_reset 'h0;
                }
            }
            register sip5_ccf_axi_I_main_TransactionStatFilter_Reserved_18 @0x68 {
                bytes 4;
                field sip5_ccf_axi_I_main_TransactionStatFilter_Reserved_18 {
                    bits 32;
                    access rw;
                    hard_reset 'h0;
                }
            }
            register sip5_ccf_axi_I_main_TransactionStatFilter_Reserved_19 @0x6C {
                bytes 4;
                field sip5_ccf_axi_I_main_TransactionStatFilter_Reserved_19 {
                    bits 32;
                    access rw;
                    hard_reset 'h0;
                }
            }
            register sip5_ccf_axi_I_main_TransactionStatFilter_Reserved_20 @0x70 {
                bytes 4;
                field sip5_ccf_axi_I_main_TransactionStatFilter_Reserved_20 {
                    bits 32;
                    access rw;
                    hard_reset 'h0;
                }
            }
            register sip5_ccf_axi_I_main_TransactionStatFilter_Reserved_21 @0x74 {
                bytes 4;
                field sip5_ccf_axi_I_main_TransactionStatFilter_Reserved_21 {
                    bits 32;
                    access rw;
                    hard_reset 'h0;
                }
            }
            register sip5_ccf_axi_I_main_TransactionStatFilter_Reserved_22 @0x78 {
                bytes 4;
                field sip5_ccf_axi_I_main_TransactionStatFilter_Reserved_22 {
                    bits 32;
                    access rw;
                    hard_reset 'h0;
                }
            }
            register sip5_ccf_axi_I_main_TransactionStatFilter_Reserved_23 @0x7C {
                bytes 4;
                field sip5_ccf_axi_I_main_TransactionStatFilter_Reserved_23 {
                    bits 32;
                    access rw;
                    hard_reset 'h0;
                }
            }
        }
        block ecf_ccf_axi_sip6_ccf_axi_I_main_TransactionStatFilter @0xDD500 {
            bytes 4;
            register sip6_ccf_axi_I_main_TransactionStatFilter_Id_CoreId @0x0 {
                bytes 4;
                field CORETYPEID @'h0 {
                    bits 8;
                    access ro;
                    hard_reset 'h9;
                    doc {
                        Field identifying the type of IP.
                    }
                }
                field CORECHECKSUM @'h8 {
                    bits 24;
                    access ro;
                    hard_reset 'he6713d;
                    doc {
                        Field containing a checksum of the parameters of the IP.
                    }
                }
            }
            register sip6_ccf_axi_I_main_TransactionStatFilter_Id_RevisionId @0x4 {
                bytes 4;
                field USERID @'h0 {
                    bits 8;
                    access ro;
                    hard_reset 'h0;
                    doc {
                        Field containing a user defined value, not used anywhere inside the IP itself.
                    }
                }
                field FLEXNOCID @'h8 {
                    bits 24;
                    access ro;
                    hard_reset 'h84f8c6;
                    doc {
                        Field containing the build revision of the software used to generate the IP HDL code.
                    }
                }
            }
            register sip6_ccf_axi_I_main_TransactionStatFilter_Mode @0x8 {
                bytes 4;
                field MODE @'h0 {
                    access rw;
                    hard_reset 'h0;
                    doc {
                        Register Mode is a 1-bit register that sets the filtering mode as follows: handshake Mode = 0 or latency Mode = 1.
                    }
                }
            }
            register sip6_ccf_axi_I_main_TransactionStatFilter_AddrBase_Low @0xC {
                bytes 4;
                field ADDRBASE_LOW @'h0 {
                    bits 30;
                    access rw;
                    hard_reset 'h0;
                    doc {
                        Address base LSB register.
                    }
                }
            }
            register sip6_ccf_axi_I_main_TransactionStatFilter_Reserved_00 @0x10 {
                bytes 4;
                field sip6_ccf_axi_I_main_TransactionStatFilter_Reserved_00 {
                    bits 32;
                    access rw;
                    hard_reset 'h0;
                }
            }
            register sip6_ccf_axi_I_main_TransactionStatFilter_AddrWindowSize @0x14 {
                bytes 4;
                field ADDRWINDOWSIZE @'h0 {
                    bits 5;
                    access rw;
                    hard_reset 'h0;
                    doc {
                        Register AddrWindowSize contains the encoded address mask used to filter packets: the effective Mask value is equal to ~(2**AddrWindowSize - 1). A packet is a candidate when ReqInfo.Addr & AddrMask = AddrBase & AddrMask.
                    }
                }
            }
            register sip6_ccf_axi_I_main_TransactionStatFilter_Reserved_01 @0x18 {
                bytes 4;
                field sip6_ccf_axi_I_main_TransactionStatFilter_Reserved_01 {
                    bits 32;
                    access rw;
                    hard_reset 'h0;
                }
            }
            register sip6_ccf_axi_I_main_TransactionStatFilter_Reserved_02 @0x1C {
                bytes 4;
                field sip6_ccf_axi_I_main_TransactionStatFilter_Reserved_02 {
                    bits 32;
                    access rw;
                    hard_reset 'h0;
                }
            }
            register sip6_ccf_axi_I_main_TransactionStatFilter_Opcode @0x20 {
                bytes 4;
                field RDEN @'h0 {
                    access rw;
                    hard_reset 'h0;
                    doc {
                        When set to 1, selects RD requests.
                    }
                }
                field WREN @'h1 {
                    access rw;
                    hard_reset 'h0;
                    doc {
                        When set to 1, selects WR requests.
                    }
                }
                doc {
                    This register selects candidate packets based on packet opcodes. (0 disables the filter):
	This register selects candidate packets based on packet opcodes. (0 disables the filter):
	
                }
            }
            register sip6_ccf_axi_I_main_TransactionStatFilter_UserBase @0x24 {
                bytes 4;
                field USERBASE @'h0 {
                    bits 27;
                    access rw;
                    hard_reset 'h0;
                    doc {
                        This register contains the User base used to filter requests.
                    }
                }
            }
            register sip6_ccf_axi_I_main_TransactionStatFilter_UserMask @0x28 {
                bytes 4;
                field USERMASK @'h0 {
                    bits 27;
                    access rw;
                    hard_reset 'h0;
                    doc {
                        This register contains the User mask used to filter requests.
                    }
                }
            }
            register sip6_ccf_axi_I_main_TransactionStatFilter_Reserved_03 @0x2C {
                bytes 4;
                field sip6_ccf_axi_I_main_TransactionStatFilter_Reserved_03 {
                    bits 32;
                    access rw;
                    hard_reset 'h0;
                }
            }
            register sip6_ccf_axi_I_main_TransactionStatFilter_Reserved_04 @0x30 {
                bytes 4;
                field sip6_ccf_axi_I_main_TransactionStatFilter_Reserved_04 {
                    bits 32;
                    access rw;
                    hard_reset 'h0;
                }
            }
            register sip6_ccf_axi_I_main_TransactionStatFilter_Reserved_05 @0x34 {
                bytes 4;
                field sip6_ccf_axi_I_main_TransactionStatFilter_Reserved_05 {
                    bits 32;
                    access rw;
                    hard_reset 'h0;
                }
            }
            register sip6_ccf_axi_I_main_TransactionStatFilter_Reserved_06 @0x38 {
                bytes 4;
                field sip6_ccf_axi_I_main_TransactionStatFilter_Reserved_06 {
                    bits 32;
                    access rw;
                    hard_reset 'h0;
                }
            }
            register sip6_ccf_axi_I_main_TransactionStatFilter_Reserved_07 @0x3C {
                bytes 4;
                field sip6_ccf_axi_I_main_TransactionStatFilter_Reserved_07 {
                    bits 32;
                    access rw;
                    hard_reset 'h0;
                }
            }
            register sip6_ccf_axi_I_main_TransactionStatFilter_Reserved_08 @0x40 {
                bytes 4;
                field sip6_ccf_axi_I_main_TransactionStatFilter_Reserved_08 {
                    bits 32;
                    access rw;
                    hard_reset 'h0;
                }
            }
            register sip6_ccf_axi_I_main_TransactionStatFilter_Reserved_09 @0x44 {
                bytes 4;
                field sip6_ccf_axi_I_main_TransactionStatFilter_Reserved_09 {
                    bits 32;
                    access rw;
                    hard_reset 'h0;
                }
            }
            register sip6_ccf_axi_I_main_TransactionStatFilter_Reserved_10 @0x48 {
                bytes 4;
                field sip6_ccf_axi_I_main_TransactionStatFilter_Reserved_10 {
                    bits 32;
                    access rw;
                    hard_reset 'h0;
                }
            }
            register sip6_ccf_axi_I_main_TransactionStatFilter_Reserved_11 @0x4C {
                bytes 4;
                field sip6_ccf_axi_I_main_TransactionStatFilter_Reserved_11 {
                    bits 32;
                    access rw;
                    hard_reset 'h0;
                }
            }
            register sip6_ccf_axi_I_main_TransactionStatFilter_Reserved_12 @0x50 {
                bytes 4;
                field sip6_ccf_axi_I_main_TransactionStatFilter_Reserved_12 {
                    bits 32;
                    access rw;
                    hard_reset 'h0;
                }
            }
            register sip6_ccf_axi_I_main_TransactionStatFilter_Reserved_13 @0x54 {
                bytes 4;
                field sip6_ccf_axi_I_main_TransactionStatFilter_Reserved_13 {
                    bits 32;
                    access rw;
                    hard_reset 'h0;
                }
            }
            register sip6_ccf_axi_I_main_TransactionStatFilter_Reserved_14 @0x58 {
                bytes 4;
                field sip6_ccf_axi_I_main_TransactionStatFilter_Reserved_14 {
                    bits 32;
                    access rw;
                    hard_reset 'h0;
                }
            }
            register sip6_ccf_axi_I_main_TransactionStatFilter_Reserved_15 @0x5C {
                bytes 4;
                field sip6_ccf_axi_I_main_TransactionStatFilter_Reserved_15 {
                    bits 32;
                    access rw;
                    hard_reset 'h0;
                }
            }
            register sip6_ccf_axi_I_main_TransactionStatFilter_Reserved_16 @0x60 {
                bytes 4;
                field sip6_ccf_axi_I_main_TransactionStatFilter_Reserved_16 {
                    bits 32;
                    access rw;
                    hard_reset 'h0;
                }
            }
            register sip6_ccf_axi_I_main_TransactionStatFilter_Reserved_17 @0x64 {
                bytes 4;
                field sip6_ccf_axi_I_main_TransactionStatFilter_Reserved_17 {
                    bits 32;
                    access rw;
                    hard_reset 'h0;
                }
            }
            register sip6_ccf_axi_I_main_TransactionStatFilter_Reserved_18 @0x68 {
                bytes 4;
                field sip6_ccf_axi_I_main_TransactionStatFilter_Reserved_18 {
                    bits 32;
                    access rw;
                    hard_reset 'h0;
                }
            }
            register sip6_ccf_axi_I_main_TransactionStatFilter_Reserved_19 @0x6C {
                bytes 4;
                field sip6_ccf_axi_I_main_TransactionStatFilter_Reserved_19 {
                    bits 32;
                    access rw;
                    hard_reset 'h0;
                }
            }
            register sip6_ccf_axi_I_main_TransactionStatFilter_Reserved_20 @0x70 {
                bytes 4;
                field sip6_ccf_axi_I_main_TransactionStatFilter_Reserved_20 {
                    bits 32;
                    access rw;
                    hard_reset 'h0;
                }
            }
            register sip6_ccf_axi_I_main_TransactionStatFilter_Reserved_21 @0x74 {
                bytes 4;
                field sip6_ccf_axi_I_main_TransactionStatFilter_Reserved_21 {
                    bits 32;
                    access rw;
                    hard_reset 'h0;
                }
            }
            register sip6_ccf_axi_I_main_TransactionStatFilter_Reserved_22 @0x78 {
                bytes 4;
                field sip6_ccf_axi_I_main_TransactionStatFilter_Reserved_22 {
                    bits 32;
                    access rw;
                    hard_reset 'h0;
                }
            }
            register sip6_ccf_axi_I_main_TransactionStatFilter_Reserved_23 @0x7C {
                bytes 4;
                field sip6_ccf_axi_I_main_TransactionStatFilter_Reserved_23 {
                    bits 32;
                    access rw;
                    hard_reset 'h0;
                }
            }
        }
        block ecf_ccf_axi_sip7_ccf_axi_I_main_TransactionStatFilter @0xDD580 {
            bytes 4;
            register sip7_ccf_axi_I_main_TransactionStatFilter_Id_CoreId @0x0 {
                bytes 4;
                field CORETYPEID @'h0 {
                    bits 8;
                    access ro;
                    hard_reset 'h9;
                    doc {
                        Field identifying the type of IP.
                    }
                }
                field CORECHECKSUM @'h8 {
                    bits 24;
                    access ro;
                    hard_reset 'ha73da6;
                    doc {
                        Field containing a checksum of the parameters of the IP.
                    }
                }
            }
            register sip7_ccf_axi_I_main_TransactionStatFilter_Id_RevisionId @0x4 {
                bytes 4;
                field USERID @'h0 {
                    bits 8;
                    access ro;
                    hard_reset 'h0;
                    doc {
                        Field containing a user defined value, not used anywhere inside the IP itself.
                    }
                }
                field FLEXNOCID @'h8 {
                    bits 24;
                    access ro;
                    hard_reset 'h84f8c6;
                    doc {
                        Field containing the build revision of the software used to generate the IP HDL code.
                    }
                }
            }
            register sip7_ccf_axi_I_main_TransactionStatFilter_Mode @0x8 {
                bytes 4;
                field MODE @'h0 {
                    access rw;
                    hard_reset 'h0;
                    doc {
                        Register Mode is a 1-bit register that sets the filtering mode as follows: handshake Mode = 0 or latency Mode = 1.
                    }
                }
            }
            register sip7_ccf_axi_I_main_TransactionStatFilter_AddrBase_Low @0xC {
                bytes 4;
                field ADDRBASE_LOW @'h0 {
                    bits 30;
                    access rw;
                    hard_reset 'h0;
                    doc {
                        Address base LSB register.
                    }
                }
            }
            register sip7_ccf_axi_I_main_TransactionStatFilter_Reserved_00 @0x10 {
                bytes 4;
                field sip7_ccf_axi_I_main_TransactionStatFilter_Reserved_00 {
                    bits 32;
                    access rw;
                    hard_reset 'h0;
                }
            }
            register sip7_ccf_axi_I_main_TransactionStatFilter_AddrWindowSize @0x14 {
                bytes 4;
                field ADDRWINDOWSIZE @'h0 {
                    bits 5;
                    access rw;
                    hard_reset 'h0;
                    doc {
                        Register AddrWindowSize contains the encoded address mask used to filter packets: the effective Mask value is equal to ~(2**AddrWindowSize - 1). A packet is a candidate when ReqInfo.Addr & AddrMask = AddrBase & AddrMask.
                    }
                }
            }
            register sip7_ccf_axi_I_main_TransactionStatFilter_Reserved_01 @0x18 {
                bytes 4;
                field sip7_ccf_axi_I_main_TransactionStatFilter_Reserved_01 {
                    bits 32;
                    access rw;
                    hard_reset 'h0;
                }
            }
            register sip7_ccf_axi_I_main_TransactionStatFilter_Reserved_02 @0x1C {
                bytes 4;
                field sip7_ccf_axi_I_main_TransactionStatFilter_Reserved_02 {
                    bits 32;
                    access rw;
                    hard_reset 'h0;
                }
            }
            register sip7_ccf_axi_I_main_TransactionStatFilter_Opcode @0x20 {
                bytes 4;
                field RDEN @'h0 {
                    access rw;
                    hard_reset 'h0;
                    doc {
                        When set to 1, selects RD requests.
                    }
                }
                field WREN @'h1 {
                    access rw;
                    hard_reset 'h0;
                    doc {
                        When set to 1, selects WR requests.
                    }
                }
                doc {
                    This register selects candidate packets based on packet opcodes. (0 disables the filter):
	This register selects candidate packets based on packet opcodes. (0 disables the filter):
	
                }
            }
            register sip7_ccf_axi_I_main_TransactionStatFilter_UserBase @0x24 {
                bytes 4;
                field USERBASE @'h0 {
                    bits 27;
                    access rw;
                    hard_reset 'h0;
                    doc {
                        This register contains the User base used to filter requests.
                    }
                }
            }
            register sip7_ccf_axi_I_main_TransactionStatFilter_UserMask @0x28 {
                bytes 4;
                field USERMASK @'h0 {
                    bits 27;
                    access rw;
                    hard_reset 'h0;
                    doc {
                        This register contains the User mask used to filter requests.
                    }
                }
            }
            register sip7_ccf_axi_I_main_TransactionStatFilter_Reserved_03 @0x2C {
                bytes 4;
                field sip7_ccf_axi_I_main_TransactionStatFilter_Reserved_03 {
                    bits 32;
                    access rw;
                    hard_reset 'h0;
                }
            }
            register sip7_ccf_axi_I_main_TransactionStatFilter_Reserved_04 @0x30 {
                bytes 4;
                field sip7_ccf_axi_I_main_TransactionStatFilter_Reserved_04 {
                    bits 32;
                    access rw;
                    hard_reset 'h0;
                }
            }
            register sip7_ccf_axi_I_main_TransactionStatFilter_Reserved_05 @0x34 {
                bytes 4;
                field sip7_ccf_axi_I_main_TransactionStatFilter_Reserved_05 {
                    bits 32;
                    access rw;
                    hard_reset 'h0;
                }
            }
            register sip7_ccf_axi_I_main_TransactionStatFilter_Reserved_06 @0x38 {
                bytes 4;
                field sip7_ccf_axi_I_main_TransactionStatFilter_Reserved_06 {
                    bits 32;
                    access rw;
                    hard_reset 'h0;
                }
            }
            register sip7_ccf_axi_I_main_TransactionStatFilter_Reserved_07 @0x3C {
                bytes 4;
                field sip7_ccf_axi_I_main_TransactionStatFilter_Reserved_07 {
                    bits 32;
                    access rw;
                    hard_reset 'h0;
                }
            }
            register sip7_ccf_axi_I_main_TransactionStatFilter_Reserved_08 @0x40 {
                bytes 4;
                field sip7_ccf_axi_I_main_TransactionStatFilter_Reserved_08 {
                    bits 32;
                    access rw;
                    hard_reset 'h0;
                }
            }
            register sip7_ccf_axi_I_main_TransactionStatFilter_Reserved_09 @0x44 {
                bytes 4;
                field sip7_ccf_axi_I_main_TransactionStatFilter_Reserved_09 {
                    bits 32;
                    access rw;
                    hard_reset 'h0;
                }
            }
            register sip7_ccf_axi_I_main_TransactionStatFilter_Reserved_10 @0x48 {
                bytes 4;
                field sip7_ccf_axi_I_main_TransactionStatFilter_Reserved_10 {
                    bits 32;
                    access rw;
                    hard_reset 'h0;
                }
            }
            register sip7_ccf_axi_I_main_TransactionStatFilter_Reserved_11 @0x4C {
                bytes 4;
                field sip7_ccf_axi_I_main_TransactionStatFilter_Reserved_11 {
                    bits 32;
                    access rw;
                    hard_reset 'h0;
                }
            }
            register sip7_ccf_axi_I_main_TransactionStatFilter_Reserved_12 @0x50 {
                bytes 4;
                field sip7_ccf_axi_I_main_TransactionStatFilter_Reserved_12 {
                    bits 32;
                    access rw;
                    hard_reset 'h0;
                }
            }
            register sip7_ccf_axi_I_main_TransactionStatFilter_Reserved_13 @0x54 {
                bytes 4;
                field sip7_ccf_axi_I_main_TransactionStatFilter_Reserved_13 {
                    bits 32;
                    access rw;
                    hard_reset 'h0;
                }
            }
            register sip7_ccf_axi_I_main_TransactionStatFilter_Reserved_14 @0x58 {
                bytes 4;
                field sip7_ccf_axi_I_main_TransactionStatFilter_Reserved_14 {
                    bits 32;
                    access rw;
                    hard_reset 'h0;
                }
            }
            register sip7_ccf_axi_I_main_TransactionStatFilter_Reserved_15 @0x5C {
                bytes 4;
                field sip7_ccf_axi_I_main_TransactionStatFilter_Reserved_15 {
                    bits 32;
                    access rw;
                    hard_reset 'h0;
                }
            }
            register sip7_ccf_axi_I_main_TransactionStatFilter_Reserved_16 @0x60 {
                bytes 4;
                field sip7_ccf_axi_I_main_TransactionStatFilter_Reserved_16 {
                    bits 32;
                    access rw;
                    hard_reset 'h0;
                }
            }
            register sip7_ccf_axi_I_main_TransactionStatFilter_Reserved_17 @0x64 {
                bytes 4;
                field sip7_ccf_axi_I_main_TransactionStatFilter_Reserved_17 {
                    bits 32;
                    access rw;
                    hard_reset 'h0;
                }
            }
            register sip7_ccf_axi_I_main_TransactionStatFilter_Reserved_18 @0x68 {
                bytes 4;
                field sip7_ccf_axi_I_main_TransactionStatFilter_Reserved_18 {
                    bits 32;
                    access rw;
                    hard_reset 'h0;
                }
            }
            register sip7_ccf_axi_I_main_TransactionStatFilter_Reserved_19 @0x6C {
                bytes 4;
                field sip7_ccf_axi_I_main_TransactionStatFilter_Reserved_19 {
                    bits 32;
                    access rw;
                    hard_reset 'h0;
                }
            }
            register sip7_ccf_axi_I_main_TransactionStatFilter_Reserved_20 @0x70 {
                bytes 4;
                field sip7_ccf_axi_I_main_TransactionStatFilter_Reserved_20 {
                    bits 32;
                    access rw;
                    hard_reset 'h0;
                }
            }
            register sip7_ccf_axi_I_main_TransactionStatFilter_Reserved_21 @0x74 {
                bytes 4;
                field sip7_ccf_axi_I_main_TransactionStatFilter_Reserved_21 {
                    bits 32;
                    access rw;
                    hard_reset 'h0;
                }
            }
            register sip7_ccf_axi_I_main_TransactionStatFilter_Reserved_22 @0x78 {
                bytes 4;
                field sip7_ccf_axi_I_main_TransactionStatFilter_Reserved_22 {
                    bits 32;
                    access rw;
                    hard_reset 'h0;
                }
            }
            register sip7_ccf_axi_I_main_TransactionStatFilter_Reserved_23 @0x7C {
                bytes 4;
                field sip7_ccf_axi_I_main_TransactionStatFilter_Reserved_23 {
                    bits 32;
                    access rw;
                    hard_reset 'h0;
                }
            }
        }
        block ecf_ccf_axi_CCF_Observer_main_AtbEndPoint @0xDE000 {
            bytes 4;
            register CCF_Observer_main_AtbEndPoint_Id_CoreId @0x0 {
                bytes 4;
                field CORETYPEID @'h0 {
                    bits 8;
                    access ro;
                    hard_reset 'h7;
                    doc {
                        Field identifying the type of IP.
                    }
                }
                field CORECHECKSUM @'h8 {
                    bits 24;
                    access ro;
                    hard_reset 'h47d3b2;
                    doc {
                        Field containing a checksum of the parameters of the IP.
                    }
                }
            }
            register CCF_Observer_main_AtbEndPoint_Id_RevisionId @0x4 {
                bytes 4;
                field USERID @'h0 {
                    bits 8;
                    access ro;
                    hard_reset 'h0;
                    doc {
                        Field containing a user defined value, not used anywhere inside the IP itself.
                    }
                }
                field FLEXNOCID @'h8 {
                    bits 24;
                    access ro;
                    hard_reset 'h84f8c6;
                    doc {
                        Field containing the build revision of the software used to generate the IP HDL code.
                    }
                }
            }
            register CCF_Observer_main_AtbEndPoint_AtbId @0x8 {
                bytes 4;
                field ATBID @'h0 {
                    bits 7;
                    access rw;
                    hard_reset 'h1;
                    doc {
                        ATB AtId
                    }
                }
            }
            register CCF_Observer_main_AtbEndPoint_AtbEn @0xC {
                bytes 4;
                field ATBEN @'h0 {
                    access rw;
                    hard_reset 'h0;
                    doc {
                        ATB Unit Enable
                    }
                }
            }
            register CCF_Observer_main_AtbEndPoint_SyncPeriod @0x10 {
                bytes 4;
                field SYNCPERIOD @'h0 {
                    bits 5;
                    access rw;
                    hard_reset 'h0;
                    doc {
                        ATB Synchro Period
                    }
                }
            }
            register CCF_Observer_main_AtbEndPoint_Reserved_00 @0x14 {
                bytes 4;
                field CCF_Observer_main_AtbEndPoint_Reserved_00 {
                    bits 32;
                    access rw;
                    hard_reset 'h0;
                }
            }
            register CCF_Observer_main_AtbEndPoint_Reserved_01 @0x18 {
                bytes 4;
                field CCF_Observer_main_AtbEndPoint_Reserved_01 {
                    bits 32;
                    access rw;
                    hard_reset 'h0;
                }
            }
            register CCF_Observer_main_AtbEndPoint_Reserved_02 @0x1C {
                bytes 4;
                field CCF_Observer_main_AtbEndPoint_Reserved_02 {
                    bits 32;
                    access rw;
                    hard_reset 'h0;
                }
            }
            register CCF_Observer_main_AtbEndPoint_Reserved_03 @0x20 {
                bytes 4;
                field CCF_Observer_main_AtbEndPoint_Reserved_03 {
                    bits 32;
                    access rw;
                    hard_reset 'h0;
                }
            }
            register CCF_Observer_main_AtbEndPoint_Reserved_04 @0x24 {
                bytes 4;
                field CCF_Observer_main_AtbEndPoint_Reserved_04 {
                    bits 32;
                    access rw;
                    hard_reset 'h0;
                }
            }
            register CCF_Observer_main_AtbEndPoint_Reserved_05 @0x28 {
                bytes 4;
                field CCF_Observer_main_AtbEndPoint_Reserved_05 {
                    bits 32;
                    access rw;
                    hard_reset 'h0;
                }
            }
            register CCF_Observer_main_AtbEndPoint_Reserved_06 @0x2C {
                bytes 4;
                field CCF_Observer_main_AtbEndPoint_Reserved_06 {
                    bits 32;
                    access rw;
                    hard_reset 'h0;
                }
            }
            register CCF_Observer_main_AtbEndPoint_Reserved_07 @0x30 {
                bytes 4;
                field CCF_Observer_main_AtbEndPoint_Reserved_07 {
                    bits 32;
                    access rw;
                    hard_reset 'h0;
                }
            }
            register CCF_Observer_main_AtbEndPoint_Reserved_08 @0x34 {
                bytes 4;
                field CCF_Observer_main_AtbEndPoint_Reserved_08 {
                    bits 32;
                    access rw;
                    hard_reset 'h0;
                }
            }
            register CCF_Observer_main_AtbEndPoint_Reserved_09 @0x38 {
                bytes 4;
                field CCF_Observer_main_AtbEndPoint_Reserved_09 {
                    bits 32;
                    access rw;
                    hard_reset 'h0;
                }
            }
            register CCF_Observer_main_AtbEndPoint_Reserved_10 @0x3C {
                bytes 4;
                field CCF_Observer_main_AtbEndPoint_Reserved_10 {
                    bits 32;
                    access rw;
                    hard_reset 'h0;
                }
            }
            register CCF_Observer_main_AtbEndPoint_Reserved_11 @0x40 {
                bytes 4;
                field CCF_Observer_main_AtbEndPoint_Reserved_11 {
                    bits 32;
                    access rw;
                    hard_reset 'h0;
                }
            }
            register CCF_Observer_main_AtbEndPoint_Reserved_12 @0x44 {
                bytes 4;
                field CCF_Observer_main_AtbEndPoint_Reserved_12 {
                    bits 32;
                    access rw;
                    hard_reset 'h0;
                }
            }
            register CCF_Observer_main_AtbEndPoint_Reserved_13 @0x48 {
                bytes 4;
                field CCF_Observer_main_AtbEndPoint_Reserved_13 {
                    bits 32;
                    access rw;
                    hard_reset 'h0;
                }
            }
            register CCF_Observer_main_AtbEndPoint_Reserved_14 @0x4C {
                bytes 4;
                field CCF_Observer_main_AtbEndPoint_Reserved_14 {
                    bits 32;
                    access rw;
                    hard_reset 'h0;
                }
            }
            register CCF_Observer_main_AtbEndPoint_Reserved_15 @0x50 {
                bytes 4;
                field CCF_Observer_main_AtbEndPoint_Reserved_15 {
                    bits 32;
                    access rw;
                    hard_reset 'h0;
                }
            }
            register CCF_Observer_main_AtbEndPoint_Reserved_16 @0x54 {
                bytes 4;
                field CCF_Observer_main_AtbEndPoint_Reserved_16 {
                    bits 32;
                    access rw;
                    hard_reset 'h0;
                }
            }
            register CCF_Observer_main_AtbEndPoint_Reserved_17 @0x58 {
                bytes 4;
                field CCF_Observer_main_AtbEndPoint_Reserved_17 {
                    bits 32;
                    access rw;
                    hard_reset 'h0;
                }
            }
            register CCF_Observer_main_AtbEndPoint_Reserved_18 @0x5C {
                bytes 4;
                field CCF_Observer_main_AtbEndPoint_Reserved_18 {
                    bits 32;
                    access rw;
                    hard_reset 'h0;
                }
            }
            register CCF_Observer_main_AtbEndPoint_Reserved_19 @0x60 {
                bytes 4;
                field CCF_Observer_main_AtbEndPoint_Reserved_19 {
                    bits 32;
                    access rw;
                    hard_reset 'h0;
                }
            }
            register CCF_Observer_main_AtbEndPoint_Reserved_20 @0x64 {
                bytes 4;
                field CCF_Observer_main_AtbEndPoint_Reserved_20 {
                    bits 32;
                    access rw;
                    hard_reset 'h0;
                }
            }
            register CCF_Observer_main_AtbEndPoint_Reserved_21 @0x68 {
                bytes 4;
                field CCF_Observer_main_AtbEndPoint_Reserved_21 {
                    bits 32;
                    access rw;
                    hard_reset 'h0;
                }
            }
            register CCF_Observer_main_AtbEndPoint_Reserved_22 @0x6C {
                bytes 4;
                field CCF_Observer_main_AtbEndPoint_Reserved_22 {
                    bits 32;
                    access rw;
                    hard_reset 'h0;
                }
            }
            register CCF_Observer_main_AtbEndPoint_Reserved_23 @0x70 {
                bytes 4;
                field CCF_Observer_main_AtbEndPoint_Reserved_23 {
                    bits 32;
                    access rw;
                    hard_reset 'h0;
                }
            }
            register CCF_Observer_main_AtbEndPoint_Reserved_24 @0x74 {
                bytes 4;
                field CCF_Observer_main_AtbEndPoint_Reserved_24 {
                    bits 32;
                    access rw;
                    hard_reset 'h0;
                }
            }
            register CCF_Observer_main_AtbEndPoint_Reserved_25 @0x78 {
                bytes 4;
                field CCF_Observer_main_AtbEndPoint_Reserved_25 {
                    bits 32;
                    access rw;
                    hard_reset 'h0;
                }
            }
            register CCF_Observer_main_AtbEndPoint_Reserved_26 @0x7C {
                bytes 4;
                field CCF_Observer_main_AtbEndPoint_Reserved_26 {
                    bits 32;
                    access rw;
                    hard_reset 'h0;
                }
            }
        }
        block ecf_ccf_axi_CCF_Observer_main_ErrorLogger_0 @0xDF000 {
            bytes 4;
            register CCF_Observer_main_ErrorLogger_0_Id_CoreId @0x0 {
                bytes 4;
                field CORETYPEID @'h0 {
                    bits 8;
                    access ro;
                    hard_reset 'hd;
                    doc {
                        Field identifying the type of IP.
                    }
                }
                field CORECHECKSUM @'h8 {
                    bits 24;
                    access ro;
                    hard_reset 'h59113c;
                    doc {
                        Field containing a checksum of the parameters of the IP.
                    }
                }
            }
            register CCF_Observer_main_ErrorLogger_0_Id_RevisionId @0x4 {
                bytes 4;
                field USERID @'h0 {
                    bits 8;
                    access ro;
                    hard_reset 'h0;
                    doc {
                        Field containing a user defined value, not used anywhere inside the IP itself.
                    }
                }
                field FLEXNOCID @'h8 {
                    bits 24;
                    access ro;
                    hard_reset 'h84f8c6;
                    doc {
                        Field containing the build revision of the software used to generate the IP HDL code.
                    }
                }
            }
            register CCF_Observer_main_ErrorLogger_0_FaultEn @0x8 {
                bytes 4;
                field FAULTEN @'h0 {
                    access rw;
                    hard_reset 'h0;
                    doc {
                        Set to 1 to enable output signal Fault. Fault asserted when ErrVld is 1.
                    }
                }
            }
            register CCF_Observer_main_ErrorLogger_0_ErrVld @0xC {
                bytes 4;
                field ERRVLD @'h0 {
                    access ro;
                    hard_reset 'h0;
                    doc {
                        1 indicates an error has been logged
                    }
                }
            }
            register CCF_Observer_main_ErrorLogger_0_ErrClr @0x10 {
                bytes 4;
                field ERRCLR @'h0 {
                    access w1c;
                    hard_reset 'h0;
                    doc {
                        Set to 1 to clear ErrVld. NOTE The written value is not stored in ErrVld. A read always returns 0.
                    }
                }
            }
            register CCF_Observer_main_ErrorLogger_0_ErrLog0 @0x14 {
                bytes 4;
                field LOCK @'h0 {
                    access ro;
                    hard_reset 'h0;
                    doc {
                        Lock
                    }
                }
                field OPC @'h1 {
                    bits 4;
                    access ro;
                    hard_reset 'h0;
                    doc {
                        Opc
                    }
                }
                field ERRCODE @'h8 {
                    bits 3;
                    access ro;
                    hard_reset 'h0;
                    doc {
                        ErrCode
                    }
                }
                field LEN1 @'h10 {
                    bits 7;
                    access ro;
                    hard_reset 'h0;
                    doc {
                        Len1
                    }
                }
                field FORMAT @'h1f {
                    access ro;
                    hard_reset 'h1;
                    doc {
                        NTTP transport protocol version
                    }
                }
                doc {
                    Stores NTTP packet header fields Lock, Opc, ErrCode, Len1 and indicates version of NTTP transport protocolStores NTTP packet header fields Lock, Opc, ErrCode, Len1 and indicates version of NTTP transport protocol
                }
            }
            register CCF_Observer_main_ErrorLogger_0_ErrLog1 @0x18 {
                bytes 4;
                field ERRLOG1 @'h0 {
                    bits 20;
                    access ro;
                    hard_reset 'h0;
                    doc {
                        Stores NTTP packet header field RouteId (LSBs) of the logged error
                    }
                }
            }
            register CCF_Observer_main_ErrorLogger_0_Reserved_00 @0x1C {
                bytes 4;
                field CCF_Observer_main_ErrorLogger_0_Reserved_00 {
                    bits 32;
                    access rw;
                    hard_reset 'h0;
                }
            }
            register CCF_Observer_main_ErrorLogger_0_ErrLog3 @0x20 {
                bytes 4;
                field ERRLOG3 @'h0 {
                    bits 30;
                    access ro;
                    hard_reset 'h0;
                    doc {
                        Stores NTTP packet header field Addr (LSBs) of the logged error
                    }
                }
            }
            register CCF_Observer_main_ErrorLogger_0_Reserved_01 @0x24 {
                bytes 4;
                field CCF_Observer_main_ErrorLogger_0_Reserved_01 {
                    bits 32;
                    access rw;
                    hard_reset 'h0;
                }
            }
            register CCF_Observer_main_ErrorLogger_0_ErrLog5 @0x28 {
                bytes 4;
                field ERRLOG5 @'h0 {
                    bits 27;
                    access ro;
                    hard_reset 'h0;
                    doc {
                        Stores NTTP packet header field User (LSBs) of the logged error
                    }
                }
            }
            register CCF_Observer_main_ErrorLogger_0_Reserved_02 @0x2C {
                bytes 4;
                field CCF_Observer_main_ErrorLogger_0_Reserved_02 {
                    bits 32;
                    access rw;
                    hard_reset 'h0;
                }
            }
            register CCF_Observer_main_ErrorLogger_0_Reserved_03 @0x30 {
                bytes 4;
                field CCF_Observer_main_ErrorLogger_0_Reserved_03 {
                    bits 32;
                    access rw;
                    hard_reset 'h0;
                }
            }
            register CCF_Observer_main_ErrorLogger_0_Reserved_04 @0x34 {
                bytes 4;
                field CCF_Observer_main_ErrorLogger_0_Reserved_04 {
                    bits 32;
                    access rw;
                    hard_reset 'h0;
                }
            }
            register CCF_Observer_main_ErrorLogger_0_StallEn @0x38 {
                bytes 4;
                field STALLEN @'h0 {
                    access rw;
                    hard_reset 'h0;
                    doc {
                        Set to 1 to enable stall mode behavior.
                    }
                }
            }
            register CCF_Observer_main_ErrorLogger_0_Reserved_05 @0x3C {
                bytes 4;
                field CCF_Observer_main_ErrorLogger_0_Reserved_05 {
                    bits 32;
                    access rw;
                    hard_reset 'h0;
                }
            }
            register CCF_Observer_main_ErrorLogger_0_Reserved_06 @0x40 {
                bytes 4;
                field CCF_Observer_main_ErrorLogger_0_Reserved_06 {
                    bits 32;
                    access rw;
                    hard_reset 'h0;
                }
            }
            register CCF_Observer_main_ErrorLogger_0_Reserved_07 @0x44 {
                bytes 4;
                field CCF_Observer_main_ErrorLogger_0_Reserved_07 {
                    bits 32;
                    access rw;
                    hard_reset 'h0;
                }
            }
            register CCF_Observer_main_ErrorLogger_0_Reserved_08 @0x48 {
                bytes 4;
                field CCF_Observer_main_ErrorLogger_0_Reserved_08 {
                    bits 32;
                    access rw;
                    hard_reset 'h0;
                }
            }
            register CCF_Observer_main_ErrorLogger_0_Reserved_09 @0x4C {
                bytes 4;
                field CCF_Observer_main_ErrorLogger_0_Reserved_09 {
                    bits 32;
                    access rw;
                    hard_reset 'h0;
                }
            }
            register CCF_Observer_main_ErrorLogger_0_Reserved_10 @0x50 {
                bytes 4;
                field CCF_Observer_main_ErrorLogger_0_Reserved_10 {
                    bits 32;
                    access rw;
                    hard_reset 'h0;
                }
            }
            register CCF_Observer_main_ErrorLogger_0_Reserved_11 @0x54 {
                bytes 4;
                field CCF_Observer_main_ErrorLogger_0_Reserved_11 {
                    bits 32;
                    access rw;
                    hard_reset 'h0;
                }
            }
            register CCF_Observer_main_ErrorLogger_0_Reserved_12 @0x58 {
                bytes 4;
                field CCF_Observer_main_ErrorLogger_0_Reserved_12 {
                    bits 32;
                    access rw;
                    hard_reset 'h0;
                }
            }
            register CCF_Observer_main_ErrorLogger_0_Reserved_13 @0x5C {
                bytes 4;
                field CCF_Observer_main_ErrorLogger_0_Reserved_13 {
                    bits 32;
                    access rw;
                    hard_reset 'h0;
                }
            }
            register CCF_Observer_main_ErrorLogger_0_Reserved_14 @0x60 {
                bytes 4;
                field CCF_Observer_main_ErrorLogger_0_Reserved_14 {
                    bits 32;
                    access rw;
                    hard_reset 'h0;
                }
            }
            register CCF_Observer_main_ErrorLogger_0_Reserved_15 @0x64 {
                bytes 4;
                field CCF_Observer_main_ErrorLogger_0_Reserved_15 {
                    bits 32;
                    access rw;
                    hard_reset 'h0;
                }
            }
            register CCF_Observer_main_ErrorLogger_0_Reserved_16 @0x68 {
                bytes 4;
                field CCF_Observer_main_ErrorLogger_0_Reserved_16 {
                    bits 32;
                    access rw;
                    hard_reset 'h0;
                }
            }
            register CCF_Observer_main_ErrorLogger_0_Reserved_17 @0x6C {
                bytes 4;
                field CCF_Observer_main_ErrorLogger_0_Reserved_17 {
                    bits 32;
                    access rw;
                    hard_reset 'h0;
                }
            }
            register CCF_Observer_main_ErrorLogger_0_Reserved_18 @0x70 {
                bytes 4;
                field CCF_Observer_main_ErrorLogger_0_Reserved_18 {
                    bits 32;
                    access rw;
                    hard_reset 'h0;
                }
            }
            register CCF_Observer_main_ErrorLogger_0_Reserved_19 @0x74 {
                bytes 4;
                field CCF_Observer_main_ErrorLogger_0_Reserved_19 {
                    bits 32;
                    access rw;
                    hard_reset 'h0;
                }
            }
            register CCF_Observer_main_ErrorLogger_0_Reserved_20 @0x78 {
                bytes 4;
                field CCF_Observer_main_ErrorLogger_0_Reserved_20 {
                    bits 32;
                    access rw;
                    hard_reset 'h0;
                }
            }
            register CCF_Observer_main_ErrorLogger_0_Reserved_21 @0x7C {
                bytes 4;
                field CCF_Observer_main_ErrorLogger_0_Reserved_21 {
                    bits 32;
                    access rw;
                    hard_reset 'h0;
                }
            }
        }
}
